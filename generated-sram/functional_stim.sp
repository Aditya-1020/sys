* Functional test stimulus file for 10ns period

* TT process corner
.lib "/home/link/eda/.volare/sky130A/libs.tech/ngspice/sky130.lib.spice" tt
.include "/tmp/openram_link_409280_temp/sram.sp"

* Global Power Supplies
Vvdd vdd 0 1.8

*Nodes gnd and 0 are the same global ground node in ngspice/hspice/xa. Otherwise, this source may be needed.
*Vgnd gnd 0 0.0

* Instantiation of the SRAM
Xsky130_sram_512byte_1rw1r_32x128_8 din0_0 din0_1 din0_2 din0_3 din0_4 din0_5 din0_6 din0_7 din0_8 din0_9 din0_10 din0_11 din0_12 din0_13 din0_14 din0_15 din0_16 din0_17 din0_18 din0_19 din0_20 din0_21 din0_22 din0_23 din0_24 din0_25 din0_26 din0_27 din0_28 din0_29 din0_30 din0_31 a0_0 a0_1 a0_2 a0_3 a0_4 a0_5 a0_6 a1_0 a1_1 a1_2 a1_3 a1_4 a1_5 a1_6 CSB0 CSB1 WEB0 clk0 clk1 WMASK0_0 WMASK0_1 WMASK0_2 WMASK0_3 dout0_0 dout0_1 dout0_2 dout0_3 dout0_4 dout0_5 dout0_6 dout0_7 dout0_8 dout0_9 dout0_10 dout0_11 dout0_12 dout0_13 dout0_14 dout0_15 dout0_16 dout0_17 dout0_18 dout0_19 dout0_20 dout0_21 dout0_22 dout0_23 dout0_24 dout0_25 dout0_26 dout0_27 dout0_28 dout0_29 dout0_30 dout0_31 dout1_0 dout1_1 dout1_2 dout1_3 dout1_4 dout1_5 dout1_6 dout1_7 dout1_8 dout1_9 dout1_10 dout1_11 dout1_12 dout1_13 dout1_14 dout1_15 dout1_16 dout1_17 dout1_18 dout1_19 dout1_20 dout1_21 dout1_22 dout1_23 dout1_24 dout1_25 dout1_26 dout1_27 dout1_28 dout1_29 dout1_30 dout1_31 vdd gnd sky130_sram_512byte_1rw1r_32x128_8

* SRAM output loads
CD00 dout0_0  0 27.56f
CD01 dout0_1  0 27.56f
CD02 dout0_2  0 27.56f
CD03 dout0_3  0 27.56f
CD04 dout0_4  0 27.56f
CD05 dout0_5  0 27.56f
CD06 dout0_6  0 27.56f
CD07 dout0_7  0 27.56f
CD08 dout0_8  0 27.56f
CD09 dout0_9  0 27.56f
CD010 dout0_10  0 27.56f
CD011 dout0_11  0 27.56f
CD012 dout0_12  0 27.56f
CD013 dout0_13  0 27.56f
CD014 dout0_14  0 27.56f
CD015 dout0_15  0 27.56f
CD016 dout0_16  0 27.56f
CD017 dout0_17  0 27.56f
CD018 dout0_18  0 27.56f
CD019 dout0_19  0 27.56f
CD020 dout0_20  0 27.56f
CD021 dout0_21  0 27.56f
CD022 dout0_22  0 27.56f
CD023 dout0_23  0 27.56f
CD024 dout0_24  0 27.56f
CD025 dout0_25  0 27.56f
CD026 dout0_26  0 27.56f
CD027 dout0_27  0 27.56f
CD028 dout0_28  0 27.56f
CD029 dout0_29  0 27.56f
CD030 dout0_30  0 27.56f
CD031 dout0_31  0 27.56f
CD10 dout1_0  0 27.56f
CD11 dout1_1  0 27.56f
CD12 dout1_2  0 27.56f
CD13 dout1_3  0 27.56f
CD14 dout1_4  0 27.56f
CD15 dout1_5  0 27.56f
CD16 dout1_6  0 27.56f
CD17 dout1_7  0 27.56f
CD18 dout1_8  0 27.56f
CD19 dout1_9  0 27.56f
CD110 dout1_10  0 27.56f
CD111 dout1_11  0 27.56f
CD112 dout1_12  0 27.56f
CD113 dout1_13  0 27.56f
CD114 dout1_14  0 27.56f
CD115 dout1_15  0 27.56f
CD116 dout1_16  0 27.56f
CD117 dout1_17  0 27.56f
CD118 dout1_18  0 27.56f
CD119 dout1_19  0 27.56f
CD120 dout1_20  0 27.56f
CD121 dout1_21  0 27.56f
CD122 dout1_22  0 27.56f
CD123 dout1_23  0 27.56f
CD124 dout1_24  0 27.56f
CD125 dout1_25  0 27.56f
CD126 dout1_26  0 27.56f
CD127 dout1_27  0 27.56f
CD128 dout1_28  0 27.56f
CD129 dout1_29  0 27.56f
CD130 dout1_30  0 27.56f
CD131 dout1_31  0 27.56f

* Important signals for debug
* bl:	xsram:xbank0:bl_0_1
* br:	xsram:xbank0:br_0_1
* s_en:	xsram:s_en
* q:	xsram:xbank0:xbitcell_array:xbitcell_array:xbit_r0_c0.Q
* qbar:	xsram:xbank0:xbitcell_array:xbitcell_array:xbit_r0_c0.Q_bar

* Sequence of operations
*	Idle during cycle 0 (0ns - 10ns)
*	Writing 00100110110000011010011010110100  to  address 0000000 (from port 0) during cycle 1 (10ns - 20ns)
*	Writing 01011010101011011001011000000101  to  address 0000001 (from port 0) during cycle 2 (20ns - 30ns)
*	Writing 11000101111000000000110001111110  to  address 1111101 (from port 0) during cycle 3 (30ns - 40ns)
*	Reading 00100110110000011010011010110100 from address 0000000 (from port 0) during cycle 4 (40ns - 50ns)
*	Reading 11000101111000000000110001111110 from address 1111101 (from port 1) during cycle 4 (40ns - 50ns)
*	Reading 00100110110000011010011010110100 from address 0000000 (from port 1) during cycle 5 (50ns - 60ns)
*	Reading 11000101111000000000110001111110 from address 1111101 (from port 0) during cycle 6 (60ns - 70ns)
*	Reading 00100110110000011010011010110100 from address 0000000 (from port 1) during cycle 6 (60ns - 70ns)
*	Reading 00100110110000011010011010110100 from address 0000000 (from port 1) during cycle 7 (70ns - 80ns)
*	Writing 11100000111001110001100111101000  to  address 1111101 (from port 0) during cycle 8 (80ns - 90ns)
*	Reading 01011010101011011001011000000101 from address 0000001 (from port 1) during cycle 8 (80ns - 90ns)
*	Reading 00100110110000011010011010110100 from address 0000000 (from port 0) during cycle 9 (90ns - 100ns)
*	Reading 11100000111001110001100111101000 from address 1111101 (from port 0) during cycle 10 (100ns - 110ns)
*	Writing (partial) 10100001010110101000001010110110  to  address 0000001 with mask bit 1000 (from port 0) during cycle 11 (110ns - 120ns)
*	Reading 10100001101011011001011000000101 from address 0000001 (from port 0) during cycle 12 (120ns - 130ns)
*	Reading 10100001101011011001011000000101 from address 0000001 (from port 0) during cycle 13 (130ns - 140ns)
*	Reading 10100001101011011001011000000101 from address 0000001 (from port 1) during cycle 13 (130ns - 140ns)
*	Reading 11100000111001110001100111101000 from address 1111101 (from port 0) during cycle 14 (140ns - 150ns)
*	Reading 10100001101011011001011000000101 from address 0000001 (from port 1) during cycle 14 (140ns - 150ns)
*	Reading 00100110110000011010011010110100 from address 0000000 (from port 0) during cycle 15 (150ns - 160ns)
*	Reading 00100110110000011010011010110100 from address 0000000 (from port 1) during cycle 15 (150ns - 160ns)
*	Reading 11100000111001110001100111101000 from address 1111101 (from port 0) during cycle 16 (160ns - 170ns)
*	Writing (partial) 00001111010100011011101011111000  to  address 1111101 with mask bit 0100 (from port 0) during cycle 17 (170ns - 180ns)
*	Reading 00100110110000011010011010110100 from address 0000000 (from port 0) during cycle 18 (180ns - 190ns)
*	Reading 00100110110000011010011010110100 from address 0000000 (from port 1) during cycle 19 (190ns - 200ns)
*	Writing 11011100110000111010001101101110  to  address 0000001 (from port 0) during cycle 20 (200ns - 210ns)
*	Reading 11100000010100010001100111101000 from address 1111101 (from port 0) during cycle 22 (220ns - 230ns)
*	Reading 00100110110000011010011010110100 from address 0000000 (from port 1) during cycle 22 (220ns - 230ns)
*	Reading 11100000010100010001100111101000 from address 1111101 (from port 0) during cycle 23 (230ns - 240ns)
*	Writing 00001010100001110001000110000011  to  address 0000001 (from port 0) during cycle 24 (240ns - 250ns)
*	Reading 00100110110000011010011010110100 from address 0000000 (from port 1) during cycle 24 (240ns - 250ns)
*	Reading 00001010100001110001000110000011 from address 0000001 (from port 0) during cycle 25 (250ns - 260ns)
*	Reading 11100000010100010001100111101000 from address 1111101 (from port 1) during cycle 25 (250ns - 260ns)
*	Reading 00001010100001110001000110000011 from address 0000001 (from port 0) during cycle 26 (260ns - 270ns)
*	Writing 11011010000011010010000011000001  to  address 0000000 (from port 0) during cycle 27 (270ns - 280ns)
*	Writing 01000110001101011000000101110011  to  address 1111101 (from port 0) during cycle 28 (280ns - 290ns)
*	Reading 00001010100001110001000110000011 from address 0000001 (from port 1) during cycle 28 (280ns - 290ns)
*	Reading 11011010000011010010000011000001 from address 0000000 (from port 0) during cycle 29 (290ns - 300ns)
*	Reading 00001010100001110001000110000011 from address 0000001 (from port 0) during cycle 30 (300ns - 310ns)
*	Reading 01000110001101011000000101110011 from address 1111101 (from port 1) during cycle 30 (300ns - 310ns)
*	Writing 01010011101110110101001010000101  to  address 1111110 (from port 0) during cycle 31 (310ns - 320ns)
*	Writing (partial) 10101110110101111101011001001101  to  address 0000001 with mask bit 1100 (from port 0) during cycle 32 (320ns - 330ns)
*	Reading 01010011101110110101001010000101 from address 1111110 (from port 1) during cycle 32 (320ns - 330ns)
*	Reading 01010011101110110101001010000101 from address 1111110 (from port 0) during cycle 33 (330ns - 340ns)
*	Reading 01010011101110110101001010000101 from address 1111110 (from port 1) during cycle 33 (330ns - 340ns)
*	Writing (partial) 00000000001111110111110011111110  to  address 0000001 with mask bit 1000 (from port 0) during cycle 34 (340ns - 350ns)
*	Reading 11011010000011010010000011000001 from address 0000000 (from port 0) during cycle 35 (350ns - 360ns)
*	Reading 00000000110101110001000110000011 from address 0000001 (from port 0) during cycle 36 (360ns - 370ns)
*	Reading 00000000110101110001000110000011 from address 0000001 (from port 1) during cycle 36 (360ns - 370ns)
*	Reading 01000110001101011000000101110011 from address 1111101 (from port 0) during cycle 37 (370ns - 380ns)
*	Reading 01000110001101011000000101110011 from address 1111101 (from port 1) during cycle 37 (370ns - 380ns)
*	Writing 11110101001010010101100101110000  to  address 1111101 (from port 0) during cycle 39 (390ns - 400ns)
*	Writing (partial) 11010100111000110011000011101100  to  address 0000001 with mask bit 0100 (from port 0) during cycle 40 (400ns - 410ns)
*	Reading 11011010000011010010000011000001 from address 0000000 (from port 1) during cycle 40 (400ns - 410ns)
*	Writing (partial) 11111001110100110000101110010011  to  address 0000000 with mask bit 1101 (from port 0) during cycle 41 (410ns - 420ns)
*	Reading 11110101001010010101100101110000 from address 1111101 (from port 1) during cycle 41 (410ns - 420ns)
*	Writing 11111001111100001111110000001100  to  address 0000001 (from port 0) during cycle 43 (430ns - 440ns)
*	Reading 01010011101110110101001010000101 from address 1111110 (from port 1) during cycle 43 (430ns - 440ns)
*	Reading 01010011101110110101001010000101 from address 1111110 (from port 0) during cycle 45 (450ns - 460ns)
*	Reading 11110101001010010101100101110000 from address 1111101 (from port 1) during cycle 45 (450ns - 460ns)
*	Reading 11110101001010010101100101110000 from address 1111101 (from port 0) during cycle 47 (470ns - 480ns)
*	Reading 01010011101110110101001010000101 from address 1111110 (from port 1) during cycle 47 (470ns - 480ns)
*	Reading 01010011101110110101001010000101 from address 1111110 (from port 0) during cycle 48 (480ns - 490ns)
*	Reading 11111001110100110010000010010011 from address 0000000 (from port 0) during cycle 49 (490ns - 500ns)
*	Reading 01010011101110110101001010000101 from address 1111110 (from port 1) during cycle 49 (490ns - 500ns)
*	Writing 01100100001111101011110100011101  to  address 1111101 (from port 0) during cycle 50 (500ns - 510ns)
*	Writing (partial) 10010011110011111100000010000011  to  address 0000001 with mask bit 0110 (from port 0) during cycle 51 (510ns - 520ns)
*	Reading 11111001110011111100000000001100 from address 0000001 (from port 0) during cycle 52 (520ns - 530ns)
*	Reading 01010011101110110101001010000101 from address 1111110 (from port 1) during cycle 52 (520ns - 530ns)
*	Writing 11001011010001001011100110011110  to  address 0000000 (from port 0) during cycle 53 (530ns - 540ns)
*	Writing 11101000111000000011100100110011  to  address 1111101 (from port 0) during cycle 54 (540ns - 550ns)
*	Reading 11111001110011111100000000001100 from address 0000001 (from port 1) during cycle 54 (540ns - 550ns)
*	Reading 11001011010001001011100110011110 from address 0000000 (from port 0) during cycle 55 (550ns - 560ns)
*	Reading 11111001110011111100000000001100 from address 0000001 (from port 0) during cycle 56 (560ns - 570ns)
*	Reading 11001011010001001011100110011110 from address 0000000 (from port 0) during cycle 57 (570ns - 580ns)
*	Reading 11001011010001001011100110011110 from address 0000000 (from port 1) during cycle 57 (570ns - 580ns)
*	Reading 11111001110011111100000000001100 from address 0000001 (from port 0) during cycle 58 (580ns - 590ns)
*	Reading 11001011010001001011100110011110 from address 0000000 (from port 0) during cycle 59 (590ns - 600ns)
*	Writing (partial) 01001001000110101101110100001011  to  address 0000001 with mask bit 1110 (from port 0) during cycle 60 (600ns - 610ns)
*	Reading 11001011010001001011100110011110 from address 0000000 (from port 1) during cycle 60 (600ns - 610ns)
*	Reading 11101000111000000011100100110011 from address 1111101 (from port 0) during cycle 61 (610ns - 620ns)
*	Writing (partial) 10111000010011100000010010110100  to  address 0000001 with mask bit 1000 (from port 0) during cycle 62 (620ns - 630ns)
*	Reading 01010011101110110101001010000101 from address 1111110 (from port 0) during cycle 63 (630ns - 640ns)
*	Reading 01010011101110110101001010000101 from address 1111110 (from port 1) during cycle 64 (640ns - 650ns)
*	Writing 00011100001100110010101010101010  to  address 1111110 (from port 0) during cycle 65 (650ns - 660ns)
*	Reading 11101000111000000011100100110011 from address 1111101 (from port 1) during cycle 65 (650ns - 660ns)
*	Reading 11101000111000000011100100110011 from address 1111101 (from port 1) during cycle 66 (660ns - 670ns)
*	Writing 11100011110011110010001000100000  to  address 0000000 (from port 0) during cycle 67 (670ns - 680ns)
*	Reading 11101000111000000011100100110011 from address 1111101 (from port 1) during cycle 67 (670ns - 680ns)
*	Reading 11100011110011110010001000100000 from address 0000000 (from port 0) during cycle 69 (690ns - 700ns)
*	Reading 11100011110011110010001000100000 from address 0000000 (from port 1) during cycle 69 (690ns - 700ns)
*	Reading 10111000000110101101110100001100 from address 0000001 (from port 0) during cycle 70 (700ns - 710ns)
*	Reading 00011100001100110010101010101010 from address 1111110 (from port 0) during cycle 71 (710ns - 720ns)
*	Reading 11100011110011110010001000100000 from address 0000000 (from port 1) during cycle 71 (710ns - 720ns)
*	Reading 11101000111000000011100100110011 from address 1111101 (from port 0) during cycle 72 (720ns - 730ns)
*	Reading 11101000111000000011100100110011 from address 1111101 (from port 0) during cycle 73 (730ns - 740ns)
*	Reading 10111000000110101101110100001100 from address 0000001 (from port 1) during cycle 73 (730ns - 740ns)
*	Writing (partial) 10101111111110111100001011100011  to  address 0000000 with mask bit 0001 (from port 0) during cycle 74 (740ns - 750ns)
*	Reading 11101000111000000011100100110011 from address 1111101 (from port 1) during cycle 74 (740ns - 750ns)
*	Writing 01001110001001110101100101001011  to  address 1111101 (from port 0) during cycle 75 (750ns - 760ns)
*	Writing 10101110010100000001101010111011  to  address 0000001 (from port 0) during cycle 76 (760ns - 770ns)
*	Writing 00001010000011011101100101100111  to  address 0000001 (from port 0) during cycle 77 (770ns - 780ns)
*	Reading 01001110001001110101100101001011 from address 1111101 (from port 1) during cycle 77 (770ns - 780ns)
*	Reading 00011100001100110010101010101010 from address 1111110 (from port 0) during cycle 78 (780ns - 790ns)
*	Reading 01001110001001110101100101001011 from address 1111101 (from port 0) during cycle 79 (790ns - 800ns)
*	Reading 11100011110011110010001011100011 from address 0000000 (from port 1) during cycle 80 (800ns - 810ns)
*	Reading 01001110001001110101100101001011 from address 1111101 (from port 0) during cycle 81 (810ns - 820ns)
*	Reading 00001010000011011101100101100111 from address 0000001 (from port 0) during cycle 82 (820ns - 830ns)
*	Reading 00011100001100110010101010101010 from address 1111110 (from port 1) during cycle 82 (820ns - 830ns)
*	Reading 11100011110011110010001011100011 from address 0000000 (from port 0) during cycle 85 (850ns - 860ns)
*	Reading 00011100001100110010101010101010 from address 1111110 (from port 1) during cycle 85 (850ns - 860ns)
*	Writing 01011000011100011010100110111110  to  address 0000000 (from port 0) during cycle 86 (860ns - 870ns)
*	Reading 01001110001001110101100101001011 from address 1111101 (from port 1) during cycle 86 (860ns - 870ns)
*	Reading 01011000011100011010100110111110 from address 0000000 (from port 1) during cycle 87 (870ns - 880ns)
*	Reading 01011000011100011010100110111110 from address 0000000 (from port 0) during cycle 88 (880ns - 890ns)
*	Reading 01011000011100011010100110111110 from address 0000000 (from port 0) during cycle 89 (890ns - 900ns)
*	Reading 01011000011100011010100110111110 from address 0000000 (from port 1) during cycle 89 (890ns - 900ns)
*	Writing 00100110010101001111110100100100  to  address 0000001 (from port 0) during cycle 90 (900ns - 910ns)
*	Writing 11001111101110010010101000001110  to  address 1111110 (from port 0) during cycle 91 (910ns - 920ns)
*	Writing 00111111000110110011001001000100  to  address 1111101 (from port 0) during cycle 92 (920ns - 930ns)
*	Reading 00100110010101001111110100100100 from address 0000001 (from port 0) during cycle 93 (930ns - 940ns)
*	Reading 01011000011100011010100110111110 from address 0000000 (from port 1) during cycle 93 (930ns - 940ns)
*	Reading 11001111101110010010101000001110 from address 1111110 (from port 0) during cycle 94 (940ns - 950ns)
*	Reading 00111111000110110011001001000100 from address 1111101 (from port 1) during cycle 94 (940ns - 950ns)
*	Reading 01011000011100011010100110111110 from address 0000000 (from port 0) during cycle 95 (950ns - 960ns)
*	Reading 00111111000110110011001001000100 from address 1111101 (from port 0) during cycle 96 (960ns - 970ns)
*	Reading 01011000011100011010100110111110 from address 0000000 (from port 1) during cycle 96 (960ns - 970ns)
*	Reading 01011000011100011010100110111110 from address 0000000 (from port 1) during cycle 97 (970ns - 980ns)
*	Writing 01111000101001100100110110100100  to  address 0000000 (from port 0) during cycle 99 (990ns - 1000ns)
*	Reading 00111111000110110011001001000100 from address 1111101 (from port 1) during cycle 99 (990ns - 1000ns)
*	Writing (partial) 01000100001111000010101010111000  to  address 1111110 with mask bit 0100 (from port 0) during cycle 100 (1000ns - 1010ns)
*	Reading 00100110010101001111110100100100 from address 0000001 (from port 0) during cycle 101 (1010ns - 1020ns)
*	Reading 11001111001111000010101000001110 from address 1111110 (from port 0) during cycle 103 (1030ns - 1040ns)
*	Reading 00100110010101001111110100100100 from address 0000001 (from port 1) during cycle 103 (1030ns - 1040ns)
*	Writing 01101101001011100100010101110111  to  address 1111101 (from port 0) during cycle 104 (1040ns - 1050ns)
*	Reading 01111000101001100100110110100100 from address 0000000 (from port 0) during cycle 105 (1050ns - 1060ns)
*	Writing 01100000011110000110100000010010  to  address 1111110 (from port 0) during cycle 106 (1060ns - 1070ns)
*	Reading 00100110010101001111110100100100 from address 0000001 (from port 1) during cycle 106 (1060ns - 1070ns)
*	Reading 01100000011110000110100000010010 from address 1111110 (from port 0) during cycle 107 (1070ns - 1080ns)
*	Reading 01100000011110000110100000010010 from address 1111110 (from port 1) during cycle 107 (1070ns - 1080ns)
*	Reading 00100110010101001111110100100100 from address 0000001 (from port 0) during cycle 108 (1080ns - 1090ns)
*	Reading 01111000101001100100110110100100 from address 0000000 (from port 1) during cycle 108 (1080ns - 1090ns)
*	Reading 01111000101001100100110110100100 from address 0000000 (from port 0) during cycle 109 (1090ns - 1100ns)
*	Writing (partial) 00000100001011101100000011001101  to  address 1111110 with mask bit 0100 (from port 0) during cycle 110 (1100ns - 1110ns)
*	Reading 01111000101001100100110110100100 from address 0000000 (from port 1) during cycle 110 (1100ns - 1110ns)
*	Reading 00100110010101001111110100100100 from address 0000001 (from port 0) during cycle 111 (1110ns - 1120ns)
*	Reading 01111000101001100100110110100100 from address 0000000 (from port 1) during cycle 111 (1110ns - 1120ns)
*	Writing 00111000010111010010101111011101  to  address 0000000 (from port 0) during cycle 112 (1120ns - 1130ns)
*	Writing 00011110011011100100010001011111  to  address 1111110 (from port 0) during cycle 113 (1130ns - 1140ns)
*	Reading 01101101001011100100010101110111 from address 1111101 (from port 0) during cycle 114 (1140ns - 1150ns)
*	Writing 00000111111111010000001001100101  to  address 0000001 (from port 0) during cycle 115 (1150ns - 1160ns)
*	Reading 00111000010111010010101111011101 from address 0000000 (from port 1) during cycle 115 (1150ns - 1160ns)
*	Reading 00011110011011100100010001011111 from address 1111110 (from port 0) during cycle 116 (1160ns - 1170ns)
*	Reading 00011110011011100100010001011111 from address 1111110 (from port 1) during cycle 116 (1160ns - 1170ns)
*	Reading 00111000010111010010101111011101 from address 0000000 (from port 0) during cycle 117 (1170ns - 1180ns)
*	Reading 00000111111111010000001001100101 from address 0000001 (from port 1) during cycle 117 (1170ns - 1180ns)
*	Reading 00011110011011100100010001011111 from address 1111110 (from port 0) during cycle 118 (1180ns - 1190ns)
*	Reading 00000111111111010000001001100101 from address 0000001 (from port 0) during cycle 119 (1190ns - 1200ns)
*	Reading 01101101001011100100010101110111 from address 1111101 (from port 1) during cycle 119 (1190ns - 1200ns)
*	Reading 00011110011011100100010001011111 from address 1111110 (from port 0) during cycle 120 (1200ns - 1210ns)
*	Writing (partial) 00011010000111100000011111001110  to  address 0000000 with mask bit 0011 (from port 0) during cycle 121 (1210ns - 1220ns)
*	Writing (partial) 00111100000011010001101101100111  to  address 1111110 with mask bit 0101 (from port 0) during cycle 122 (1220ns - 1230ns)
*	Reading 00111000010111010000011111001110 from address 0000000 (from port 1) during cycle 122 (1220ns - 1230ns)
*	Writing 11110100110100000100000010111001  to  address 1111110 (from port 0) during cycle 123 (1230ns - 1240ns)
*	Reading 00111000010111010000011111001110 from address 0000000 (from port 1) during cycle 123 (1230ns - 1240ns)
*	Writing (partial) 11101000010010001111010000101010  to  address 1111110 with mask bit 0001 (from port 0) during cycle 124 (1240ns - 1250ns)
*	Reading 00000111111111010000001001100101 from address 0000001 (from port 1) during cycle 124 (1240ns - 1250ns)
*	Writing 01000001100011101110100001001001  to  address 1111110 (from port 0) during cycle 125 (1250ns - 1260ns)
*	Reading 00111000010111010000011111001110 from address 0000000 (from port 1) during cycle 125 (1250ns - 1260ns)
*	Writing 11110111101110111110100101101101  to  address 1111101 (from port 0) during cycle 126 (1260ns - 1270ns)
*	Reading 01000001100011101110100001001001 from address 1111110 (from port 1) during cycle 127 (1270ns - 1280ns)
*	Reading 00000111111111010000001001100101 from address 0000001 (from port 0) during cycle 129 (1290ns - 1300ns)
*	Reading 01000001100011101110100001001001 from address 1111110 (from port 0) during cycle 132 (1320ns - 1330ns)
*	Reading 00000111111111010000001001100101 from address 0000001 (from port 1) during cycle 132 (1320ns - 1330ns)
*	Reading 11110111101110111110100101101101 from address 1111101 (from port 0) during cycle 133 (1330ns - 1340ns)
*	Reading 01000001100011101110100001001001 from address 1111110 (from port 1) during cycle 133 (1330ns - 1340ns)
*	Writing 01001101010110011100101101110001  to  address 1111101 (from port 0) during cycle 134 (1340ns - 1350ns)
*	Writing (partial) 00110101001100110100100100000111  to  address 0000001 with mask bit 0011 (from port 0) during cycle 135 (1350ns - 1360ns)
*	Reading 01000001100011101110100001001001 from address 1111110 (from port 0) during cycle 136 (1360ns - 1370ns)
*	Reading 01001101010110011100101101110001 from address 1111101 (from port 1) during cycle 136 (1360ns - 1370ns)
*	Reading 00000111111111010100100100000111 from address 0000001 (from port 0) during cycle 137 (1370ns - 1380ns)
*	Reading 00000111111111010100100100000111 from address 0000001 (from port 0) during cycle 138 (1380ns - 1390ns)
*	Writing (partial) 11000000001000100110110101011111  to  address 1111101 with mask bit 0100 (from port 0) during cycle 139 (1390ns - 1400ns)
*	Reading 01001101001000101100101101110001 from address 1111101 (from port 0) during cycle 140 (1400ns - 1410ns)
*	Writing (partial) 00110110010110011111100001001010  to  address 1111110 with mask bit 1101 (from port 0) during cycle 141 (1410ns - 1420ns)
*	Writing 10100101101101010000011101101001  to  address 1111110 (from port 0) during cycle 142 (1420ns - 1430ns)
*	Reading 10100101101101010000011101101001 from address 1111110 (from port 0) during cycle 143 (1430ns - 1440ns)
*	Reading 00111000010111010000011111001110 from address 0000000 (from port 0) during cycle 144 (1440ns - 1450ns)
*	Reading 00000111111111010100100100000111 from address 0000001 (from port 0) during cycle 145 (1450ns - 1460ns)
*	Reading 10100101101101010000011101101001 from address 1111110 (from port 1) during cycle 145 (1450ns - 1460ns)
*	Reading 00000111111111010100100100000111 from address 0000001 (from port 0) during cycle 146 (1460ns - 1470ns)
*	Reading 00111000010111010000011111001110 from address 0000000 (from port 0) during cycle 147 (1470ns - 1480ns)
*	Reading 10100101101101010000011101101001 from address 1111110 (from port 1) during cycle 147 (1470ns - 1480ns)
*	Writing (partial) 00001110111010101001100010111100  to  address 1111110 with mask bit 0111 (from port 0) during cycle 148 (1480ns - 1490ns)
*	Reading 00111000010111010000011111001110 from address 0000000 (from port 1) during cycle 148 (1480ns - 1490ns)
*	Reading 00111000010111010000011111001110 from address 0000000 (from port 0) during cycle 149 (1490ns - 1500ns)
*	Reading 10100101111010101001100010111100 from address 1111110 (from port 0) during cycle 150 (1500ns - 1510ns)
*	Writing (partial) 11011100100011110101011100110010  to  address 0000001 with mask bit 0110 (from port 0) during cycle 151 (1510ns - 1520ns)
*	Reading 01001101001000101100101101110001 from address 1111101 (from port 1) during cycle 151 (1510ns - 1520ns)
*	Writing (partial) 01011100010110011101100101000100  to  address 1111101 with mask bit 1000 (from port 0) during cycle 153 (1530ns - 1540ns)
*	Writing (partial) 00110110000001111011100100110111  to  address 1111101 with mask bit 0010 (from port 0) during cycle 155 (1550ns - 1560ns)
*	Reading 00000111100011110101011100000111 from address 0000001 (from port 0) during cycle 156 (1560ns - 1570ns)
*	Writing (partial) 01110011001111010001101011000100  to  address 0000000 with mask bit 0111 (from port 0) during cycle 157 (1570ns - 1580ns)
*	Writing (partial) 11111001010111000001110000110011  to  address 1111101 with mask bit 0111 (from port 0) during cycle 158 (1580ns - 1590ns)
*	Reading 00000111100011110101011100000111 from address 0000001 (from port 1) during cycle 158 (1580ns - 1590ns)
*	Writing (partial) 01101111001010110100010010110111  to  address 0000001 with mask bit 1110 (from port 0) during cycle 159 (1590ns - 1600ns)
*	Reading 00111000001111010001101011000100 from address 0000000 (from port 1) during cycle 159 (1590ns - 1600ns)
*	Writing (partial) 10000000101000100000001101001011  to  address 1111101 with mask bit 1100 (from port 0) during cycle 161 (1610ns - 1620ns)
*	Reading 10100101111010101001100010111100 from address 1111110 (from port 1) during cycle 161 (1610ns - 1620ns)
*	Reading 10000000101000100001110000110011 from address 1111101 (from port 0) during cycle 163 (1630ns - 1640ns)
*	Reading 01101111001010110100010000000111 from address 0000001 (from port 0) during cycle 164 (1640ns - 1650ns)
*	Reading 00111000001111010001101011000100 from address 0000000 (from port 1) during cycle 164 (1640ns - 1650ns)
*	Reading 01101111001010110100010000000111 from address 0000001 (from port 1) during cycle 165 (1650ns - 1660ns)
*	Writing 01001111101001101100101110101000  to  address 1111110 (from port 0) during cycle 166 (1660ns - 1670ns)
*	Reading 01101111001010110100010000000111 from address 0000001 (from port 0) during cycle 167 (1670ns - 1680ns)
*	Writing (partial) 11100101101011111011010011101110  to  address 1111110 with mask bit 1000 (from port 0) during cycle 168 (1680ns - 1690ns)
*	Reading 10000000101000100001110000110011 from address 1111101 (from port 1) during cycle 168 (1680ns - 1690ns)
*	Writing 01001011100000011110000110101110  to  address 1111101 (from port 0) during cycle 169 (1690ns - 1700ns)
*	Reading 00111000001111010001101011000100 from address 0000000 (from port 0) during cycle 170 (1700ns - 1710ns)
*	Reading 11100101101001101100101110101000 from address 1111110 (from port 1) during cycle 170 (1700ns - 1710ns)
*	Writing 00000000010000000010010010011000  to  address 1111110 (from port 0) during cycle 171 (1710ns - 1720ns)
*	Reading 00111000001111010001101011000100 from address 0000000 (from port 1) during cycle 171 (1710ns - 1720ns)
*	Reading 00111000001111010001101011000100 from address 0000000 (from port 0) during cycle 172 (1720ns - 1730ns)
*	Reading 01101111001010110100010000000111 from address 0000001 (from port 1) during cycle 172 (1720ns - 1730ns)
*	Writing 00111010111001001111111111100011  to  address 0000000 (from port 0) during cycle 173 (1730ns - 1740ns)
*	Reading 01001011100000011110000110101110 from address 1111101 (from port 0) during cycle 174 (1740ns - 1750ns)
*	Reading 01001011100000011110000110101110 from address 1111101 (from port 1) during cycle 174 (1740ns - 1750ns)
*	Reading 00111010111001001111111111100011 from address 0000000 (from port 0) during cycle 175 (1750ns - 1760ns)
*	Reading 01101111001010110100010000000111 from address 0000001 (from port 1) during cycle 175 (1750ns - 1760ns)
*	Reading 01001011100000011110000110101110 from address 1111101 (from port 0) during cycle 176 (1760ns - 1770ns)
*	Reading 00111010111001001111111111100011 from address 0000000 (from port 1) during cycle 176 (1760ns - 1770ns)
*	Reading 01001011100000011110000110101110 from address 1111101 (from port 0) during cycle 177 (1770ns - 1780ns)
*	Reading 00111010111001001111111111100011 from address 0000000 (from port 1) during cycle 177 (1770ns - 1780ns)
*	Writing 10001110001101101011010011101100  to  address 0000001 (from port 0) during cycle 178 (1780ns - 1790ns)
*	Reading 00111010111001001111111111100011 from address 0000000 (from port 0) during cycle 179 (1790ns - 1800ns)
*	Writing 01110111111001011101100000010010  to  address 1111101 (from port 0) during cycle 180 (1800ns - 1810ns)
*	Reading 10001110001101101011010011101100 from address 0000001 (from port 1) during cycle 180 (1800ns - 1810ns)
*	Reading 00000000010000000010010010011000 from address 1111110 (from port 0) during cycle 181 (1810ns - 1820ns)
*	Reading 10001110001101101011010011101100 from address 0000001 (from port 0) during cycle 182 (1820ns - 1830ns)
*	Reading 01110111111001011101100000010010 from address 1111101 (from port 1) during cycle 183 (1830ns - 1840ns)
*	Writing (partial) 00001001000000000101100000110010  to  address 1111101 with mask bit 0011 (from port 0) during cycle 184 (1840ns - 1850ns)
*	Writing 01010001010110101000101010110111  to  address 0000001 (from port 0) during cycle 185 (1850ns - 1860ns)
*	Reading 00000000010000000010010010011000 from address 1111110 (from port 0) during cycle 186 (1860ns - 1870ns)
*	Reading 00000000010000000010010010011000 from address 1111110 (from port 0) during cycle 187 (1870ns - 1880ns)
*	Reading 01110111111001010101100000110010 from address 1111101 (from port 1) during cycle 187 (1870ns - 1880ns)
*	Reading 01010001010110101000101010110111 from address 0000001 (from port 0) during cycle 188 (1880ns - 1890ns)
*	Reading 01010001010110101000101010110111 from address 0000001 (from port 1) during cycle 189 (1890ns - 1900ns)
*	Writing 01101100011100111100011100110010  to  address 0000000 (from port 0) during cycle 190 (1900ns - 1910ns)
*	Reading 01110111111001010101100000110010 from address 1111101 (from port 1) during cycle 190 (1900ns - 1910ns)
*	Reading 01010001010110101000101010110111 from address 0000001 (from port 0) during cycle 191 (1910ns - 1920ns)
*	Reading 01101100011100111100011100110010 from address 0000000 (from port 1) during cycle 191 (1910ns - 1920ns)
*	Reading 00000000010000000010010010011000 from address 1111110 (from port 0) during cycle 192 (1920ns - 1930ns)
*	Reading 01010001010110101000101010110111 from address 0000001 (from port 0) during cycle 193 (1930ns - 1940ns)
*	Reading 00000000010000000010010010011000 from address 1111110 (from port 1) during cycle 193 (1930ns - 1940ns)
*	Writing 00011000100100000001110110000010  to  address 1111101 (from port 0) during cycle 194 (1940ns - 1950ns)
*	Writing 00000111111110110110111111101011  to  address 1111101 (from port 0) during cycle 195 (1950ns - 1960ns)
*	Reading 00000111111110110110111111101011 from address 1111101 (from port 0) during cycle 196 (1960ns - 1970ns)
*	Writing 10000110000000111100111011110011  to  address 1111101 (from port 0) during cycle 197 (1970ns - 1980ns)
*	Reading 01101100011100111100011100110010 from address 0000000 (from port 1) during cycle 197 (1970ns - 1980ns)
*	Reading 10000110000000111100111011110011 from address 1111101 (from port 0) during cycle 198 (1980ns - 1990ns)
*	Writing (partial) 10111001000101110000011010100000  to  address 1111101 with mask bit 1010 (from port 0) during cycle 199 (1990ns - 2000ns)
*	Reading 00000000010000000010010010011000 from address 1111110 (from port 1) during cycle 199 (1990ns - 2000ns)
*	Reading 10111001000000110000011011110011 from address 1111101 (from port 0) during cycle 200 (2000ns - 2010ns)
*	Reading 01010001010110101000101010110111 from address 0000001 (from port 1) during cycle 200 (2000ns - 2010ns)
*	Reading 00000000010000000010010010011000 from address 1111110 (from port 0) during cycle 201 (2010ns - 2020ns)
*	Reading 01101100011100111100011100110010 from address 0000000 (from port 0) during cycle 202 (2020ns - 2030ns)
*	Reading 00000000010000000010010010011000 from address 1111110 (from port 0) during cycle 203 (2030ns - 2040ns)
*	Reading 00000000010000000010010010011000 from address 1111110 (from port 1) during cycle 203 (2030ns - 2040ns)
*	Writing 11100100000011001101101001000011  to  address 0000000 (from port 0) during cycle 204 (2040ns - 2050ns)
*	Reading 01010001010110101000101010110111 from address 0000001 (from port 1) during cycle 204 (2040ns - 2050ns)
*	Idle during cycle 205 (2050ns - 2060ns)

* Generation of data and address signals
* (time, data): [(0, 0), (10, 0), (20, 1), (30, 0), (40, 0), (50, 0), (60, 0), (70, 0), (80, 0), (90, 0), (100, 0), (110, 0), (120, 0), (130, 0), (140, 0), (150, 0), (160, 0), (170, 0), (180, 0), (190, 0), (200, 0), (210, 0), (220, 0), (230, 0), (240, 1), (250, 1), (260, 1), (270, 1), (280, 1), (290, 1), (300, 1), (310, 1), (320, 1), (330, 1), (340, 0), (350, 0), (360, 0), (370, 0), (380, 0), (390, 0), (400, 0), (410, 1), (420, 1), (430, 0), (440, 0), (450, 0), (460, 0), (470, 0), (480, 0), (490, 0), (500, 1), (510, 1), (520, 1), (530, 0), (540, 1), (550, 1), (560, 1), (570, 1), (580, 1), (590, 1), (600, 1), (610, 1), (620, 0), (630, 0), (640, 0), (650, 0), (660, 0), (670, 0), (680, 0), (690, 0), (700, 0), (710, 0), (720, 0), (730, 0), (740, 1), (750, 1), (760, 1), (770, 1), (780, 1), (790, 1), (800, 1), (810, 1), (820, 1), (830, 1), (840, 1), (850, 1), (860, 0), (870, 0), (880, 0), (890, 0), (900, 0), (910, 0), (920, 0), (930, 0), (940, 0), (950, 0), (960, 0), (970, 0), (980, 0), (990, 0), (1000, 0), (1010, 0), (1020, 0), (1030, 0), (1040, 1), (1050, 1), (1060, 0), (1070, 0), (1080, 0), (1090, 0), (1100, 1), (1110, 1), (1120, 1), (1130, 1), (1140, 1), (1150, 1), (1160, 1), (1170, 1), (1180, 1), (1190, 1), (1200, 1), (1210, 0), (1220, 1), (1230, 1), (1240, 0), (1250, 1), (1260, 1), (1270, 1), (1280, 1), (1290, 1), (1300, 1), (1310, 1), (1320, 1), (1330, 1), (1340, 1), (1350, 1), (1360, 1), (1370, 1), (1380, 1), (1390, 1), (1400, 1), (1410, 0), (1420, 1), (1430, 1), (1440, 1), (1450, 1), (1460, 1), (1470, 1), (1480, 0), (1490, 0), (1500, 0), (1510, 0), (1520, 0), (1530, 0), (1540, 0), (1550, 1), (1560, 1), (1570, 0), (1580, 1), (1590, 1), (1600, 1), (1610, 1), (1620, 1), (1630, 1), (1640, 1), (1650, 1), (1660, 0), (1670, 0), (1680, 0), (1690, 0), (1700, 0), (1710, 0), (1720, 0), (1730, 1), (1740, 1), (1750, 1), (1760, 1), (1770, 1), (1780, 0), (1790, 0), (1800, 0), (1810, 0), (1820, 0), (1830, 0), (1840, 0), (1850, 1), (1860, 1), (1870, 1), (1880, 1), (1890, 1), (1900, 0), (1910, 0), (1920, 0), (1930, 0), (1940, 0), (1950, 1), (1960, 1), (1970, 1), (1980, 1), (1990, 0), (2000, 0), (2010, 0), (2020, 0), (2030, 0), (2040, 1), (2050, 1)]
Vdin0_0  din0_0  0 PWL (0n 0.0v 9.495n 0.0v 9.505n 0.0v 19.495n 0.0v 19.505n 1.8v 29.495n 1.8v 29.505n 0.0v 39.495n 0.0v 39.505n 0.0v 49.495n 0.0v 49.505n 0.0v 59.495n 0.0v 59.505n 0.0v 69.495n 0.0v 69.505n 0.0v 79.495n 0.0v 79.505n 0.0v 89.495n 0.0v 89.505n 0.0v 99.495n 0.0v 99.505n 0.0v 109.495n 0.0v 109.505n 0.0v 119.495n 0.0v 119.505n 0.0v 129.495n 0.0v 129.505n 0.0v 139.495n 0.0v 139.505n 0.0v 149.495n 0.0v 149.505n 0.0v 159.495n 0.0v 159.505n 0.0v 169.495n 0.0v 169.505n 0.0v 179.495n 0.0v 179.505n 0.0v 189.495n 0.0v 189.505n 0.0v 199.495n 0.0v 199.505n 0.0v 209.495n 0.0v 209.505n 0.0v 219.495n 0.0v 219.505n 0.0v 229.495n 0.0v 229.505n 0.0v 239.495n 0.0v 239.505n 1.8v 249.495n 1.8v 249.505n 1.8v 259.495n 1.8v 259.505n 1.8v 269.495n 1.8v 269.505n 1.8v 279.495n 1.8v 279.505n 1.8v 289.495n 1.8v 289.505n 1.8v 299.495n 1.8v 299.505n 1.8v 309.495n 1.8v 309.505n 1.8v 319.495n 1.8v 319.505n 1.8v 329.495n 1.8v 329.505n 1.8v 339.495n 1.8v 339.505n 0.0v 349.495n 0.0v 349.505n 0.0v 359.495n 0.0v 359.505n 0.0v 369.495n 0.0v 369.505n 0.0v 379.495n 0.0v 379.505n 0.0v 389.495n 0.0v 389.505n 0.0v 399.495n 0.0v 399.505n 0.0v 409.495n 0.0v 409.505n 1.8v 419.495n 1.8v 419.505n 1.8v 429.495n 1.8v 429.505n 0.0v 439.495n 0.0v 439.505n 0.0v 449.495n 0.0v 449.505n 0.0v 459.495n 0.0v 459.505n 0.0v 469.495n 0.0v 469.505n 0.0v 479.495n 0.0v 479.505n 0.0v 489.495n 0.0v 489.505n 0.0v 499.495n 0.0v 499.505n 1.8v 509.495n 1.8v 509.505n 1.8v 519.495n 1.8v 519.505n 1.8v 529.495n 1.8v 529.505n 0.0v 539.495n 0.0v 539.505n 1.8v 549.495n 1.8v 549.505n 1.8v 559.495n 1.8v 559.505n 1.8v 569.495n 1.8v 569.505n 1.8v 579.495n 1.8v 579.505n 1.8v 589.495n 1.8v 589.505n 1.8v 599.495n 1.8v 599.505n 1.8v 609.495n 1.8v 609.505n 1.8v 619.495n 1.8v 619.505n 0.0v 629.495n 0.0v 629.505n 0.0v 639.495n 0.0v 639.505n 0.0v 649.495n 0.0v 649.505n 0.0v 659.495n 0.0v 659.505n 0.0v 669.495n 0.0v 669.505n 0.0v 679.495n 0.0v 679.505n 0.0v 689.495n 0.0v 689.505n 0.0v 699.495n 0.0v 699.505n 0.0v 709.495n 0.0v 709.505n 0.0v 719.495n 0.0v 719.505n 0.0v 729.495n 0.0v 729.505n 0.0v 739.495n 0.0v 739.505n 1.8v 749.495n 1.8v 749.505n 1.8v 759.495n 1.8v 759.505n 1.8v 769.495n 1.8v 769.505n 1.8v 779.495n 1.8v 779.505n 1.8v 789.495n 1.8v 789.505n 1.8v 799.495n 1.8v 799.505n 1.8v 809.495n 1.8v 809.505n 1.8v 819.495n 1.8v 819.505n 1.8v 829.495n 1.8v 829.505n 1.8v 839.495n 1.8v 839.505n 1.8v 849.495n 1.8v 849.505n 1.8v 859.495n 1.8v 859.505n 0.0v 869.495n 0.0v 869.505n 0.0v 879.495n 0.0v 879.505n 0.0v 889.495n 0.0v 889.505n 0.0v 899.495n 0.0v 899.505n 0.0v 909.495n 0.0v 909.505n 0.0v 919.495n 0.0v 919.505n 0.0v 929.495n 0.0v 929.505n 0.0v 939.495n 0.0v 939.505n 0.0v 949.495n 0.0v 949.505n 0.0v 959.495n 0.0v 959.505n 0.0v 969.495n 0.0v 969.505n 0.0v 979.495n 0.0v 979.505n 0.0v 989.495n 0.0v 989.505n 0.0v 999.495n 0.0v 999.505n 0.0v 1009.495n 0.0v 1009.505n 0.0v 1019.495n 0.0v 1019.505n 0.0v 1029.495n 0.0v 1029.505n 0.0v 1039.495n 0.0v 1039.505n 1.8v 1049.495n 1.8v 1049.505n 1.8v 1059.495n 1.8v 1059.505n 0.0v 1069.495n 0.0v 1069.505n 0.0v 1079.495n 0.0v 1079.505n 0.0v 1089.495n 0.0v 1089.505n 0.0v 1099.495n 0.0v 1099.505n 1.8v 1109.495n 1.8v 1109.505n 1.8v 1119.495n 1.8v 1119.505n 1.8v 1129.495n 1.8v 1129.505n 1.8v 1139.495n 1.8v 1139.505n 1.8v 1149.495n 1.8v 1149.505n 1.8v 1159.495n 1.8v 1159.505n 1.8v 1169.495n 1.8v 1169.505n 1.8v 1179.495n 1.8v 1179.505n 1.8v 1189.495n 1.8v 1189.505n 1.8v 1199.495n 1.8v 1199.505n 1.8v 1209.495n 1.8v 1209.505n 0.0v 1219.495n 0.0v 1219.505n 1.8v 1229.495n 1.8v 1229.505n 1.8v 1239.495n 1.8v 1239.505n 0.0v 1249.495n 0.0v 1249.505n 1.8v 1259.495n 1.8v 1259.505n 1.8v 1269.495n 1.8v 1269.505n 1.8v 1279.495n 1.8v 1279.505n 1.8v 1289.495n 1.8v 1289.505n 1.8v 1299.495n 1.8v 1299.505n 1.8v 1309.495n 1.8v 1309.505n 1.8v 1319.495n 1.8v 1319.505n 1.8v 1329.495n 1.8v 1329.505n 1.8v 1339.495n 1.8v 1339.505n 1.8v 1349.495n 1.8v 1349.505n 1.8v 1359.495n 1.8v 1359.505n 1.8v 1369.495n 1.8v 1369.505n 1.8v 1379.495n 1.8v 1379.505n 1.8v 1389.495n 1.8v 1389.505n 1.8v 1399.495n 1.8v 1399.505n 1.8v 1409.495n 1.8v 1409.505n 0.0v 1419.495n 0.0v 1419.505n 1.8v 1429.495n 1.8v 1429.505n 1.8v 1439.495n 1.8v 1439.505n 1.8v 1449.495n 1.8v 1449.505n 1.8v 1459.495n 1.8v 1459.505n 1.8v 1469.495n 1.8v 1469.505n 1.8v 1479.495n 1.8v 1479.505n 0.0v 1489.495n 0.0v 1489.505n 0.0v 1499.495n 0.0v 1499.505n 0.0v 1509.495n 0.0v 1509.505n 0.0v 1519.495n 0.0v 1519.505n 0.0v 1529.495n 0.0v 1529.505n 0.0v 1539.495n 0.0v 1539.505n 0.0v 1549.495n 0.0v 1549.505n 1.8v 1559.495n 1.8v 1559.505n 1.8v 1569.495n 1.8v 1569.505n 0.0v 1579.495n 0.0v 1579.505n 1.8v 1589.495n 1.8v 1589.505n 1.8v 1599.495n 1.8v 1599.505n 1.8v 1609.495n 1.8v 1609.505n 1.8v 1619.495n 1.8v 1619.505n 1.8v 1629.495n 1.8v 1629.505n 1.8v 1639.495n 1.8v 1639.505n 1.8v 1649.495n 1.8v 1649.505n 1.8v 1659.495n 1.8v 1659.505n 0.0v 1669.495n 0.0v 1669.505n 0.0v 1679.495n 0.0v 1679.505n 0.0v 1689.495n 0.0v 1689.505n 0.0v 1699.495n 0.0v 1699.505n 0.0v 1709.495n 0.0v 1709.505n 0.0v 1719.495n 0.0v 1719.505n 0.0v 1729.495n 0.0v 1729.505n 1.8v 1739.495n 1.8v 1739.505n 1.8v 1749.495n 1.8v 1749.505n 1.8v 1759.495n 1.8v 1759.505n 1.8v 1769.495n 1.8v 1769.505n 1.8v 1779.495n 1.8v 1779.505n 0.0v 1789.495n 0.0v 1789.505n 0.0v 1799.495n 0.0v 1799.505n 0.0v 1809.495n 0.0v 1809.505n 0.0v 1819.495n 0.0v 1819.505n 0.0v 1829.495n 0.0v 1829.505n 0.0v 1839.495n 0.0v 1839.505n 0.0v 1849.495n 0.0v 1849.505n 1.8v 1859.495n 1.8v 1859.505n 1.8v 1869.495n 1.8v 1869.505n 1.8v 1879.495n 1.8v 1879.505n 1.8v 1889.495n 1.8v 1889.505n 1.8v 1899.495n 1.8v 1899.505n 0.0v 1909.495n 0.0v 1909.505n 0.0v 1919.495n 0.0v 1919.505n 0.0v 1929.495n 0.0v 1929.505n 0.0v 1939.495n 0.0v 1939.505n 0.0v 1949.495n 0.0v 1949.505n 1.8v 1959.495n 1.8v 1959.505n 1.8v 1969.495n 1.8v 1969.505n 1.8v 1979.495n 1.8v 1979.505n 1.8v 1989.495n 1.8v 1989.505n 0.0v 1999.495n 0.0v 1999.505n 0.0v 2009.495n 0.0v 2009.505n 0.0v 2019.495n 0.0v 2019.505n 0.0v 2029.495n 0.0v 2029.505n 0.0v 2039.495n 0.0v 2039.505n 1.8v 2049.495n 1.8v 2049.505n 1.8v )
* (time, data): [(0, 0), (10, 0), (20, 0), (30, 1), (40, 1), (50, 1), (60, 1), (70, 1), (80, 0), (90, 0), (100, 0), (110, 1), (120, 1), (130, 1), (140, 1), (150, 1), (160, 1), (170, 0), (180, 0), (190, 0), (200, 1), (210, 1), (220, 1), (230, 1), (240, 1), (250, 1), (260, 1), (270, 0), (280, 1), (290, 1), (300, 1), (310, 0), (320, 0), (330, 0), (340, 1), (350, 1), (360, 1), (370, 1), (380, 1), (390, 0), (400, 0), (410, 1), (420, 1), (430, 0), (440, 0), (450, 0), (460, 0), (470, 0), (480, 0), (490, 0), (500, 0), (510, 1), (520, 1), (530, 1), (540, 1), (550, 1), (560, 1), (570, 1), (580, 1), (590, 1), (600, 1), (610, 1), (620, 0), (630, 0), (640, 0), (650, 1), (660, 1), (670, 0), (680, 0), (690, 0), (700, 0), (710, 0), (720, 0), (730, 0), (740, 1), (750, 1), (760, 1), (770, 1), (780, 1), (790, 1), (800, 1), (810, 1), (820, 1), (830, 1), (840, 1), (850, 1), (860, 1), (870, 1), (880, 1), (890, 1), (900, 0), (910, 1), (920, 0), (930, 0), (940, 0), (950, 0), (960, 0), (970, 0), (980, 0), (990, 0), (1000, 0), (1010, 0), (1020, 0), (1030, 0), (1040, 1), (1050, 1), (1060, 1), (1070, 1), (1080, 1), (1090, 1), (1100, 0), (1110, 0), (1120, 0), (1130, 1), (1140, 1), (1150, 0), (1160, 0), (1170, 0), (1180, 0), (1190, 0), (1200, 0), (1210, 1), (1220, 1), (1230, 0), (1240, 1), (1250, 0), (1260, 0), (1270, 0), (1280, 0), (1290, 0), (1300, 0), (1310, 0), (1320, 0), (1330, 0), (1340, 0), (1350, 1), (1360, 1), (1370, 1), (1380, 1), (1390, 1), (1400, 1), (1410, 1), (1420, 0), (1430, 0), (1440, 0), (1450, 0), (1460, 0), (1470, 0), (1480, 0), (1490, 0), (1500, 0), (1510, 1), (1520, 1), (1530, 0), (1540, 0), (1550, 1), (1560, 1), (1570, 0), (1580, 1), (1590, 1), (1600, 1), (1610, 1), (1620, 1), (1630, 1), (1640, 1), (1650, 1), (1660, 0), (1670, 0), (1680, 1), (1690, 1), (1700, 1), (1710, 0), (1720, 0), (1730, 1), (1740, 1), (1750, 1), (1760, 1), (1770, 1), (1780, 0), (1790, 0), (1800, 1), (1810, 1), (1820, 1), (1830, 1), (1840, 1), (1850, 1), (1860, 1), (1870, 1), (1880, 1), (1890, 1), (1900, 1), (1910, 1), (1920, 1), (1930, 1), (1940, 1), (1950, 1), (1960, 1), (1970, 1), (1980, 1), (1990, 0), (2000, 0), (2010, 0), (2020, 0), (2030, 0), (2040, 1), (2050, 1)]
Vdin0_1  din0_1  0 PWL (0n 0.0v 9.495n 0.0v 9.505n 0.0v 19.495n 0.0v 19.505n 0.0v 29.495n 0.0v 29.505n 1.8v 39.495n 1.8v 39.505n 1.8v 49.495n 1.8v 49.505n 1.8v 59.495n 1.8v 59.505n 1.8v 69.495n 1.8v 69.505n 1.8v 79.495n 1.8v 79.505n 0.0v 89.495n 0.0v 89.505n 0.0v 99.495n 0.0v 99.505n 0.0v 109.495n 0.0v 109.505n 1.8v 119.495n 1.8v 119.505n 1.8v 129.495n 1.8v 129.505n 1.8v 139.495n 1.8v 139.505n 1.8v 149.495n 1.8v 149.505n 1.8v 159.495n 1.8v 159.505n 1.8v 169.495n 1.8v 169.505n 0.0v 179.495n 0.0v 179.505n 0.0v 189.495n 0.0v 189.505n 0.0v 199.495n 0.0v 199.505n 1.8v 209.495n 1.8v 209.505n 1.8v 219.495n 1.8v 219.505n 1.8v 229.495n 1.8v 229.505n 1.8v 239.495n 1.8v 239.505n 1.8v 249.495n 1.8v 249.505n 1.8v 259.495n 1.8v 259.505n 1.8v 269.495n 1.8v 269.505n 0.0v 279.495n 0.0v 279.505n 1.8v 289.495n 1.8v 289.505n 1.8v 299.495n 1.8v 299.505n 1.8v 309.495n 1.8v 309.505n 0.0v 319.495n 0.0v 319.505n 0.0v 329.495n 0.0v 329.505n 0.0v 339.495n 0.0v 339.505n 1.8v 349.495n 1.8v 349.505n 1.8v 359.495n 1.8v 359.505n 1.8v 369.495n 1.8v 369.505n 1.8v 379.495n 1.8v 379.505n 1.8v 389.495n 1.8v 389.505n 0.0v 399.495n 0.0v 399.505n 0.0v 409.495n 0.0v 409.505n 1.8v 419.495n 1.8v 419.505n 1.8v 429.495n 1.8v 429.505n 0.0v 439.495n 0.0v 439.505n 0.0v 449.495n 0.0v 449.505n 0.0v 459.495n 0.0v 459.505n 0.0v 469.495n 0.0v 469.505n 0.0v 479.495n 0.0v 479.505n 0.0v 489.495n 0.0v 489.505n 0.0v 499.495n 0.0v 499.505n 0.0v 509.495n 0.0v 509.505n 1.8v 519.495n 1.8v 519.505n 1.8v 529.495n 1.8v 529.505n 1.8v 539.495n 1.8v 539.505n 1.8v 549.495n 1.8v 549.505n 1.8v 559.495n 1.8v 559.505n 1.8v 569.495n 1.8v 569.505n 1.8v 579.495n 1.8v 579.505n 1.8v 589.495n 1.8v 589.505n 1.8v 599.495n 1.8v 599.505n 1.8v 609.495n 1.8v 609.505n 1.8v 619.495n 1.8v 619.505n 0.0v 629.495n 0.0v 629.505n 0.0v 639.495n 0.0v 639.505n 0.0v 649.495n 0.0v 649.505n 1.8v 659.495n 1.8v 659.505n 1.8v 669.495n 1.8v 669.505n 0.0v 679.495n 0.0v 679.505n 0.0v 689.495n 0.0v 689.505n 0.0v 699.495n 0.0v 699.505n 0.0v 709.495n 0.0v 709.505n 0.0v 719.495n 0.0v 719.505n 0.0v 729.495n 0.0v 729.505n 0.0v 739.495n 0.0v 739.505n 1.8v 749.495n 1.8v 749.505n 1.8v 759.495n 1.8v 759.505n 1.8v 769.495n 1.8v 769.505n 1.8v 779.495n 1.8v 779.505n 1.8v 789.495n 1.8v 789.505n 1.8v 799.495n 1.8v 799.505n 1.8v 809.495n 1.8v 809.505n 1.8v 819.495n 1.8v 819.505n 1.8v 829.495n 1.8v 829.505n 1.8v 839.495n 1.8v 839.505n 1.8v 849.495n 1.8v 849.505n 1.8v 859.495n 1.8v 859.505n 1.8v 869.495n 1.8v 869.505n 1.8v 879.495n 1.8v 879.505n 1.8v 889.495n 1.8v 889.505n 1.8v 899.495n 1.8v 899.505n 0.0v 909.495n 0.0v 909.505n 1.8v 919.495n 1.8v 919.505n 0.0v 929.495n 0.0v 929.505n 0.0v 939.495n 0.0v 939.505n 0.0v 949.495n 0.0v 949.505n 0.0v 959.495n 0.0v 959.505n 0.0v 969.495n 0.0v 969.505n 0.0v 979.495n 0.0v 979.505n 0.0v 989.495n 0.0v 989.505n 0.0v 999.495n 0.0v 999.505n 0.0v 1009.495n 0.0v 1009.505n 0.0v 1019.495n 0.0v 1019.505n 0.0v 1029.495n 0.0v 1029.505n 0.0v 1039.495n 0.0v 1039.505n 1.8v 1049.495n 1.8v 1049.505n 1.8v 1059.495n 1.8v 1059.505n 1.8v 1069.495n 1.8v 1069.505n 1.8v 1079.495n 1.8v 1079.505n 1.8v 1089.495n 1.8v 1089.505n 1.8v 1099.495n 1.8v 1099.505n 0.0v 1109.495n 0.0v 1109.505n 0.0v 1119.495n 0.0v 1119.505n 0.0v 1129.495n 0.0v 1129.505n 1.8v 1139.495n 1.8v 1139.505n 1.8v 1149.495n 1.8v 1149.505n 0.0v 1159.495n 0.0v 1159.505n 0.0v 1169.495n 0.0v 1169.505n 0.0v 1179.495n 0.0v 1179.505n 0.0v 1189.495n 0.0v 1189.505n 0.0v 1199.495n 0.0v 1199.505n 0.0v 1209.495n 0.0v 1209.505n 1.8v 1219.495n 1.8v 1219.505n 1.8v 1229.495n 1.8v 1229.505n 0.0v 1239.495n 0.0v 1239.505n 1.8v 1249.495n 1.8v 1249.505n 0.0v 1259.495n 0.0v 1259.505n 0.0v 1269.495n 0.0v 1269.505n 0.0v 1279.495n 0.0v 1279.505n 0.0v 1289.495n 0.0v 1289.505n 0.0v 1299.495n 0.0v 1299.505n 0.0v 1309.495n 0.0v 1309.505n 0.0v 1319.495n 0.0v 1319.505n 0.0v 1329.495n 0.0v 1329.505n 0.0v 1339.495n 0.0v 1339.505n 0.0v 1349.495n 0.0v 1349.505n 1.8v 1359.495n 1.8v 1359.505n 1.8v 1369.495n 1.8v 1369.505n 1.8v 1379.495n 1.8v 1379.505n 1.8v 1389.495n 1.8v 1389.505n 1.8v 1399.495n 1.8v 1399.505n 1.8v 1409.495n 1.8v 1409.505n 1.8v 1419.495n 1.8v 1419.505n 0.0v 1429.495n 0.0v 1429.505n 0.0v 1439.495n 0.0v 1439.505n 0.0v 1449.495n 0.0v 1449.505n 0.0v 1459.495n 0.0v 1459.505n 0.0v 1469.495n 0.0v 1469.505n 0.0v 1479.495n 0.0v 1479.505n 0.0v 1489.495n 0.0v 1489.505n 0.0v 1499.495n 0.0v 1499.505n 0.0v 1509.495n 0.0v 1509.505n 1.8v 1519.495n 1.8v 1519.505n 1.8v 1529.495n 1.8v 1529.505n 0.0v 1539.495n 0.0v 1539.505n 0.0v 1549.495n 0.0v 1549.505n 1.8v 1559.495n 1.8v 1559.505n 1.8v 1569.495n 1.8v 1569.505n 0.0v 1579.495n 0.0v 1579.505n 1.8v 1589.495n 1.8v 1589.505n 1.8v 1599.495n 1.8v 1599.505n 1.8v 1609.495n 1.8v 1609.505n 1.8v 1619.495n 1.8v 1619.505n 1.8v 1629.495n 1.8v 1629.505n 1.8v 1639.495n 1.8v 1639.505n 1.8v 1649.495n 1.8v 1649.505n 1.8v 1659.495n 1.8v 1659.505n 0.0v 1669.495n 0.0v 1669.505n 0.0v 1679.495n 0.0v 1679.505n 1.8v 1689.495n 1.8v 1689.505n 1.8v 1699.495n 1.8v 1699.505n 1.8v 1709.495n 1.8v 1709.505n 0.0v 1719.495n 0.0v 1719.505n 0.0v 1729.495n 0.0v 1729.505n 1.8v 1739.495n 1.8v 1739.505n 1.8v 1749.495n 1.8v 1749.505n 1.8v 1759.495n 1.8v 1759.505n 1.8v 1769.495n 1.8v 1769.505n 1.8v 1779.495n 1.8v 1779.505n 0.0v 1789.495n 0.0v 1789.505n 0.0v 1799.495n 0.0v 1799.505n 1.8v 1809.495n 1.8v 1809.505n 1.8v 1819.495n 1.8v 1819.505n 1.8v 1829.495n 1.8v 1829.505n 1.8v 1839.495n 1.8v 1839.505n 1.8v 1849.495n 1.8v 1849.505n 1.8v 1859.495n 1.8v 1859.505n 1.8v 1869.495n 1.8v 1869.505n 1.8v 1879.495n 1.8v 1879.505n 1.8v 1889.495n 1.8v 1889.505n 1.8v 1899.495n 1.8v 1899.505n 1.8v 1909.495n 1.8v 1909.505n 1.8v 1919.495n 1.8v 1919.505n 1.8v 1929.495n 1.8v 1929.505n 1.8v 1939.495n 1.8v 1939.505n 1.8v 1949.495n 1.8v 1949.505n 1.8v 1959.495n 1.8v 1959.505n 1.8v 1969.495n 1.8v 1969.505n 1.8v 1979.495n 1.8v 1979.505n 1.8v 1989.495n 1.8v 1989.505n 0.0v 1999.495n 0.0v 1999.505n 0.0v 2009.495n 0.0v 2009.505n 0.0v 2019.495n 0.0v 2019.505n 0.0v 2029.495n 0.0v 2029.505n 0.0v 2039.495n 0.0v 2039.505n 1.8v 2049.495n 1.8v 2049.505n 1.8v )
* (time, data): [(0, 0), (10, 1), (20, 1), (30, 1), (40, 1), (50, 1), (60, 1), (70, 1), (80, 0), (90, 0), (100, 0), (110, 1), (120, 1), (130, 1), (140, 1), (150, 1), (160, 1), (170, 0), (180, 0), (190, 0), (200, 1), (210, 1), (220, 1), (230, 1), (240, 0), (250, 0), (260, 0), (270, 0), (280, 0), (290, 0), (300, 0), (310, 1), (320, 1), (330, 1), (340, 1), (350, 1), (360, 1), (370, 1), (380, 1), (390, 0), (400, 1), (410, 0), (420, 0), (430, 1), (440, 1), (450, 1), (460, 1), (470, 1), (480, 1), (490, 1), (500, 1), (510, 0), (520, 0), (530, 1), (540, 0), (550, 0), (560, 0), (570, 0), (580, 0), (590, 0), (600, 0), (610, 0), (620, 1), (630, 1), (640, 1), (650, 0), (660, 0), (670, 0), (680, 0), (690, 0), (700, 0), (710, 0), (720, 0), (730, 0), (740, 0), (750, 0), (760, 0), (770, 1), (780, 1), (790, 1), (800, 1), (810, 1), (820, 1), (830, 1), (840, 1), (850, 1), (860, 1), (870, 1), (880, 1), (890, 1), (900, 1), (910, 1), (920, 1), (930, 1), (940, 1), (950, 1), (960, 1), (970, 1), (980, 1), (990, 1), (1000, 0), (1010, 0), (1020, 0), (1030, 0), (1040, 1), (1050, 1), (1060, 0), (1070, 0), (1080, 0), (1090, 0), (1100, 1), (1110, 1), (1120, 1), (1130, 1), (1140, 1), (1150, 1), (1160, 1), (1170, 1), (1180, 1), (1190, 1), (1200, 1), (1210, 1), (1220, 1), (1230, 0), (1240, 0), (1250, 0), (1260, 1), (1270, 1), (1280, 1), (1290, 1), (1300, 1), (1310, 1), (1320, 1), (1330, 1), (1340, 0), (1350, 1), (1360, 1), (1370, 1), (1380, 1), (1390, 1), (1400, 1), (1410, 0), (1420, 0), (1430, 0), (1440, 0), (1450, 0), (1460, 0), (1470, 0), (1480, 1), (1490, 1), (1500, 1), (1510, 0), (1520, 0), (1530, 1), (1540, 1), (1550, 1), (1560, 1), (1570, 1), (1580, 0), (1590, 1), (1600, 1), (1610, 0), (1620, 0), (1630, 0), (1640, 0), (1650, 0), (1660, 0), (1670, 0), (1680, 1), (1690, 1), (1700, 1), (1710, 0), (1720, 0), (1730, 0), (1740, 0), (1750, 0), (1760, 0), (1770, 0), (1780, 1), (1790, 1), (1800, 0), (1810, 0), (1820, 0), (1830, 0), (1840, 0), (1850, 1), (1860, 1), (1870, 1), (1880, 1), (1890, 1), (1900, 0), (1910, 0), (1920, 0), (1930, 0), (1940, 0), (1950, 0), (1960, 0), (1970, 0), (1980, 0), (1990, 0), (2000, 0), (2010, 0), (2020, 0), (2030, 0), (2040, 0), (2050, 0)]
Vdin0_2  din0_2  0 PWL (0n 0.0v 9.495n 0.0v 9.505n 1.8v 19.495n 1.8v 19.505n 1.8v 29.495n 1.8v 29.505n 1.8v 39.495n 1.8v 39.505n 1.8v 49.495n 1.8v 49.505n 1.8v 59.495n 1.8v 59.505n 1.8v 69.495n 1.8v 69.505n 1.8v 79.495n 1.8v 79.505n 0.0v 89.495n 0.0v 89.505n 0.0v 99.495n 0.0v 99.505n 0.0v 109.495n 0.0v 109.505n 1.8v 119.495n 1.8v 119.505n 1.8v 129.495n 1.8v 129.505n 1.8v 139.495n 1.8v 139.505n 1.8v 149.495n 1.8v 149.505n 1.8v 159.495n 1.8v 159.505n 1.8v 169.495n 1.8v 169.505n 0.0v 179.495n 0.0v 179.505n 0.0v 189.495n 0.0v 189.505n 0.0v 199.495n 0.0v 199.505n 1.8v 209.495n 1.8v 209.505n 1.8v 219.495n 1.8v 219.505n 1.8v 229.495n 1.8v 229.505n 1.8v 239.495n 1.8v 239.505n 0.0v 249.495n 0.0v 249.505n 0.0v 259.495n 0.0v 259.505n 0.0v 269.495n 0.0v 269.505n 0.0v 279.495n 0.0v 279.505n 0.0v 289.495n 0.0v 289.505n 0.0v 299.495n 0.0v 299.505n 0.0v 309.495n 0.0v 309.505n 1.8v 319.495n 1.8v 319.505n 1.8v 329.495n 1.8v 329.505n 1.8v 339.495n 1.8v 339.505n 1.8v 349.495n 1.8v 349.505n 1.8v 359.495n 1.8v 359.505n 1.8v 369.495n 1.8v 369.505n 1.8v 379.495n 1.8v 379.505n 1.8v 389.495n 1.8v 389.505n 0.0v 399.495n 0.0v 399.505n 1.8v 409.495n 1.8v 409.505n 0.0v 419.495n 0.0v 419.505n 0.0v 429.495n 0.0v 429.505n 1.8v 439.495n 1.8v 439.505n 1.8v 449.495n 1.8v 449.505n 1.8v 459.495n 1.8v 459.505n 1.8v 469.495n 1.8v 469.505n 1.8v 479.495n 1.8v 479.505n 1.8v 489.495n 1.8v 489.505n 1.8v 499.495n 1.8v 499.505n 1.8v 509.495n 1.8v 509.505n 0.0v 519.495n 0.0v 519.505n 0.0v 529.495n 0.0v 529.505n 1.8v 539.495n 1.8v 539.505n 0.0v 549.495n 0.0v 549.505n 0.0v 559.495n 0.0v 559.505n 0.0v 569.495n 0.0v 569.505n 0.0v 579.495n 0.0v 579.505n 0.0v 589.495n 0.0v 589.505n 0.0v 599.495n 0.0v 599.505n 0.0v 609.495n 0.0v 609.505n 0.0v 619.495n 0.0v 619.505n 1.8v 629.495n 1.8v 629.505n 1.8v 639.495n 1.8v 639.505n 1.8v 649.495n 1.8v 649.505n 0.0v 659.495n 0.0v 659.505n 0.0v 669.495n 0.0v 669.505n 0.0v 679.495n 0.0v 679.505n 0.0v 689.495n 0.0v 689.505n 0.0v 699.495n 0.0v 699.505n 0.0v 709.495n 0.0v 709.505n 0.0v 719.495n 0.0v 719.505n 0.0v 729.495n 0.0v 729.505n 0.0v 739.495n 0.0v 739.505n 0.0v 749.495n 0.0v 749.505n 0.0v 759.495n 0.0v 759.505n 0.0v 769.495n 0.0v 769.505n 1.8v 779.495n 1.8v 779.505n 1.8v 789.495n 1.8v 789.505n 1.8v 799.495n 1.8v 799.505n 1.8v 809.495n 1.8v 809.505n 1.8v 819.495n 1.8v 819.505n 1.8v 829.495n 1.8v 829.505n 1.8v 839.495n 1.8v 839.505n 1.8v 849.495n 1.8v 849.505n 1.8v 859.495n 1.8v 859.505n 1.8v 869.495n 1.8v 869.505n 1.8v 879.495n 1.8v 879.505n 1.8v 889.495n 1.8v 889.505n 1.8v 899.495n 1.8v 899.505n 1.8v 909.495n 1.8v 909.505n 1.8v 919.495n 1.8v 919.505n 1.8v 929.495n 1.8v 929.505n 1.8v 939.495n 1.8v 939.505n 1.8v 949.495n 1.8v 949.505n 1.8v 959.495n 1.8v 959.505n 1.8v 969.495n 1.8v 969.505n 1.8v 979.495n 1.8v 979.505n 1.8v 989.495n 1.8v 989.505n 1.8v 999.495n 1.8v 999.505n 0.0v 1009.495n 0.0v 1009.505n 0.0v 1019.495n 0.0v 1019.505n 0.0v 1029.495n 0.0v 1029.505n 0.0v 1039.495n 0.0v 1039.505n 1.8v 1049.495n 1.8v 1049.505n 1.8v 1059.495n 1.8v 1059.505n 0.0v 1069.495n 0.0v 1069.505n 0.0v 1079.495n 0.0v 1079.505n 0.0v 1089.495n 0.0v 1089.505n 0.0v 1099.495n 0.0v 1099.505n 1.8v 1109.495n 1.8v 1109.505n 1.8v 1119.495n 1.8v 1119.505n 1.8v 1129.495n 1.8v 1129.505n 1.8v 1139.495n 1.8v 1139.505n 1.8v 1149.495n 1.8v 1149.505n 1.8v 1159.495n 1.8v 1159.505n 1.8v 1169.495n 1.8v 1169.505n 1.8v 1179.495n 1.8v 1179.505n 1.8v 1189.495n 1.8v 1189.505n 1.8v 1199.495n 1.8v 1199.505n 1.8v 1209.495n 1.8v 1209.505n 1.8v 1219.495n 1.8v 1219.505n 1.8v 1229.495n 1.8v 1229.505n 0.0v 1239.495n 0.0v 1239.505n 0.0v 1249.495n 0.0v 1249.505n 0.0v 1259.495n 0.0v 1259.505n 1.8v 1269.495n 1.8v 1269.505n 1.8v 1279.495n 1.8v 1279.505n 1.8v 1289.495n 1.8v 1289.505n 1.8v 1299.495n 1.8v 1299.505n 1.8v 1309.495n 1.8v 1309.505n 1.8v 1319.495n 1.8v 1319.505n 1.8v 1329.495n 1.8v 1329.505n 1.8v 1339.495n 1.8v 1339.505n 0.0v 1349.495n 0.0v 1349.505n 1.8v 1359.495n 1.8v 1359.505n 1.8v 1369.495n 1.8v 1369.505n 1.8v 1379.495n 1.8v 1379.505n 1.8v 1389.495n 1.8v 1389.505n 1.8v 1399.495n 1.8v 1399.505n 1.8v 1409.495n 1.8v 1409.505n 0.0v 1419.495n 0.0v 1419.505n 0.0v 1429.495n 0.0v 1429.505n 0.0v 1439.495n 0.0v 1439.505n 0.0v 1449.495n 0.0v 1449.505n 0.0v 1459.495n 0.0v 1459.505n 0.0v 1469.495n 0.0v 1469.505n 0.0v 1479.495n 0.0v 1479.505n 1.8v 1489.495n 1.8v 1489.505n 1.8v 1499.495n 1.8v 1499.505n 1.8v 1509.495n 1.8v 1509.505n 0.0v 1519.495n 0.0v 1519.505n 0.0v 1529.495n 0.0v 1529.505n 1.8v 1539.495n 1.8v 1539.505n 1.8v 1549.495n 1.8v 1549.505n 1.8v 1559.495n 1.8v 1559.505n 1.8v 1569.495n 1.8v 1569.505n 1.8v 1579.495n 1.8v 1579.505n 0.0v 1589.495n 0.0v 1589.505n 1.8v 1599.495n 1.8v 1599.505n 1.8v 1609.495n 1.8v 1609.505n 0.0v 1619.495n 0.0v 1619.505n 0.0v 1629.495n 0.0v 1629.505n 0.0v 1639.495n 0.0v 1639.505n 0.0v 1649.495n 0.0v 1649.505n 0.0v 1659.495n 0.0v 1659.505n 0.0v 1669.495n 0.0v 1669.505n 0.0v 1679.495n 0.0v 1679.505n 1.8v 1689.495n 1.8v 1689.505n 1.8v 1699.495n 1.8v 1699.505n 1.8v 1709.495n 1.8v 1709.505n 0.0v 1719.495n 0.0v 1719.505n 0.0v 1729.495n 0.0v 1729.505n 0.0v 1739.495n 0.0v 1739.505n 0.0v 1749.495n 0.0v 1749.505n 0.0v 1759.495n 0.0v 1759.505n 0.0v 1769.495n 0.0v 1769.505n 0.0v 1779.495n 0.0v 1779.505n 1.8v 1789.495n 1.8v 1789.505n 1.8v 1799.495n 1.8v 1799.505n 0.0v 1809.495n 0.0v 1809.505n 0.0v 1819.495n 0.0v 1819.505n 0.0v 1829.495n 0.0v 1829.505n 0.0v 1839.495n 0.0v 1839.505n 0.0v 1849.495n 0.0v 1849.505n 1.8v 1859.495n 1.8v 1859.505n 1.8v 1869.495n 1.8v 1869.505n 1.8v 1879.495n 1.8v 1879.505n 1.8v 1889.495n 1.8v 1889.505n 1.8v 1899.495n 1.8v 1899.505n 0.0v 1909.495n 0.0v 1909.505n 0.0v 1919.495n 0.0v 1919.505n 0.0v 1929.495n 0.0v 1929.505n 0.0v 1939.495n 0.0v 1939.505n 0.0v 1949.495n 0.0v 1949.505n 0.0v 1959.495n 0.0v 1959.505n 0.0v 1969.495n 0.0v 1969.505n 0.0v 1979.495n 0.0v 1979.505n 0.0v 1989.495n 0.0v 1989.505n 0.0v 1999.495n 0.0v 1999.505n 0.0v 2009.495n 0.0v 2009.505n 0.0v 2019.495n 0.0v 2019.505n 0.0v 2029.495n 0.0v 2029.505n 0.0v 2039.495n 0.0v 2039.505n 0.0v 2049.495n 0.0v 2049.505n 0.0v )
* (time, data): [(0, 0), (10, 0), (20, 0), (30, 1), (40, 1), (50, 1), (60, 1), (70, 1), (80, 1), (90, 1), (100, 1), (110, 0), (120, 0), (130, 0), (140, 0), (150, 0), (160, 0), (170, 1), (180, 1), (190, 1), (200, 1), (210, 1), (220, 1), (230, 1), (240, 0), (250, 0), (260, 0), (270, 0), (280, 0), (290, 0), (300, 0), (310, 0), (320, 1), (330, 1), (340, 1), (350, 1), (360, 1), (370, 1), (380, 1), (390, 0), (400, 1), (410, 0), (420, 0), (430, 1), (440, 1), (450, 1), (460, 1), (470, 1), (480, 1), (490, 1), (500, 1), (510, 0), (520, 0), (530, 1), (540, 0), (550, 0), (560, 0), (570, 0), (580, 0), (590, 0), (600, 1), (610, 1), (620, 0), (630, 0), (640, 0), (650, 1), (660, 1), (670, 0), (680, 0), (690, 0), (700, 0), (710, 0), (720, 0), (730, 0), (740, 0), (750, 1), (760, 1), (770, 0), (780, 0), (790, 0), (800, 0), (810, 0), (820, 0), (830, 0), (840, 0), (850, 0), (860, 1), (870, 1), (880, 1), (890, 1), (900, 0), (910, 1), (920, 0), (930, 0), (940, 0), (950, 0), (960, 0), (970, 0), (980, 0), (990, 0), (1000, 1), (1010, 1), (1020, 1), (1030, 1), (1040, 0), (1050, 0), (1060, 0), (1070, 0), (1080, 0), (1090, 0), (1100, 1), (1110, 1), (1120, 1), (1130, 1), (1140, 1), (1150, 0), (1160, 0), (1170, 0), (1180, 0), (1190, 0), (1200, 0), (1210, 1), (1220, 0), (1230, 1), (1240, 1), (1250, 1), (1260, 1), (1270, 1), (1280, 1), (1290, 1), (1300, 1), (1310, 1), (1320, 1), (1330, 1), (1340, 0), (1350, 0), (1360, 0), (1370, 0), (1380, 0), (1390, 1), (1400, 1), (1410, 1), (1420, 1), (1430, 1), (1440, 1), (1450, 1), (1460, 1), (1470, 1), (1480, 1), (1490, 1), (1500, 1), (1510, 0), (1520, 0), (1530, 0), (1540, 0), (1550, 0), (1560, 0), (1570, 0), (1580, 0), (1590, 0), (1600, 0), (1610, 1), (1620, 1), (1630, 1), (1640, 1), (1650, 1), (1660, 1), (1670, 1), (1680, 1), (1690, 1), (1700, 1), (1710, 1), (1720, 1), (1730, 0), (1740, 0), (1750, 0), (1760, 0), (1770, 0), (1780, 1), (1790, 1), (1800, 0), (1810, 0), (1820, 0), (1830, 0), (1840, 0), (1850, 0), (1860, 0), (1870, 0), (1880, 0), (1890, 0), (1900, 0), (1910, 0), (1920, 0), (1930, 0), (1940, 0), (1950, 1), (1960, 1), (1970, 0), (1980, 0), (1990, 0), (2000, 0), (2010, 0), (2020, 0), (2030, 0), (2040, 0), (2050, 0)]
Vdin0_3  din0_3  0 PWL (0n 0.0v 9.495n 0.0v 9.505n 0.0v 19.495n 0.0v 19.505n 0.0v 29.495n 0.0v 29.505n 1.8v 39.495n 1.8v 39.505n 1.8v 49.495n 1.8v 49.505n 1.8v 59.495n 1.8v 59.505n 1.8v 69.495n 1.8v 69.505n 1.8v 79.495n 1.8v 79.505n 1.8v 89.495n 1.8v 89.505n 1.8v 99.495n 1.8v 99.505n 1.8v 109.495n 1.8v 109.505n 0.0v 119.495n 0.0v 119.505n 0.0v 129.495n 0.0v 129.505n 0.0v 139.495n 0.0v 139.505n 0.0v 149.495n 0.0v 149.505n 0.0v 159.495n 0.0v 159.505n 0.0v 169.495n 0.0v 169.505n 1.8v 179.495n 1.8v 179.505n 1.8v 189.495n 1.8v 189.505n 1.8v 199.495n 1.8v 199.505n 1.8v 209.495n 1.8v 209.505n 1.8v 219.495n 1.8v 219.505n 1.8v 229.495n 1.8v 229.505n 1.8v 239.495n 1.8v 239.505n 0.0v 249.495n 0.0v 249.505n 0.0v 259.495n 0.0v 259.505n 0.0v 269.495n 0.0v 269.505n 0.0v 279.495n 0.0v 279.505n 0.0v 289.495n 0.0v 289.505n 0.0v 299.495n 0.0v 299.505n 0.0v 309.495n 0.0v 309.505n 0.0v 319.495n 0.0v 319.505n 1.8v 329.495n 1.8v 329.505n 1.8v 339.495n 1.8v 339.505n 1.8v 349.495n 1.8v 349.505n 1.8v 359.495n 1.8v 359.505n 1.8v 369.495n 1.8v 369.505n 1.8v 379.495n 1.8v 379.505n 1.8v 389.495n 1.8v 389.505n 0.0v 399.495n 0.0v 399.505n 1.8v 409.495n 1.8v 409.505n 0.0v 419.495n 0.0v 419.505n 0.0v 429.495n 0.0v 429.505n 1.8v 439.495n 1.8v 439.505n 1.8v 449.495n 1.8v 449.505n 1.8v 459.495n 1.8v 459.505n 1.8v 469.495n 1.8v 469.505n 1.8v 479.495n 1.8v 479.505n 1.8v 489.495n 1.8v 489.505n 1.8v 499.495n 1.8v 499.505n 1.8v 509.495n 1.8v 509.505n 0.0v 519.495n 0.0v 519.505n 0.0v 529.495n 0.0v 529.505n 1.8v 539.495n 1.8v 539.505n 0.0v 549.495n 0.0v 549.505n 0.0v 559.495n 0.0v 559.505n 0.0v 569.495n 0.0v 569.505n 0.0v 579.495n 0.0v 579.505n 0.0v 589.495n 0.0v 589.505n 0.0v 599.495n 0.0v 599.505n 1.8v 609.495n 1.8v 609.505n 1.8v 619.495n 1.8v 619.505n 0.0v 629.495n 0.0v 629.505n 0.0v 639.495n 0.0v 639.505n 0.0v 649.495n 0.0v 649.505n 1.8v 659.495n 1.8v 659.505n 1.8v 669.495n 1.8v 669.505n 0.0v 679.495n 0.0v 679.505n 0.0v 689.495n 0.0v 689.505n 0.0v 699.495n 0.0v 699.505n 0.0v 709.495n 0.0v 709.505n 0.0v 719.495n 0.0v 719.505n 0.0v 729.495n 0.0v 729.505n 0.0v 739.495n 0.0v 739.505n 0.0v 749.495n 0.0v 749.505n 1.8v 759.495n 1.8v 759.505n 1.8v 769.495n 1.8v 769.505n 0.0v 779.495n 0.0v 779.505n 0.0v 789.495n 0.0v 789.505n 0.0v 799.495n 0.0v 799.505n 0.0v 809.495n 0.0v 809.505n 0.0v 819.495n 0.0v 819.505n 0.0v 829.495n 0.0v 829.505n 0.0v 839.495n 0.0v 839.505n 0.0v 849.495n 0.0v 849.505n 0.0v 859.495n 0.0v 859.505n 1.8v 869.495n 1.8v 869.505n 1.8v 879.495n 1.8v 879.505n 1.8v 889.495n 1.8v 889.505n 1.8v 899.495n 1.8v 899.505n 0.0v 909.495n 0.0v 909.505n 1.8v 919.495n 1.8v 919.505n 0.0v 929.495n 0.0v 929.505n 0.0v 939.495n 0.0v 939.505n 0.0v 949.495n 0.0v 949.505n 0.0v 959.495n 0.0v 959.505n 0.0v 969.495n 0.0v 969.505n 0.0v 979.495n 0.0v 979.505n 0.0v 989.495n 0.0v 989.505n 0.0v 999.495n 0.0v 999.505n 1.8v 1009.495n 1.8v 1009.505n 1.8v 1019.495n 1.8v 1019.505n 1.8v 1029.495n 1.8v 1029.505n 1.8v 1039.495n 1.8v 1039.505n 0.0v 1049.495n 0.0v 1049.505n 0.0v 1059.495n 0.0v 1059.505n 0.0v 1069.495n 0.0v 1069.505n 0.0v 1079.495n 0.0v 1079.505n 0.0v 1089.495n 0.0v 1089.505n 0.0v 1099.495n 0.0v 1099.505n 1.8v 1109.495n 1.8v 1109.505n 1.8v 1119.495n 1.8v 1119.505n 1.8v 1129.495n 1.8v 1129.505n 1.8v 1139.495n 1.8v 1139.505n 1.8v 1149.495n 1.8v 1149.505n 0.0v 1159.495n 0.0v 1159.505n 0.0v 1169.495n 0.0v 1169.505n 0.0v 1179.495n 0.0v 1179.505n 0.0v 1189.495n 0.0v 1189.505n 0.0v 1199.495n 0.0v 1199.505n 0.0v 1209.495n 0.0v 1209.505n 1.8v 1219.495n 1.8v 1219.505n 0.0v 1229.495n 0.0v 1229.505n 1.8v 1239.495n 1.8v 1239.505n 1.8v 1249.495n 1.8v 1249.505n 1.8v 1259.495n 1.8v 1259.505n 1.8v 1269.495n 1.8v 1269.505n 1.8v 1279.495n 1.8v 1279.505n 1.8v 1289.495n 1.8v 1289.505n 1.8v 1299.495n 1.8v 1299.505n 1.8v 1309.495n 1.8v 1309.505n 1.8v 1319.495n 1.8v 1319.505n 1.8v 1329.495n 1.8v 1329.505n 1.8v 1339.495n 1.8v 1339.505n 0.0v 1349.495n 0.0v 1349.505n 0.0v 1359.495n 0.0v 1359.505n 0.0v 1369.495n 0.0v 1369.505n 0.0v 1379.495n 0.0v 1379.505n 0.0v 1389.495n 0.0v 1389.505n 1.8v 1399.495n 1.8v 1399.505n 1.8v 1409.495n 1.8v 1409.505n 1.8v 1419.495n 1.8v 1419.505n 1.8v 1429.495n 1.8v 1429.505n 1.8v 1439.495n 1.8v 1439.505n 1.8v 1449.495n 1.8v 1449.505n 1.8v 1459.495n 1.8v 1459.505n 1.8v 1469.495n 1.8v 1469.505n 1.8v 1479.495n 1.8v 1479.505n 1.8v 1489.495n 1.8v 1489.505n 1.8v 1499.495n 1.8v 1499.505n 1.8v 1509.495n 1.8v 1509.505n 0.0v 1519.495n 0.0v 1519.505n 0.0v 1529.495n 0.0v 1529.505n 0.0v 1539.495n 0.0v 1539.505n 0.0v 1549.495n 0.0v 1549.505n 0.0v 1559.495n 0.0v 1559.505n 0.0v 1569.495n 0.0v 1569.505n 0.0v 1579.495n 0.0v 1579.505n 0.0v 1589.495n 0.0v 1589.505n 0.0v 1599.495n 0.0v 1599.505n 0.0v 1609.495n 0.0v 1609.505n 1.8v 1619.495n 1.8v 1619.505n 1.8v 1629.495n 1.8v 1629.505n 1.8v 1639.495n 1.8v 1639.505n 1.8v 1649.495n 1.8v 1649.505n 1.8v 1659.495n 1.8v 1659.505n 1.8v 1669.495n 1.8v 1669.505n 1.8v 1679.495n 1.8v 1679.505n 1.8v 1689.495n 1.8v 1689.505n 1.8v 1699.495n 1.8v 1699.505n 1.8v 1709.495n 1.8v 1709.505n 1.8v 1719.495n 1.8v 1719.505n 1.8v 1729.495n 1.8v 1729.505n 0.0v 1739.495n 0.0v 1739.505n 0.0v 1749.495n 0.0v 1749.505n 0.0v 1759.495n 0.0v 1759.505n 0.0v 1769.495n 0.0v 1769.505n 0.0v 1779.495n 0.0v 1779.505n 1.8v 1789.495n 1.8v 1789.505n 1.8v 1799.495n 1.8v 1799.505n 0.0v 1809.495n 0.0v 1809.505n 0.0v 1819.495n 0.0v 1819.505n 0.0v 1829.495n 0.0v 1829.505n 0.0v 1839.495n 0.0v 1839.505n 0.0v 1849.495n 0.0v 1849.505n 0.0v 1859.495n 0.0v 1859.505n 0.0v 1869.495n 0.0v 1869.505n 0.0v 1879.495n 0.0v 1879.505n 0.0v 1889.495n 0.0v 1889.505n 0.0v 1899.495n 0.0v 1899.505n 0.0v 1909.495n 0.0v 1909.505n 0.0v 1919.495n 0.0v 1919.505n 0.0v 1929.495n 0.0v 1929.505n 0.0v 1939.495n 0.0v 1939.505n 0.0v 1949.495n 0.0v 1949.505n 1.8v 1959.495n 1.8v 1959.505n 1.8v 1969.495n 1.8v 1969.505n 0.0v 1979.495n 0.0v 1979.505n 0.0v 1989.495n 0.0v 1989.505n 0.0v 1999.495n 0.0v 1999.505n 0.0v 2009.495n 0.0v 2009.505n 0.0v 2019.495n 0.0v 2019.505n 0.0v 2029.495n 0.0v 2029.505n 0.0v 2039.495n 0.0v 2039.505n 0.0v 2049.495n 0.0v 2049.505n 0.0v )
* (time, data): [(0, 0), (10, 1), (20, 0), (30, 1), (40, 1), (50, 1), (60, 1), (70, 1), (80, 0), (90, 0), (100, 0), (110, 1), (120, 1), (130, 1), (140, 1), (150, 1), (160, 1), (170, 1), (180, 1), (190, 1), (200, 0), (210, 0), (220, 0), (230, 0), (240, 0), (250, 0), (260, 0), (270, 0), (280, 1), (290, 1), (300, 1), (310, 0), (320, 0), (330, 0), (340, 1), (350, 1), (360, 1), (370, 1), (380, 1), (390, 1), (400, 0), (410, 1), (420, 1), (430, 0), (440, 0), (450, 0), (460, 0), (470, 0), (480, 0), (490, 0), (500, 1), (510, 0), (520, 0), (530, 1), (540, 1), (550, 1), (560, 1), (570, 1), (580, 1), (590, 1), (600, 0), (610, 0), (620, 1), (630, 1), (640, 1), (650, 0), (660, 0), (670, 0), (680, 0), (690, 0), (700, 0), (710, 0), (720, 0), (730, 0), (740, 0), (750, 0), (760, 1), (770, 0), (780, 0), (790, 0), (800, 0), (810, 0), (820, 0), (830, 0), (840, 0), (850, 0), (860, 1), (870, 1), (880, 1), (890, 1), (900, 0), (910, 0), (920, 0), (930, 0), (940, 0), (950, 0), (960, 0), (970, 0), (980, 0), (990, 0), (1000, 1), (1010, 1), (1020, 1), (1030, 1), (1040, 1), (1050, 1), (1060, 1), (1070, 1), (1080, 1), (1090, 1), (1100, 0), (1110, 0), (1120, 1), (1130, 1), (1140, 1), (1150, 0), (1160, 0), (1170, 0), (1180, 0), (1190, 0), (1200, 0), (1210, 0), (1220, 0), (1230, 1), (1240, 0), (1250, 0), (1260, 0), (1270, 0), (1280, 0), (1290, 0), (1300, 0), (1310, 0), (1320, 0), (1330, 0), (1340, 1), (1350, 0), (1360, 0), (1370, 0), (1380, 0), (1390, 1), (1400, 1), (1410, 0), (1420, 0), (1430, 0), (1440, 0), (1450, 0), (1460, 0), (1470, 0), (1480, 1), (1490, 1), (1500, 1), (1510, 1), (1520, 1), (1530, 0), (1540, 0), (1550, 1), (1560, 1), (1570, 0), (1580, 1), (1590, 1), (1600, 1), (1610, 0), (1620, 0), (1630, 0), (1640, 0), (1650, 0), (1660, 0), (1670, 0), (1680, 0), (1690, 0), (1700, 0), (1710, 1), (1720, 1), (1730, 0), (1740, 0), (1750, 0), (1760, 0), (1770, 0), (1780, 0), (1790, 0), (1800, 1), (1810, 1), (1820, 1), (1830, 1), (1840, 1), (1850, 1), (1860, 1), (1870, 1), (1880, 1), (1890, 1), (1900, 1), (1910, 1), (1920, 1), (1930, 1), (1940, 0), (1950, 0), (1960, 0), (1970, 1), (1980, 1), (1990, 0), (2000, 0), (2010, 0), (2020, 0), (2030, 0), (2040, 0), (2050, 0)]
Vdin0_4  din0_4  0 PWL (0n 0.0v 9.495n 0.0v 9.505n 1.8v 19.495n 1.8v 19.505n 0.0v 29.495n 0.0v 29.505n 1.8v 39.495n 1.8v 39.505n 1.8v 49.495n 1.8v 49.505n 1.8v 59.495n 1.8v 59.505n 1.8v 69.495n 1.8v 69.505n 1.8v 79.495n 1.8v 79.505n 0.0v 89.495n 0.0v 89.505n 0.0v 99.495n 0.0v 99.505n 0.0v 109.495n 0.0v 109.505n 1.8v 119.495n 1.8v 119.505n 1.8v 129.495n 1.8v 129.505n 1.8v 139.495n 1.8v 139.505n 1.8v 149.495n 1.8v 149.505n 1.8v 159.495n 1.8v 159.505n 1.8v 169.495n 1.8v 169.505n 1.8v 179.495n 1.8v 179.505n 1.8v 189.495n 1.8v 189.505n 1.8v 199.495n 1.8v 199.505n 0.0v 209.495n 0.0v 209.505n 0.0v 219.495n 0.0v 219.505n 0.0v 229.495n 0.0v 229.505n 0.0v 239.495n 0.0v 239.505n 0.0v 249.495n 0.0v 249.505n 0.0v 259.495n 0.0v 259.505n 0.0v 269.495n 0.0v 269.505n 0.0v 279.495n 0.0v 279.505n 1.8v 289.495n 1.8v 289.505n 1.8v 299.495n 1.8v 299.505n 1.8v 309.495n 1.8v 309.505n 0.0v 319.495n 0.0v 319.505n 0.0v 329.495n 0.0v 329.505n 0.0v 339.495n 0.0v 339.505n 1.8v 349.495n 1.8v 349.505n 1.8v 359.495n 1.8v 359.505n 1.8v 369.495n 1.8v 369.505n 1.8v 379.495n 1.8v 379.505n 1.8v 389.495n 1.8v 389.505n 1.8v 399.495n 1.8v 399.505n 0.0v 409.495n 0.0v 409.505n 1.8v 419.495n 1.8v 419.505n 1.8v 429.495n 1.8v 429.505n 0.0v 439.495n 0.0v 439.505n 0.0v 449.495n 0.0v 449.505n 0.0v 459.495n 0.0v 459.505n 0.0v 469.495n 0.0v 469.505n 0.0v 479.495n 0.0v 479.505n 0.0v 489.495n 0.0v 489.505n 0.0v 499.495n 0.0v 499.505n 1.8v 509.495n 1.8v 509.505n 0.0v 519.495n 0.0v 519.505n 0.0v 529.495n 0.0v 529.505n 1.8v 539.495n 1.8v 539.505n 1.8v 549.495n 1.8v 549.505n 1.8v 559.495n 1.8v 559.505n 1.8v 569.495n 1.8v 569.505n 1.8v 579.495n 1.8v 579.505n 1.8v 589.495n 1.8v 589.505n 1.8v 599.495n 1.8v 599.505n 0.0v 609.495n 0.0v 609.505n 0.0v 619.495n 0.0v 619.505n 1.8v 629.495n 1.8v 629.505n 1.8v 639.495n 1.8v 639.505n 1.8v 649.495n 1.8v 649.505n 0.0v 659.495n 0.0v 659.505n 0.0v 669.495n 0.0v 669.505n 0.0v 679.495n 0.0v 679.505n 0.0v 689.495n 0.0v 689.505n 0.0v 699.495n 0.0v 699.505n 0.0v 709.495n 0.0v 709.505n 0.0v 719.495n 0.0v 719.505n 0.0v 729.495n 0.0v 729.505n 0.0v 739.495n 0.0v 739.505n 0.0v 749.495n 0.0v 749.505n 0.0v 759.495n 0.0v 759.505n 1.8v 769.495n 1.8v 769.505n 0.0v 779.495n 0.0v 779.505n 0.0v 789.495n 0.0v 789.505n 0.0v 799.495n 0.0v 799.505n 0.0v 809.495n 0.0v 809.505n 0.0v 819.495n 0.0v 819.505n 0.0v 829.495n 0.0v 829.505n 0.0v 839.495n 0.0v 839.505n 0.0v 849.495n 0.0v 849.505n 0.0v 859.495n 0.0v 859.505n 1.8v 869.495n 1.8v 869.505n 1.8v 879.495n 1.8v 879.505n 1.8v 889.495n 1.8v 889.505n 1.8v 899.495n 1.8v 899.505n 0.0v 909.495n 0.0v 909.505n 0.0v 919.495n 0.0v 919.505n 0.0v 929.495n 0.0v 929.505n 0.0v 939.495n 0.0v 939.505n 0.0v 949.495n 0.0v 949.505n 0.0v 959.495n 0.0v 959.505n 0.0v 969.495n 0.0v 969.505n 0.0v 979.495n 0.0v 979.505n 0.0v 989.495n 0.0v 989.505n 0.0v 999.495n 0.0v 999.505n 1.8v 1009.495n 1.8v 1009.505n 1.8v 1019.495n 1.8v 1019.505n 1.8v 1029.495n 1.8v 1029.505n 1.8v 1039.495n 1.8v 1039.505n 1.8v 1049.495n 1.8v 1049.505n 1.8v 1059.495n 1.8v 1059.505n 1.8v 1069.495n 1.8v 1069.505n 1.8v 1079.495n 1.8v 1079.505n 1.8v 1089.495n 1.8v 1089.505n 1.8v 1099.495n 1.8v 1099.505n 0.0v 1109.495n 0.0v 1109.505n 0.0v 1119.495n 0.0v 1119.505n 1.8v 1129.495n 1.8v 1129.505n 1.8v 1139.495n 1.8v 1139.505n 1.8v 1149.495n 1.8v 1149.505n 0.0v 1159.495n 0.0v 1159.505n 0.0v 1169.495n 0.0v 1169.505n 0.0v 1179.495n 0.0v 1179.505n 0.0v 1189.495n 0.0v 1189.505n 0.0v 1199.495n 0.0v 1199.505n 0.0v 1209.495n 0.0v 1209.505n 0.0v 1219.495n 0.0v 1219.505n 0.0v 1229.495n 0.0v 1229.505n 1.8v 1239.495n 1.8v 1239.505n 0.0v 1249.495n 0.0v 1249.505n 0.0v 1259.495n 0.0v 1259.505n 0.0v 1269.495n 0.0v 1269.505n 0.0v 1279.495n 0.0v 1279.505n 0.0v 1289.495n 0.0v 1289.505n 0.0v 1299.495n 0.0v 1299.505n 0.0v 1309.495n 0.0v 1309.505n 0.0v 1319.495n 0.0v 1319.505n 0.0v 1329.495n 0.0v 1329.505n 0.0v 1339.495n 0.0v 1339.505n 1.8v 1349.495n 1.8v 1349.505n 0.0v 1359.495n 0.0v 1359.505n 0.0v 1369.495n 0.0v 1369.505n 0.0v 1379.495n 0.0v 1379.505n 0.0v 1389.495n 0.0v 1389.505n 1.8v 1399.495n 1.8v 1399.505n 1.8v 1409.495n 1.8v 1409.505n 0.0v 1419.495n 0.0v 1419.505n 0.0v 1429.495n 0.0v 1429.505n 0.0v 1439.495n 0.0v 1439.505n 0.0v 1449.495n 0.0v 1449.505n 0.0v 1459.495n 0.0v 1459.505n 0.0v 1469.495n 0.0v 1469.505n 0.0v 1479.495n 0.0v 1479.505n 1.8v 1489.495n 1.8v 1489.505n 1.8v 1499.495n 1.8v 1499.505n 1.8v 1509.495n 1.8v 1509.505n 1.8v 1519.495n 1.8v 1519.505n 1.8v 1529.495n 1.8v 1529.505n 0.0v 1539.495n 0.0v 1539.505n 0.0v 1549.495n 0.0v 1549.505n 1.8v 1559.495n 1.8v 1559.505n 1.8v 1569.495n 1.8v 1569.505n 0.0v 1579.495n 0.0v 1579.505n 1.8v 1589.495n 1.8v 1589.505n 1.8v 1599.495n 1.8v 1599.505n 1.8v 1609.495n 1.8v 1609.505n 0.0v 1619.495n 0.0v 1619.505n 0.0v 1629.495n 0.0v 1629.505n 0.0v 1639.495n 0.0v 1639.505n 0.0v 1649.495n 0.0v 1649.505n 0.0v 1659.495n 0.0v 1659.505n 0.0v 1669.495n 0.0v 1669.505n 0.0v 1679.495n 0.0v 1679.505n 0.0v 1689.495n 0.0v 1689.505n 0.0v 1699.495n 0.0v 1699.505n 0.0v 1709.495n 0.0v 1709.505n 1.8v 1719.495n 1.8v 1719.505n 1.8v 1729.495n 1.8v 1729.505n 0.0v 1739.495n 0.0v 1739.505n 0.0v 1749.495n 0.0v 1749.505n 0.0v 1759.495n 0.0v 1759.505n 0.0v 1769.495n 0.0v 1769.505n 0.0v 1779.495n 0.0v 1779.505n 0.0v 1789.495n 0.0v 1789.505n 0.0v 1799.495n 0.0v 1799.505n 1.8v 1809.495n 1.8v 1809.505n 1.8v 1819.495n 1.8v 1819.505n 1.8v 1829.495n 1.8v 1829.505n 1.8v 1839.495n 1.8v 1839.505n 1.8v 1849.495n 1.8v 1849.505n 1.8v 1859.495n 1.8v 1859.505n 1.8v 1869.495n 1.8v 1869.505n 1.8v 1879.495n 1.8v 1879.505n 1.8v 1889.495n 1.8v 1889.505n 1.8v 1899.495n 1.8v 1899.505n 1.8v 1909.495n 1.8v 1909.505n 1.8v 1919.495n 1.8v 1919.505n 1.8v 1929.495n 1.8v 1929.505n 1.8v 1939.495n 1.8v 1939.505n 0.0v 1949.495n 0.0v 1949.505n 0.0v 1959.495n 0.0v 1959.505n 0.0v 1969.495n 0.0v 1969.505n 1.8v 1979.495n 1.8v 1979.505n 1.8v 1989.495n 1.8v 1989.505n 0.0v 1999.495n 0.0v 1999.505n 0.0v 2009.495n 0.0v 2009.505n 0.0v 2019.495n 0.0v 2019.505n 0.0v 2029.495n 0.0v 2029.505n 0.0v 2039.495n 0.0v 2039.505n 0.0v 2049.495n 0.0v 2049.505n 0.0v )
* (time, data): [(0, 0), (10, 1), (20, 0), (30, 1), (40, 1), (50, 1), (60, 1), (70, 1), (80, 1), (90, 1), (100, 1), (110, 1), (120, 1), (130, 1), (140, 1), (150, 1), (160, 1), (170, 1), (180, 1), (190, 1), (200, 1), (210, 1), (220, 1), (230, 1), (240, 0), (250, 0), (260, 0), (270, 0), (280, 1), (290, 1), (300, 1), (310, 0), (320, 0), (330, 0), (340, 1), (350, 1), (360, 1), (370, 1), (380, 1), (390, 1), (400, 1), (410, 0), (420, 0), (430, 0), (440, 0), (450, 0), (460, 0), (470, 0), (480, 0), (490, 0), (500, 0), (510, 0), (520, 0), (530, 0), (540, 1), (550, 1), (560, 1), (570, 1), (580, 1), (590, 1), (600, 0), (610, 0), (620, 1), (630, 1), (640, 1), (650, 1), (660, 1), (670, 1), (680, 1), (690, 1), (700, 1), (710, 1), (720, 1), (730, 1), (740, 1), (750, 0), (760, 1), (770, 1), (780, 1), (790, 1), (800, 1), (810, 1), (820, 1), (830, 1), (840, 1), (850, 1), (860, 1), (870, 1), (880, 1), (890, 1), (900, 1), (910, 0), (920, 0), (930, 0), (940, 0), (950, 0), (960, 0), (970, 0), (980, 0), (990, 1), (1000, 1), (1010, 1), (1020, 1), (1030, 1), (1040, 1), (1050, 1), (1060, 0), (1070, 0), (1080, 0), (1090, 0), (1100, 0), (1110, 0), (1120, 0), (1130, 0), (1140, 0), (1150, 1), (1160, 1), (1170, 1), (1180, 1), (1190, 1), (1200, 1), (1210, 0), (1220, 1), (1230, 1), (1240, 1), (1250, 0), (1260, 1), (1270, 1), (1280, 1), (1290, 1), (1300, 1), (1310, 1), (1320, 1), (1330, 1), (1340, 1), (1350, 0), (1360, 0), (1370, 0), (1380, 0), (1390, 0), (1400, 0), (1410, 0), (1420, 1), (1430, 1), (1440, 1), (1450, 1), (1460, 1), (1470, 1), (1480, 1), (1490, 1), (1500, 1), (1510, 1), (1520, 1), (1530, 0), (1540, 0), (1550, 1), (1560, 1), (1570, 0), (1580, 1), (1590, 1), (1600, 1), (1610, 0), (1620, 0), (1630, 0), (1640, 0), (1650, 0), (1660, 1), (1670, 1), (1680, 1), (1690, 1), (1700, 1), (1710, 0), (1720, 0), (1730, 1), (1740, 1), (1750, 1), (1760, 1), (1770, 1), (1780, 1), (1790, 1), (1800, 0), (1810, 0), (1820, 0), (1830, 0), (1840, 1), (1850, 1), (1860, 1), (1870, 1), (1880, 1), (1890, 1), (1900, 1), (1910, 1), (1920, 1), (1930, 1), (1940, 0), (1950, 1), (1960, 1), (1970, 1), (1980, 1), (1990, 1), (2000, 1), (2010, 1), (2020, 1), (2030, 1), (2040, 0), (2050, 0)]
Vdin0_5  din0_5  0 PWL (0n 0.0v 9.495n 0.0v 9.505n 1.8v 19.495n 1.8v 19.505n 0.0v 29.495n 0.0v 29.505n 1.8v 39.495n 1.8v 39.505n 1.8v 49.495n 1.8v 49.505n 1.8v 59.495n 1.8v 59.505n 1.8v 69.495n 1.8v 69.505n 1.8v 79.495n 1.8v 79.505n 1.8v 89.495n 1.8v 89.505n 1.8v 99.495n 1.8v 99.505n 1.8v 109.495n 1.8v 109.505n 1.8v 119.495n 1.8v 119.505n 1.8v 129.495n 1.8v 129.505n 1.8v 139.495n 1.8v 139.505n 1.8v 149.495n 1.8v 149.505n 1.8v 159.495n 1.8v 159.505n 1.8v 169.495n 1.8v 169.505n 1.8v 179.495n 1.8v 179.505n 1.8v 189.495n 1.8v 189.505n 1.8v 199.495n 1.8v 199.505n 1.8v 209.495n 1.8v 209.505n 1.8v 219.495n 1.8v 219.505n 1.8v 229.495n 1.8v 229.505n 1.8v 239.495n 1.8v 239.505n 0.0v 249.495n 0.0v 249.505n 0.0v 259.495n 0.0v 259.505n 0.0v 269.495n 0.0v 269.505n 0.0v 279.495n 0.0v 279.505n 1.8v 289.495n 1.8v 289.505n 1.8v 299.495n 1.8v 299.505n 1.8v 309.495n 1.8v 309.505n 0.0v 319.495n 0.0v 319.505n 0.0v 329.495n 0.0v 329.505n 0.0v 339.495n 0.0v 339.505n 1.8v 349.495n 1.8v 349.505n 1.8v 359.495n 1.8v 359.505n 1.8v 369.495n 1.8v 369.505n 1.8v 379.495n 1.8v 379.505n 1.8v 389.495n 1.8v 389.505n 1.8v 399.495n 1.8v 399.505n 1.8v 409.495n 1.8v 409.505n 0.0v 419.495n 0.0v 419.505n 0.0v 429.495n 0.0v 429.505n 0.0v 439.495n 0.0v 439.505n 0.0v 449.495n 0.0v 449.505n 0.0v 459.495n 0.0v 459.505n 0.0v 469.495n 0.0v 469.505n 0.0v 479.495n 0.0v 479.505n 0.0v 489.495n 0.0v 489.505n 0.0v 499.495n 0.0v 499.505n 0.0v 509.495n 0.0v 509.505n 0.0v 519.495n 0.0v 519.505n 0.0v 529.495n 0.0v 529.505n 0.0v 539.495n 0.0v 539.505n 1.8v 549.495n 1.8v 549.505n 1.8v 559.495n 1.8v 559.505n 1.8v 569.495n 1.8v 569.505n 1.8v 579.495n 1.8v 579.505n 1.8v 589.495n 1.8v 589.505n 1.8v 599.495n 1.8v 599.505n 0.0v 609.495n 0.0v 609.505n 0.0v 619.495n 0.0v 619.505n 1.8v 629.495n 1.8v 629.505n 1.8v 639.495n 1.8v 639.505n 1.8v 649.495n 1.8v 649.505n 1.8v 659.495n 1.8v 659.505n 1.8v 669.495n 1.8v 669.505n 1.8v 679.495n 1.8v 679.505n 1.8v 689.495n 1.8v 689.505n 1.8v 699.495n 1.8v 699.505n 1.8v 709.495n 1.8v 709.505n 1.8v 719.495n 1.8v 719.505n 1.8v 729.495n 1.8v 729.505n 1.8v 739.495n 1.8v 739.505n 1.8v 749.495n 1.8v 749.505n 0.0v 759.495n 0.0v 759.505n 1.8v 769.495n 1.8v 769.505n 1.8v 779.495n 1.8v 779.505n 1.8v 789.495n 1.8v 789.505n 1.8v 799.495n 1.8v 799.505n 1.8v 809.495n 1.8v 809.505n 1.8v 819.495n 1.8v 819.505n 1.8v 829.495n 1.8v 829.505n 1.8v 839.495n 1.8v 839.505n 1.8v 849.495n 1.8v 849.505n 1.8v 859.495n 1.8v 859.505n 1.8v 869.495n 1.8v 869.505n 1.8v 879.495n 1.8v 879.505n 1.8v 889.495n 1.8v 889.505n 1.8v 899.495n 1.8v 899.505n 1.8v 909.495n 1.8v 909.505n 0.0v 919.495n 0.0v 919.505n 0.0v 929.495n 0.0v 929.505n 0.0v 939.495n 0.0v 939.505n 0.0v 949.495n 0.0v 949.505n 0.0v 959.495n 0.0v 959.505n 0.0v 969.495n 0.0v 969.505n 0.0v 979.495n 0.0v 979.505n 0.0v 989.495n 0.0v 989.505n 1.8v 999.495n 1.8v 999.505n 1.8v 1009.495n 1.8v 1009.505n 1.8v 1019.495n 1.8v 1019.505n 1.8v 1029.495n 1.8v 1029.505n 1.8v 1039.495n 1.8v 1039.505n 1.8v 1049.495n 1.8v 1049.505n 1.8v 1059.495n 1.8v 1059.505n 0.0v 1069.495n 0.0v 1069.505n 0.0v 1079.495n 0.0v 1079.505n 0.0v 1089.495n 0.0v 1089.505n 0.0v 1099.495n 0.0v 1099.505n 0.0v 1109.495n 0.0v 1109.505n 0.0v 1119.495n 0.0v 1119.505n 0.0v 1129.495n 0.0v 1129.505n 0.0v 1139.495n 0.0v 1139.505n 0.0v 1149.495n 0.0v 1149.505n 1.8v 1159.495n 1.8v 1159.505n 1.8v 1169.495n 1.8v 1169.505n 1.8v 1179.495n 1.8v 1179.505n 1.8v 1189.495n 1.8v 1189.505n 1.8v 1199.495n 1.8v 1199.505n 1.8v 1209.495n 1.8v 1209.505n 0.0v 1219.495n 0.0v 1219.505n 1.8v 1229.495n 1.8v 1229.505n 1.8v 1239.495n 1.8v 1239.505n 1.8v 1249.495n 1.8v 1249.505n 0.0v 1259.495n 0.0v 1259.505n 1.8v 1269.495n 1.8v 1269.505n 1.8v 1279.495n 1.8v 1279.505n 1.8v 1289.495n 1.8v 1289.505n 1.8v 1299.495n 1.8v 1299.505n 1.8v 1309.495n 1.8v 1309.505n 1.8v 1319.495n 1.8v 1319.505n 1.8v 1329.495n 1.8v 1329.505n 1.8v 1339.495n 1.8v 1339.505n 1.8v 1349.495n 1.8v 1349.505n 0.0v 1359.495n 0.0v 1359.505n 0.0v 1369.495n 0.0v 1369.505n 0.0v 1379.495n 0.0v 1379.505n 0.0v 1389.495n 0.0v 1389.505n 0.0v 1399.495n 0.0v 1399.505n 0.0v 1409.495n 0.0v 1409.505n 0.0v 1419.495n 0.0v 1419.505n 1.8v 1429.495n 1.8v 1429.505n 1.8v 1439.495n 1.8v 1439.505n 1.8v 1449.495n 1.8v 1449.505n 1.8v 1459.495n 1.8v 1459.505n 1.8v 1469.495n 1.8v 1469.505n 1.8v 1479.495n 1.8v 1479.505n 1.8v 1489.495n 1.8v 1489.505n 1.8v 1499.495n 1.8v 1499.505n 1.8v 1509.495n 1.8v 1509.505n 1.8v 1519.495n 1.8v 1519.505n 1.8v 1529.495n 1.8v 1529.505n 0.0v 1539.495n 0.0v 1539.505n 0.0v 1549.495n 0.0v 1549.505n 1.8v 1559.495n 1.8v 1559.505n 1.8v 1569.495n 1.8v 1569.505n 0.0v 1579.495n 0.0v 1579.505n 1.8v 1589.495n 1.8v 1589.505n 1.8v 1599.495n 1.8v 1599.505n 1.8v 1609.495n 1.8v 1609.505n 0.0v 1619.495n 0.0v 1619.505n 0.0v 1629.495n 0.0v 1629.505n 0.0v 1639.495n 0.0v 1639.505n 0.0v 1649.495n 0.0v 1649.505n 0.0v 1659.495n 0.0v 1659.505n 1.8v 1669.495n 1.8v 1669.505n 1.8v 1679.495n 1.8v 1679.505n 1.8v 1689.495n 1.8v 1689.505n 1.8v 1699.495n 1.8v 1699.505n 1.8v 1709.495n 1.8v 1709.505n 0.0v 1719.495n 0.0v 1719.505n 0.0v 1729.495n 0.0v 1729.505n 1.8v 1739.495n 1.8v 1739.505n 1.8v 1749.495n 1.8v 1749.505n 1.8v 1759.495n 1.8v 1759.505n 1.8v 1769.495n 1.8v 1769.505n 1.8v 1779.495n 1.8v 1779.505n 1.8v 1789.495n 1.8v 1789.505n 1.8v 1799.495n 1.8v 1799.505n 0.0v 1809.495n 0.0v 1809.505n 0.0v 1819.495n 0.0v 1819.505n 0.0v 1829.495n 0.0v 1829.505n 0.0v 1839.495n 0.0v 1839.505n 1.8v 1849.495n 1.8v 1849.505n 1.8v 1859.495n 1.8v 1859.505n 1.8v 1869.495n 1.8v 1869.505n 1.8v 1879.495n 1.8v 1879.505n 1.8v 1889.495n 1.8v 1889.505n 1.8v 1899.495n 1.8v 1899.505n 1.8v 1909.495n 1.8v 1909.505n 1.8v 1919.495n 1.8v 1919.505n 1.8v 1929.495n 1.8v 1929.505n 1.8v 1939.495n 1.8v 1939.505n 0.0v 1949.495n 0.0v 1949.505n 1.8v 1959.495n 1.8v 1959.505n 1.8v 1969.495n 1.8v 1969.505n 1.8v 1979.495n 1.8v 1979.505n 1.8v 1989.495n 1.8v 1989.505n 1.8v 1999.495n 1.8v 1999.505n 1.8v 2009.495n 1.8v 2009.505n 1.8v 2019.495n 1.8v 2019.505n 1.8v 2029.495n 1.8v 2029.505n 1.8v 2039.495n 1.8v 2039.505n 0.0v 2049.495n 0.0v 2049.505n 0.0v )
* (time, data): [(0, 0), (10, 0), (20, 0), (30, 1), (40, 1), (50, 1), (60, 1), (70, 1), (80, 1), (90, 1), (100, 1), (110, 0), (120, 0), (130, 0), (140, 0), (150, 0), (160, 0), (170, 1), (180, 1), (190, 1), (200, 1), (210, 1), (220, 1), (230, 1), (240, 0), (250, 0), (260, 0), (270, 1), (280, 1), (290, 1), (300, 1), (310, 0), (320, 1), (330, 1), (340, 1), (350, 1), (360, 1), (370, 1), (380, 1), (390, 1), (400, 1), (410, 0), (420, 0), (430, 0), (440, 0), (450, 0), (460, 0), (470, 0), (480, 0), (490, 0), (500, 0), (510, 0), (520, 0), (530, 0), (540, 0), (550, 0), (560, 0), (570, 0), (580, 0), (590, 0), (600, 0), (610, 0), (620, 0), (630, 0), (640, 0), (650, 0), (660, 0), (670, 0), (680, 0), (690, 0), (700, 0), (710, 0), (720, 0), (730, 0), (740, 1), (750, 1), (760, 0), (770, 1), (780, 1), (790, 1), (800, 1), (810, 1), (820, 1), (830, 1), (840, 1), (850, 1), (860, 0), (870, 0), (880, 0), (890, 0), (900, 0), (910, 0), (920, 1), (930, 1), (940, 1), (950, 1), (960, 1), (970, 1), (980, 1), (990, 0), (1000, 0), (1010, 0), (1020, 0), (1030, 0), (1040, 1), (1050, 1), (1060, 0), (1070, 0), (1080, 0), (1090, 0), (1100, 1), (1110, 1), (1120, 1), (1130, 1), (1140, 1), (1150, 1), (1160, 1), (1170, 1), (1180, 1), (1190, 1), (1200, 1), (1210, 1), (1220, 1), (1230, 0), (1240, 0), (1250, 1), (1260, 1), (1270, 1), (1280, 1), (1290, 1), (1300, 1), (1310, 1), (1320, 1), (1330, 1), (1340, 1), (1350, 0), (1360, 0), (1370, 0), (1380, 0), (1390, 1), (1400, 1), (1410, 1), (1420, 1), (1430, 1), (1440, 1), (1450, 1), (1460, 1), (1470, 1), (1480, 0), (1490, 0), (1500, 0), (1510, 0), (1520, 0), (1530, 1), (1540, 1), (1550, 0), (1560, 0), (1570, 1), (1580, 0), (1590, 0), (1600, 0), (1610, 1), (1620, 1), (1630, 1), (1640, 1), (1650, 1), (1660, 0), (1670, 0), (1680, 1), (1690, 0), (1700, 0), (1710, 0), (1720, 0), (1730, 1), (1740, 1), (1750, 1), (1760, 1), (1770, 1), (1780, 1), (1790, 1), (1800, 0), (1810, 0), (1820, 0), (1830, 0), (1840, 0), (1850, 0), (1860, 0), (1870, 0), (1880, 0), (1890, 0), (1900, 0), (1910, 0), (1920, 0), (1930, 0), (1940, 0), (1950, 1), (1960, 1), (1970, 1), (1980, 1), (1990, 0), (2000, 0), (2010, 0), (2020, 0), (2030, 0), (2040, 1), (2050, 1)]
Vdin0_6  din0_6  0 PWL (0n 0.0v 9.495n 0.0v 9.505n 0.0v 19.495n 0.0v 19.505n 0.0v 29.495n 0.0v 29.505n 1.8v 39.495n 1.8v 39.505n 1.8v 49.495n 1.8v 49.505n 1.8v 59.495n 1.8v 59.505n 1.8v 69.495n 1.8v 69.505n 1.8v 79.495n 1.8v 79.505n 1.8v 89.495n 1.8v 89.505n 1.8v 99.495n 1.8v 99.505n 1.8v 109.495n 1.8v 109.505n 0.0v 119.495n 0.0v 119.505n 0.0v 129.495n 0.0v 129.505n 0.0v 139.495n 0.0v 139.505n 0.0v 149.495n 0.0v 149.505n 0.0v 159.495n 0.0v 159.505n 0.0v 169.495n 0.0v 169.505n 1.8v 179.495n 1.8v 179.505n 1.8v 189.495n 1.8v 189.505n 1.8v 199.495n 1.8v 199.505n 1.8v 209.495n 1.8v 209.505n 1.8v 219.495n 1.8v 219.505n 1.8v 229.495n 1.8v 229.505n 1.8v 239.495n 1.8v 239.505n 0.0v 249.495n 0.0v 249.505n 0.0v 259.495n 0.0v 259.505n 0.0v 269.495n 0.0v 269.505n 1.8v 279.495n 1.8v 279.505n 1.8v 289.495n 1.8v 289.505n 1.8v 299.495n 1.8v 299.505n 1.8v 309.495n 1.8v 309.505n 0.0v 319.495n 0.0v 319.505n 1.8v 329.495n 1.8v 329.505n 1.8v 339.495n 1.8v 339.505n 1.8v 349.495n 1.8v 349.505n 1.8v 359.495n 1.8v 359.505n 1.8v 369.495n 1.8v 369.505n 1.8v 379.495n 1.8v 379.505n 1.8v 389.495n 1.8v 389.505n 1.8v 399.495n 1.8v 399.505n 1.8v 409.495n 1.8v 409.505n 0.0v 419.495n 0.0v 419.505n 0.0v 429.495n 0.0v 429.505n 0.0v 439.495n 0.0v 439.505n 0.0v 449.495n 0.0v 449.505n 0.0v 459.495n 0.0v 459.505n 0.0v 469.495n 0.0v 469.505n 0.0v 479.495n 0.0v 479.505n 0.0v 489.495n 0.0v 489.505n 0.0v 499.495n 0.0v 499.505n 0.0v 509.495n 0.0v 509.505n 0.0v 519.495n 0.0v 519.505n 0.0v 529.495n 0.0v 529.505n 0.0v 539.495n 0.0v 539.505n 0.0v 549.495n 0.0v 549.505n 0.0v 559.495n 0.0v 559.505n 0.0v 569.495n 0.0v 569.505n 0.0v 579.495n 0.0v 579.505n 0.0v 589.495n 0.0v 589.505n 0.0v 599.495n 0.0v 599.505n 0.0v 609.495n 0.0v 609.505n 0.0v 619.495n 0.0v 619.505n 0.0v 629.495n 0.0v 629.505n 0.0v 639.495n 0.0v 639.505n 0.0v 649.495n 0.0v 649.505n 0.0v 659.495n 0.0v 659.505n 0.0v 669.495n 0.0v 669.505n 0.0v 679.495n 0.0v 679.505n 0.0v 689.495n 0.0v 689.505n 0.0v 699.495n 0.0v 699.505n 0.0v 709.495n 0.0v 709.505n 0.0v 719.495n 0.0v 719.505n 0.0v 729.495n 0.0v 729.505n 0.0v 739.495n 0.0v 739.505n 1.8v 749.495n 1.8v 749.505n 1.8v 759.495n 1.8v 759.505n 0.0v 769.495n 0.0v 769.505n 1.8v 779.495n 1.8v 779.505n 1.8v 789.495n 1.8v 789.505n 1.8v 799.495n 1.8v 799.505n 1.8v 809.495n 1.8v 809.505n 1.8v 819.495n 1.8v 819.505n 1.8v 829.495n 1.8v 829.505n 1.8v 839.495n 1.8v 839.505n 1.8v 849.495n 1.8v 849.505n 1.8v 859.495n 1.8v 859.505n 0.0v 869.495n 0.0v 869.505n 0.0v 879.495n 0.0v 879.505n 0.0v 889.495n 0.0v 889.505n 0.0v 899.495n 0.0v 899.505n 0.0v 909.495n 0.0v 909.505n 0.0v 919.495n 0.0v 919.505n 1.8v 929.495n 1.8v 929.505n 1.8v 939.495n 1.8v 939.505n 1.8v 949.495n 1.8v 949.505n 1.8v 959.495n 1.8v 959.505n 1.8v 969.495n 1.8v 969.505n 1.8v 979.495n 1.8v 979.505n 1.8v 989.495n 1.8v 989.505n 0.0v 999.495n 0.0v 999.505n 0.0v 1009.495n 0.0v 1009.505n 0.0v 1019.495n 0.0v 1019.505n 0.0v 1029.495n 0.0v 1029.505n 0.0v 1039.495n 0.0v 1039.505n 1.8v 1049.495n 1.8v 1049.505n 1.8v 1059.495n 1.8v 1059.505n 0.0v 1069.495n 0.0v 1069.505n 0.0v 1079.495n 0.0v 1079.505n 0.0v 1089.495n 0.0v 1089.505n 0.0v 1099.495n 0.0v 1099.505n 1.8v 1109.495n 1.8v 1109.505n 1.8v 1119.495n 1.8v 1119.505n 1.8v 1129.495n 1.8v 1129.505n 1.8v 1139.495n 1.8v 1139.505n 1.8v 1149.495n 1.8v 1149.505n 1.8v 1159.495n 1.8v 1159.505n 1.8v 1169.495n 1.8v 1169.505n 1.8v 1179.495n 1.8v 1179.505n 1.8v 1189.495n 1.8v 1189.505n 1.8v 1199.495n 1.8v 1199.505n 1.8v 1209.495n 1.8v 1209.505n 1.8v 1219.495n 1.8v 1219.505n 1.8v 1229.495n 1.8v 1229.505n 0.0v 1239.495n 0.0v 1239.505n 0.0v 1249.495n 0.0v 1249.505n 1.8v 1259.495n 1.8v 1259.505n 1.8v 1269.495n 1.8v 1269.505n 1.8v 1279.495n 1.8v 1279.505n 1.8v 1289.495n 1.8v 1289.505n 1.8v 1299.495n 1.8v 1299.505n 1.8v 1309.495n 1.8v 1309.505n 1.8v 1319.495n 1.8v 1319.505n 1.8v 1329.495n 1.8v 1329.505n 1.8v 1339.495n 1.8v 1339.505n 1.8v 1349.495n 1.8v 1349.505n 0.0v 1359.495n 0.0v 1359.505n 0.0v 1369.495n 0.0v 1369.505n 0.0v 1379.495n 0.0v 1379.505n 0.0v 1389.495n 0.0v 1389.505n 1.8v 1399.495n 1.8v 1399.505n 1.8v 1409.495n 1.8v 1409.505n 1.8v 1419.495n 1.8v 1419.505n 1.8v 1429.495n 1.8v 1429.505n 1.8v 1439.495n 1.8v 1439.505n 1.8v 1449.495n 1.8v 1449.505n 1.8v 1459.495n 1.8v 1459.505n 1.8v 1469.495n 1.8v 1469.505n 1.8v 1479.495n 1.8v 1479.505n 0.0v 1489.495n 0.0v 1489.505n 0.0v 1499.495n 0.0v 1499.505n 0.0v 1509.495n 0.0v 1509.505n 0.0v 1519.495n 0.0v 1519.505n 0.0v 1529.495n 0.0v 1529.505n 1.8v 1539.495n 1.8v 1539.505n 1.8v 1549.495n 1.8v 1549.505n 0.0v 1559.495n 0.0v 1559.505n 0.0v 1569.495n 0.0v 1569.505n 1.8v 1579.495n 1.8v 1579.505n 0.0v 1589.495n 0.0v 1589.505n 0.0v 1599.495n 0.0v 1599.505n 0.0v 1609.495n 0.0v 1609.505n 1.8v 1619.495n 1.8v 1619.505n 1.8v 1629.495n 1.8v 1629.505n 1.8v 1639.495n 1.8v 1639.505n 1.8v 1649.495n 1.8v 1649.505n 1.8v 1659.495n 1.8v 1659.505n 0.0v 1669.495n 0.0v 1669.505n 0.0v 1679.495n 0.0v 1679.505n 1.8v 1689.495n 1.8v 1689.505n 0.0v 1699.495n 0.0v 1699.505n 0.0v 1709.495n 0.0v 1709.505n 0.0v 1719.495n 0.0v 1719.505n 0.0v 1729.495n 0.0v 1729.505n 1.8v 1739.495n 1.8v 1739.505n 1.8v 1749.495n 1.8v 1749.505n 1.8v 1759.495n 1.8v 1759.505n 1.8v 1769.495n 1.8v 1769.505n 1.8v 1779.495n 1.8v 1779.505n 1.8v 1789.495n 1.8v 1789.505n 1.8v 1799.495n 1.8v 1799.505n 0.0v 1809.495n 0.0v 1809.505n 0.0v 1819.495n 0.0v 1819.505n 0.0v 1829.495n 0.0v 1829.505n 0.0v 1839.495n 0.0v 1839.505n 0.0v 1849.495n 0.0v 1849.505n 0.0v 1859.495n 0.0v 1859.505n 0.0v 1869.495n 0.0v 1869.505n 0.0v 1879.495n 0.0v 1879.505n 0.0v 1889.495n 0.0v 1889.505n 0.0v 1899.495n 0.0v 1899.505n 0.0v 1909.495n 0.0v 1909.505n 0.0v 1919.495n 0.0v 1919.505n 0.0v 1929.495n 0.0v 1929.505n 0.0v 1939.495n 0.0v 1939.505n 0.0v 1949.495n 0.0v 1949.505n 1.8v 1959.495n 1.8v 1959.505n 1.8v 1969.495n 1.8v 1969.505n 1.8v 1979.495n 1.8v 1979.505n 1.8v 1989.495n 1.8v 1989.505n 0.0v 1999.495n 0.0v 1999.505n 0.0v 2009.495n 0.0v 2009.505n 0.0v 2019.495n 0.0v 2019.505n 0.0v 2029.495n 0.0v 2029.505n 0.0v 2039.495n 0.0v 2039.505n 1.8v 2049.495n 1.8v 2049.505n 1.8v )
* (time, data): [(0, 0), (10, 1), (20, 0), (30, 0), (40, 0), (50, 0), (60, 0), (70, 0), (80, 1), (90, 1), (100, 1), (110, 1), (120, 1), (130, 1), (140, 1), (150, 1), (160, 1), (170, 1), (180, 1), (190, 1), (200, 0), (210, 0), (220, 0), (230, 0), (240, 1), (250, 1), (260, 1), (270, 1), (280, 0), (290, 0), (300, 0), (310, 1), (320, 0), (330, 0), (340, 1), (350, 1), (360, 1), (370, 1), (380, 1), (390, 0), (400, 1), (410, 1), (420, 1), (430, 0), (440, 0), (450, 0), (460, 0), (470, 0), (480, 0), (490, 0), (500, 0), (510, 1), (520, 1), (530, 1), (540, 0), (550, 0), (560, 0), (570, 0), (580, 0), (590, 0), (600, 0), (610, 0), (620, 1), (630, 1), (640, 1), (650, 1), (660, 1), (670, 0), (680, 0), (690, 0), (700, 0), (710, 0), (720, 0), (730, 0), (740, 1), (750, 0), (760, 1), (770, 0), (780, 0), (790, 0), (800, 0), (810, 0), (820, 0), (830, 0), (840, 0), (850, 0), (860, 1), (870, 1), (880, 1), (890, 1), (900, 0), (910, 0), (920, 0), (930, 0), (940, 0), (950, 0), (960, 0), (970, 0), (980, 0), (990, 1), (1000, 1), (1010, 1), (1020, 1), (1030, 1), (1040, 0), (1050, 0), (1060, 0), (1070, 0), (1080, 0), (1090, 0), (1100, 1), (1110, 1), (1120, 1), (1130, 0), (1140, 0), (1150, 0), (1160, 0), (1170, 0), (1180, 0), (1190, 0), (1200, 0), (1210, 1), (1220, 0), (1230, 1), (1240, 0), (1250, 0), (1260, 0), (1270, 0), (1280, 0), (1290, 0), (1300, 0), (1310, 0), (1320, 0), (1330, 0), (1340, 0), (1350, 0), (1360, 0), (1370, 0), (1380, 0), (1390, 0), (1400, 0), (1410, 0), (1420, 0), (1430, 0), (1440, 0), (1450, 0), (1460, 0), (1470, 0), (1480, 1), (1490, 1), (1500, 1), (1510, 0), (1520, 0), (1530, 0), (1540, 0), (1550, 0), (1560, 0), (1570, 1), (1580, 0), (1590, 1), (1600, 1), (1610, 0), (1620, 0), (1630, 0), (1640, 0), (1650, 0), (1660, 1), (1670, 1), (1680, 1), (1690, 1), (1700, 1), (1710, 1), (1720, 1), (1730, 1), (1740, 1), (1750, 1), (1760, 1), (1770, 1), (1780, 1), (1790, 1), (1800, 0), (1810, 0), (1820, 0), (1830, 0), (1840, 0), (1850, 1), (1860, 1), (1870, 1), (1880, 1), (1890, 1), (1900, 0), (1910, 0), (1920, 0), (1930, 0), (1940, 1), (1950, 1), (1960, 1), (1970, 1), (1980, 1), (1990, 1), (2000, 1), (2010, 1), (2020, 1), (2030, 1), (2040, 0), (2050, 0)]
Vdin0_7  din0_7  0 PWL (0n 0.0v 9.495n 0.0v 9.505n 1.8v 19.495n 1.8v 19.505n 0.0v 29.495n 0.0v 29.505n 0.0v 39.495n 0.0v 39.505n 0.0v 49.495n 0.0v 49.505n 0.0v 59.495n 0.0v 59.505n 0.0v 69.495n 0.0v 69.505n 0.0v 79.495n 0.0v 79.505n 1.8v 89.495n 1.8v 89.505n 1.8v 99.495n 1.8v 99.505n 1.8v 109.495n 1.8v 109.505n 1.8v 119.495n 1.8v 119.505n 1.8v 129.495n 1.8v 129.505n 1.8v 139.495n 1.8v 139.505n 1.8v 149.495n 1.8v 149.505n 1.8v 159.495n 1.8v 159.505n 1.8v 169.495n 1.8v 169.505n 1.8v 179.495n 1.8v 179.505n 1.8v 189.495n 1.8v 189.505n 1.8v 199.495n 1.8v 199.505n 0.0v 209.495n 0.0v 209.505n 0.0v 219.495n 0.0v 219.505n 0.0v 229.495n 0.0v 229.505n 0.0v 239.495n 0.0v 239.505n 1.8v 249.495n 1.8v 249.505n 1.8v 259.495n 1.8v 259.505n 1.8v 269.495n 1.8v 269.505n 1.8v 279.495n 1.8v 279.505n 0.0v 289.495n 0.0v 289.505n 0.0v 299.495n 0.0v 299.505n 0.0v 309.495n 0.0v 309.505n 1.8v 319.495n 1.8v 319.505n 0.0v 329.495n 0.0v 329.505n 0.0v 339.495n 0.0v 339.505n 1.8v 349.495n 1.8v 349.505n 1.8v 359.495n 1.8v 359.505n 1.8v 369.495n 1.8v 369.505n 1.8v 379.495n 1.8v 379.505n 1.8v 389.495n 1.8v 389.505n 0.0v 399.495n 0.0v 399.505n 1.8v 409.495n 1.8v 409.505n 1.8v 419.495n 1.8v 419.505n 1.8v 429.495n 1.8v 429.505n 0.0v 439.495n 0.0v 439.505n 0.0v 449.495n 0.0v 449.505n 0.0v 459.495n 0.0v 459.505n 0.0v 469.495n 0.0v 469.505n 0.0v 479.495n 0.0v 479.505n 0.0v 489.495n 0.0v 489.505n 0.0v 499.495n 0.0v 499.505n 0.0v 509.495n 0.0v 509.505n 1.8v 519.495n 1.8v 519.505n 1.8v 529.495n 1.8v 529.505n 1.8v 539.495n 1.8v 539.505n 0.0v 549.495n 0.0v 549.505n 0.0v 559.495n 0.0v 559.505n 0.0v 569.495n 0.0v 569.505n 0.0v 579.495n 0.0v 579.505n 0.0v 589.495n 0.0v 589.505n 0.0v 599.495n 0.0v 599.505n 0.0v 609.495n 0.0v 609.505n 0.0v 619.495n 0.0v 619.505n 1.8v 629.495n 1.8v 629.505n 1.8v 639.495n 1.8v 639.505n 1.8v 649.495n 1.8v 649.505n 1.8v 659.495n 1.8v 659.505n 1.8v 669.495n 1.8v 669.505n 0.0v 679.495n 0.0v 679.505n 0.0v 689.495n 0.0v 689.505n 0.0v 699.495n 0.0v 699.505n 0.0v 709.495n 0.0v 709.505n 0.0v 719.495n 0.0v 719.505n 0.0v 729.495n 0.0v 729.505n 0.0v 739.495n 0.0v 739.505n 1.8v 749.495n 1.8v 749.505n 0.0v 759.495n 0.0v 759.505n 1.8v 769.495n 1.8v 769.505n 0.0v 779.495n 0.0v 779.505n 0.0v 789.495n 0.0v 789.505n 0.0v 799.495n 0.0v 799.505n 0.0v 809.495n 0.0v 809.505n 0.0v 819.495n 0.0v 819.505n 0.0v 829.495n 0.0v 829.505n 0.0v 839.495n 0.0v 839.505n 0.0v 849.495n 0.0v 849.505n 0.0v 859.495n 0.0v 859.505n 1.8v 869.495n 1.8v 869.505n 1.8v 879.495n 1.8v 879.505n 1.8v 889.495n 1.8v 889.505n 1.8v 899.495n 1.8v 899.505n 0.0v 909.495n 0.0v 909.505n 0.0v 919.495n 0.0v 919.505n 0.0v 929.495n 0.0v 929.505n 0.0v 939.495n 0.0v 939.505n 0.0v 949.495n 0.0v 949.505n 0.0v 959.495n 0.0v 959.505n 0.0v 969.495n 0.0v 969.505n 0.0v 979.495n 0.0v 979.505n 0.0v 989.495n 0.0v 989.505n 1.8v 999.495n 1.8v 999.505n 1.8v 1009.495n 1.8v 1009.505n 1.8v 1019.495n 1.8v 1019.505n 1.8v 1029.495n 1.8v 1029.505n 1.8v 1039.495n 1.8v 1039.505n 0.0v 1049.495n 0.0v 1049.505n 0.0v 1059.495n 0.0v 1059.505n 0.0v 1069.495n 0.0v 1069.505n 0.0v 1079.495n 0.0v 1079.505n 0.0v 1089.495n 0.0v 1089.505n 0.0v 1099.495n 0.0v 1099.505n 1.8v 1109.495n 1.8v 1109.505n 1.8v 1119.495n 1.8v 1119.505n 1.8v 1129.495n 1.8v 1129.505n 0.0v 1139.495n 0.0v 1139.505n 0.0v 1149.495n 0.0v 1149.505n 0.0v 1159.495n 0.0v 1159.505n 0.0v 1169.495n 0.0v 1169.505n 0.0v 1179.495n 0.0v 1179.505n 0.0v 1189.495n 0.0v 1189.505n 0.0v 1199.495n 0.0v 1199.505n 0.0v 1209.495n 0.0v 1209.505n 1.8v 1219.495n 1.8v 1219.505n 0.0v 1229.495n 0.0v 1229.505n 1.8v 1239.495n 1.8v 1239.505n 0.0v 1249.495n 0.0v 1249.505n 0.0v 1259.495n 0.0v 1259.505n 0.0v 1269.495n 0.0v 1269.505n 0.0v 1279.495n 0.0v 1279.505n 0.0v 1289.495n 0.0v 1289.505n 0.0v 1299.495n 0.0v 1299.505n 0.0v 1309.495n 0.0v 1309.505n 0.0v 1319.495n 0.0v 1319.505n 0.0v 1329.495n 0.0v 1329.505n 0.0v 1339.495n 0.0v 1339.505n 0.0v 1349.495n 0.0v 1349.505n 0.0v 1359.495n 0.0v 1359.505n 0.0v 1369.495n 0.0v 1369.505n 0.0v 1379.495n 0.0v 1379.505n 0.0v 1389.495n 0.0v 1389.505n 0.0v 1399.495n 0.0v 1399.505n 0.0v 1409.495n 0.0v 1409.505n 0.0v 1419.495n 0.0v 1419.505n 0.0v 1429.495n 0.0v 1429.505n 0.0v 1439.495n 0.0v 1439.505n 0.0v 1449.495n 0.0v 1449.505n 0.0v 1459.495n 0.0v 1459.505n 0.0v 1469.495n 0.0v 1469.505n 0.0v 1479.495n 0.0v 1479.505n 1.8v 1489.495n 1.8v 1489.505n 1.8v 1499.495n 1.8v 1499.505n 1.8v 1509.495n 1.8v 1509.505n 0.0v 1519.495n 0.0v 1519.505n 0.0v 1529.495n 0.0v 1529.505n 0.0v 1539.495n 0.0v 1539.505n 0.0v 1549.495n 0.0v 1549.505n 0.0v 1559.495n 0.0v 1559.505n 0.0v 1569.495n 0.0v 1569.505n 1.8v 1579.495n 1.8v 1579.505n 0.0v 1589.495n 0.0v 1589.505n 1.8v 1599.495n 1.8v 1599.505n 1.8v 1609.495n 1.8v 1609.505n 0.0v 1619.495n 0.0v 1619.505n 0.0v 1629.495n 0.0v 1629.505n 0.0v 1639.495n 0.0v 1639.505n 0.0v 1649.495n 0.0v 1649.505n 0.0v 1659.495n 0.0v 1659.505n 1.8v 1669.495n 1.8v 1669.505n 1.8v 1679.495n 1.8v 1679.505n 1.8v 1689.495n 1.8v 1689.505n 1.8v 1699.495n 1.8v 1699.505n 1.8v 1709.495n 1.8v 1709.505n 1.8v 1719.495n 1.8v 1719.505n 1.8v 1729.495n 1.8v 1729.505n 1.8v 1739.495n 1.8v 1739.505n 1.8v 1749.495n 1.8v 1749.505n 1.8v 1759.495n 1.8v 1759.505n 1.8v 1769.495n 1.8v 1769.505n 1.8v 1779.495n 1.8v 1779.505n 1.8v 1789.495n 1.8v 1789.505n 1.8v 1799.495n 1.8v 1799.505n 0.0v 1809.495n 0.0v 1809.505n 0.0v 1819.495n 0.0v 1819.505n 0.0v 1829.495n 0.0v 1829.505n 0.0v 1839.495n 0.0v 1839.505n 0.0v 1849.495n 0.0v 1849.505n 1.8v 1859.495n 1.8v 1859.505n 1.8v 1869.495n 1.8v 1869.505n 1.8v 1879.495n 1.8v 1879.505n 1.8v 1889.495n 1.8v 1889.505n 1.8v 1899.495n 1.8v 1899.505n 0.0v 1909.495n 0.0v 1909.505n 0.0v 1919.495n 0.0v 1919.505n 0.0v 1929.495n 0.0v 1929.505n 0.0v 1939.495n 0.0v 1939.505n 1.8v 1949.495n 1.8v 1949.505n 1.8v 1959.495n 1.8v 1959.505n 1.8v 1969.495n 1.8v 1969.505n 1.8v 1979.495n 1.8v 1979.505n 1.8v 1989.495n 1.8v 1989.505n 1.8v 1999.495n 1.8v 1999.505n 1.8v 2009.495n 1.8v 2009.505n 1.8v 2019.495n 1.8v 2019.505n 1.8v 2029.495n 1.8v 2029.505n 1.8v 2039.495n 1.8v 2039.505n 0.0v 2049.495n 0.0v 2049.505n 0.0v )
* (time, data): [(0, 0), (10, 0), (20, 0), (30, 0), (40, 0), (50, 0), (60, 0), (70, 0), (80, 1), (90, 1), (100, 1), (110, 0), (120, 0), (130, 0), (140, 0), (150, 0), (160, 0), (170, 0), (180, 0), (190, 0), (200, 1), (210, 1), (220, 1), (230, 1), (240, 1), (250, 1), (260, 1), (270, 0), (280, 1), (290, 1), (300, 1), (310, 0), (320, 0), (330, 0), (340, 0), (350, 0), (360, 0), (370, 0), (380, 0), (390, 1), (400, 0), (410, 1), (420, 1), (430, 0), (440, 0), (450, 0), (460, 0), (470, 0), (480, 0), (490, 0), (500, 1), (510, 0), (520, 0), (530, 1), (540, 1), (550, 1), (560, 1), (570, 1), (580, 1), (590, 1), (600, 1), (610, 1), (620, 0), (630, 0), (640, 0), (650, 0), (660, 0), (670, 0), (680, 0), (690, 0), (700, 0), (710, 0), (720, 0), (730, 0), (740, 0), (750, 1), (760, 0), (770, 1), (780, 1), (790, 1), (800, 1), (810, 1), (820, 1), (830, 1), (840, 1), (850, 1), (860, 1), (870, 1), (880, 1), (890, 1), (900, 1), (910, 0), (920, 0), (930, 0), (940, 0), (950, 0), (960, 0), (970, 0), (980, 0), (990, 1), (1000, 0), (1010, 0), (1020, 0), (1030, 0), (1040, 1), (1050, 1), (1060, 0), (1070, 0), (1080, 0), (1090, 0), (1100, 0), (1110, 0), (1120, 1), (1130, 0), (1140, 0), (1150, 0), (1160, 0), (1170, 0), (1180, 0), (1190, 0), (1200, 0), (1210, 1), (1220, 1), (1230, 0), (1240, 0), (1250, 0), (1260, 1), (1270, 1), (1280, 1), (1290, 1), (1300, 1), (1310, 1), (1320, 1), (1330, 1), (1340, 1), (1350, 1), (1360, 1), (1370, 1), (1380, 1), (1390, 1), (1400, 1), (1410, 0), (1420, 1), (1430, 1), (1440, 1), (1450, 1), (1460, 1), (1470, 1), (1480, 0), (1490, 0), (1500, 0), (1510, 1), (1520, 1), (1530, 1), (1540, 1), (1550, 1), (1560, 1), (1570, 0), (1580, 0), (1590, 0), (1600, 0), (1610, 1), (1620, 1), (1630, 1), (1640, 1), (1650, 1), (1660, 1), (1670, 1), (1680, 0), (1690, 1), (1700, 1), (1710, 0), (1720, 0), (1730, 1), (1740, 1), (1750, 1), (1760, 1), (1770, 1), (1780, 0), (1790, 0), (1800, 0), (1810, 0), (1820, 0), (1830, 0), (1840, 0), (1850, 0), (1860, 0), (1870, 0), (1880, 0), (1890, 0), (1900, 1), (1910, 1), (1920, 1), (1930, 1), (1940, 1), (1950, 1), (1960, 1), (1970, 0), (1980, 0), (1990, 0), (2000, 0), (2010, 0), (2020, 0), (2030, 0), (2040, 0), (2050, 0)]
Vdin0_8  din0_8  0 PWL (0n 0.0v 9.495n 0.0v 9.505n 0.0v 19.495n 0.0v 19.505n 0.0v 29.495n 0.0v 29.505n 0.0v 39.495n 0.0v 39.505n 0.0v 49.495n 0.0v 49.505n 0.0v 59.495n 0.0v 59.505n 0.0v 69.495n 0.0v 69.505n 0.0v 79.495n 0.0v 79.505n 1.8v 89.495n 1.8v 89.505n 1.8v 99.495n 1.8v 99.505n 1.8v 109.495n 1.8v 109.505n 0.0v 119.495n 0.0v 119.505n 0.0v 129.495n 0.0v 129.505n 0.0v 139.495n 0.0v 139.505n 0.0v 149.495n 0.0v 149.505n 0.0v 159.495n 0.0v 159.505n 0.0v 169.495n 0.0v 169.505n 0.0v 179.495n 0.0v 179.505n 0.0v 189.495n 0.0v 189.505n 0.0v 199.495n 0.0v 199.505n 1.8v 209.495n 1.8v 209.505n 1.8v 219.495n 1.8v 219.505n 1.8v 229.495n 1.8v 229.505n 1.8v 239.495n 1.8v 239.505n 1.8v 249.495n 1.8v 249.505n 1.8v 259.495n 1.8v 259.505n 1.8v 269.495n 1.8v 269.505n 0.0v 279.495n 0.0v 279.505n 1.8v 289.495n 1.8v 289.505n 1.8v 299.495n 1.8v 299.505n 1.8v 309.495n 1.8v 309.505n 0.0v 319.495n 0.0v 319.505n 0.0v 329.495n 0.0v 329.505n 0.0v 339.495n 0.0v 339.505n 0.0v 349.495n 0.0v 349.505n 0.0v 359.495n 0.0v 359.505n 0.0v 369.495n 0.0v 369.505n 0.0v 379.495n 0.0v 379.505n 0.0v 389.495n 0.0v 389.505n 1.8v 399.495n 1.8v 399.505n 0.0v 409.495n 0.0v 409.505n 1.8v 419.495n 1.8v 419.505n 1.8v 429.495n 1.8v 429.505n 0.0v 439.495n 0.0v 439.505n 0.0v 449.495n 0.0v 449.505n 0.0v 459.495n 0.0v 459.505n 0.0v 469.495n 0.0v 469.505n 0.0v 479.495n 0.0v 479.505n 0.0v 489.495n 0.0v 489.505n 0.0v 499.495n 0.0v 499.505n 1.8v 509.495n 1.8v 509.505n 0.0v 519.495n 0.0v 519.505n 0.0v 529.495n 0.0v 529.505n 1.8v 539.495n 1.8v 539.505n 1.8v 549.495n 1.8v 549.505n 1.8v 559.495n 1.8v 559.505n 1.8v 569.495n 1.8v 569.505n 1.8v 579.495n 1.8v 579.505n 1.8v 589.495n 1.8v 589.505n 1.8v 599.495n 1.8v 599.505n 1.8v 609.495n 1.8v 609.505n 1.8v 619.495n 1.8v 619.505n 0.0v 629.495n 0.0v 629.505n 0.0v 639.495n 0.0v 639.505n 0.0v 649.495n 0.0v 649.505n 0.0v 659.495n 0.0v 659.505n 0.0v 669.495n 0.0v 669.505n 0.0v 679.495n 0.0v 679.505n 0.0v 689.495n 0.0v 689.505n 0.0v 699.495n 0.0v 699.505n 0.0v 709.495n 0.0v 709.505n 0.0v 719.495n 0.0v 719.505n 0.0v 729.495n 0.0v 729.505n 0.0v 739.495n 0.0v 739.505n 0.0v 749.495n 0.0v 749.505n 1.8v 759.495n 1.8v 759.505n 0.0v 769.495n 0.0v 769.505n 1.8v 779.495n 1.8v 779.505n 1.8v 789.495n 1.8v 789.505n 1.8v 799.495n 1.8v 799.505n 1.8v 809.495n 1.8v 809.505n 1.8v 819.495n 1.8v 819.505n 1.8v 829.495n 1.8v 829.505n 1.8v 839.495n 1.8v 839.505n 1.8v 849.495n 1.8v 849.505n 1.8v 859.495n 1.8v 859.505n 1.8v 869.495n 1.8v 869.505n 1.8v 879.495n 1.8v 879.505n 1.8v 889.495n 1.8v 889.505n 1.8v 899.495n 1.8v 899.505n 1.8v 909.495n 1.8v 909.505n 0.0v 919.495n 0.0v 919.505n 0.0v 929.495n 0.0v 929.505n 0.0v 939.495n 0.0v 939.505n 0.0v 949.495n 0.0v 949.505n 0.0v 959.495n 0.0v 959.505n 0.0v 969.495n 0.0v 969.505n 0.0v 979.495n 0.0v 979.505n 0.0v 989.495n 0.0v 989.505n 1.8v 999.495n 1.8v 999.505n 0.0v 1009.495n 0.0v 1009.505n 0.0v 1019.495n 0.0v 1019.505n 0.0v 1029.495n 0.0v 1029.505n 0.0v 1039.495n 0.0v 1039.505n 1.8v 1049.495n 1.8v 1049.505n 1.8v 1059.495n 1.8v 1059.505n 0.0v 1069.495n 0.0v 1069.505n 0.0v 1079.495n 0.0v 1079.505n 0.0v 1089.495n 0.0v 1089.505n 0.0v 1099.495n 0.0v 1099.505n 0.0v 1109.495n 0.0v 1109.505n 0.0v 1119.495n 0.0v 1119.505n 1.8v 1129.495n 1.8v 1129.505n 0.0v 1139.495n 0.0v 1139.505n 0.0v 1149.495n 0.0v 1149.505n 0.0v 1159.495n 0.0v 1159.505n 0.0v 1169.495n 0.0v 1169.505n 0.0v 1179.495n 0.0v 1179.505n 0.0v 1189.495n 0.0v 1189.505n 0.0v 1199.495n 0.0v 1199.505n 0.0v 1209.495n 0.0v 1209.505n 1.8v 1219.495n 1.8v 1219.505n 1.8v 1229.495n 1.8v 1229.505n 0.0v 1239.495n 0.0v 1239.505n 0.0v 1249.495n 0.0v 1249.505n 0.0v 1259.495n 0.0v 1259.505n 1.8v 1269.495n 1.8v 1269.505n 1.8v 1279.495n 1.8v 1279.505n 1.8v 1289.495n 1.8v 1289.505n 1.8v 1299.495n 1.8v 1299.505n 1.8v 1309.495n 1.8v 1309.505n 1.8v 1319.495n 1.8v 1319.505n 1.8v 1329.495n 1.8v 1329.505n 1.8v 1339.495n 1.8v 1339.505n 1.8v 1349.495n 1.8v 1349.505n 1.8v 1359.495n 1.8v 1359.505n 1.8v 1369.495n 1.8v 1369.505n 1.8v 1379.495n 1.8v 1379.505n 1.8v 1389.495n 1.8v 1389.505n 1.8v 1399.495n 1.8v 1399.505n 1.8v 1409.495n 1.8v 1409.505n 0.0v 1419.495n 0.0v 1419.505n 1.8v 1429.495n 1.8v 1429.505n 1.8v 1439.495n 1.8v 1439.505n 1.8v 1449.495n 1.8v 1449.505n 1.8v 1459.495n 1.8v 1459.505n 1.8v 1469.495n 1.8v 1469.505n 1.8v 1479.495n 1.8v 1479.505n 0.0v 1489.495n 0.0v 1489.505n 0.0v 1499.495n 0.0v 1499.505n 0.0v 1509.495n 0.0v 1509.505n 1.8v 1519.495n 1.8v 1519.505n 1.8v 1529.495n 1.8v 1529.505n 1.8v 1539.495n 1.8v 1539.505n 1.8v 1549.495n 1.8v 1549.505n 1.8v 1559.495n 1.8v 1559.505n 1.8v 1569.495n 1.8v 1569.505n 0.0v 1579.495n 0.0v 1579.505n 0.0v 1589.495n 0.0v 1589.505n 0.0v 1599.495n 0.0v 1599.505n 0.0v 1609.495n 0.0v 1609.505n 1.8v 1619.495n 1.8v 1619.505n 1.8v 1629.495n 1.8v 1629.505n 1.8v 1639.495n 1.8v 1639.505n 1.8v 1649.495n 1.8v 1649.505n 1.8v 1659.495n 1.8v 1659.505n 1.8v 1669.495n 1.8v 1669.505n 1.8v 1679.495n 1.8v 1679.505n 0.0v 1689.495n 0.0v 1689.505n 1.8v 1699.495n 1.8v 1699.505n 1.8v 1709.495n 1.8v 1709.505n 0.0v 1719.495n 0.0v 1719.505n 0.0v 1729.495n 0.0v 1729.505n 1.8v 1739.495n 1.8v 1739.505n 1.8v 1749.495n 1.8v 1749.505n 1.8v 1759.495n 1.8v 1759.505n 1.8v 1769.495n 1.8v 1769.505n 1.8v 1779.495n 1.8v 1779.505n 0.0v 1789.495n 0.0v 1789.505n 0.0v 1799.495n 0.0v 1799.505n 0.0v 1809.495n 0.0v 1809.505n 0.0v 1819.495n 0.0v 1819.505n 0.0v 1829.495n 0.0v 1829.505n 0.0v 1839.495n 0.0v 1839.505n 0.0v 1849.495n 0.0v 1849.505n 0.0v 1859.495n 0.0v 1859.505n 0.0v 1869.495n 0.0v 1869.505n 0.0v 1879.495n 0.0v 1879.505n 0.0v 1889.495n 0.0v 1889.505n 0.0v 1899.495n 0.0v 1899.505n 1.8v 1909.495n 1.8v 1909.505n 1.8v 1919.495n 1.8v 1919.505n 1.8v 1929.495n 1.8v 1929.505n 1.8v 1939.495n 1.8v 1939.505n 1.8v 1949.495n 1.8v 1949.505n 1.8v 1959.495n 1.8v 1959.505n 1.8v 1969.495n 1.8v 1969.505n 0.0v 1979.495n 0.0v 1979.505n 0.0v 1989.495n 0.0v 1989.505n 0.0v 1999.495n 0.0v 1999.505n 0.0v 2009.495n 0.0v 2009.505n 0.0v 2019.495n 0.0v 2019.505n 0.0v 2029.495n 0.0v 2029.505n 0.0v 2039.495n 0.0v 2039.505n 0.0v 2049.495n 0.0v 2049.505n 0.0v )
* (time, data): [(0, 0), (10, 1), (20, 1), (30, 0), (40, 0), (50, 0), (60, 0), (70, 0), (80, 0), (90, 0), (100, 0), (110, 1), (120, 1), (130, 1), (140, 1), (150, 1), (160, 1), (170, 1), (180, 1), (190, 1), (200, 1), (210, 1), (220, 1), (230, 1), (240, 0), (250, 0), (260, 0), (270, 0), (280, 0), (290, 0), (300, 0), (310, 1), (320, 1), (330, 1), (340, 0), (350, 0), (360, 0), (370, 0), (380, 0), (390, 0), (400, 0), (410, 1), (420, 1), (430, 0), (440, 0), (450, 0), (460, 0), (470, 0), (480, 0), (490, 0), (500, 0), (510, 0), (520, 0), (530, 0), (540, 0), (550, 0), (560, 0), (570, 0), (580, 0), (590, 0), (600, 0), (610, 0), (620, 0), (630, 0), (640, 0), (650, 1), (660, 1), (670, 1), (680, 1), (690, 1), (700, 1), (710, 1), (720, 1), (730, 1), (740, 1), (750, 0), (760, 1), (770, 0), (780, 0), (790, 0), (800, 0), (810, 0), (820, 0), (830, 0), (840, 0), (850, 0), (860, 0), (870, 0), (880, 0), (890, 0), (900, 0), (910, 1), (920, 1), (930, 1), (940, 1), (950, 1), (960, 1), (970, 1), (980, 1), (990, 0), (1000, 1), (1010, 1), (1020, 1), (1030, 1), (1040, 0), (1050, 0), (1060, 0), (1070, 0), (1080, 0), (1090, 0), (1100, 0), (1110, 0), (1120, 1), (1130, 0), (1140, 0), (1150, 1), (1160, 1), (1170, 1), (1180, 1), (1190, 1), (1200, 1), (1210, 1), (1220, 1), (1230, 0), (1240, 0), (1250, 0), (1260, 0), (1270, 0), (1280, 0), (1290, 0), (1300, 0), (1310, 0), (1320, 0), (1330, 0), (1340, 1), (1350, 0), (1360, 0), (1370, 0), (1380, 0), (1390, 0), (1400, 0), (1410, 0), (1420, 1), (1430, 1), (1440, 1), (1450, 1), (1460, 1), (1470, 1), (1480, 0), (1490, 0), (1500, 0), (1510, 1), (1520, 1), (1530, 0), (1540, 0), (1550, 0), (1560, 0), (1570, 1), (1580, 0), (1590, 0), (1600, 0), (1610, 1), (1620, 1), (1630, 1), (1640, 1), (1650, 1), (1660, 1), (1670, 1), (1680, 0), (1690, 0), (1700, 0), (1710, 0), (1720, 0), (1730, 1), (1740, 1), (1750, 1), (1760, 1), (1770, 1), (1780, 0), (1790, 0), (1800, 0), (1810, 0), (1820, 0), (1830, 0), (1840, 0), (1850, 1), (1860, 1), (1870, 1), (1880, 1), (1890, 1), (1900, 1), (1910, 1), (1920, 1), (1930, 1), (1940, 0), (1950, 1), (1960, 1), (1970, 1), (1980, 1), (1990, 1), (2000, 1), (2010, 1), (2020, 1), (2030, 1), (2040, 1), (2050, 1)]
Vdin0_9  din0_9  0 PWL (0n 0.0v 9.495n 0.0v 9.505n 1.8v 19.495n 1.8v 19.505n 1.8v 29.495n 1.8v 29.505n 0.0v 39.495n 0.0v 39.505n 0.0v 49.495n 0.0v 49.505n 0.0v 59.495n 0.0v 59.505n 0.0v 69.495n 0.0v 69.505n 0.0v 79.495n 0.0v 79.505n 0.0v 89.495n 0.0v 89.505n 0.0v 99.495n 0.0v 99.505n 0.0v 109.495n 0.0v 109.505n 1.8v 119.495n 1.8v 119.505n 1.8v 129.495n 1.8v 129.505n 1.8v 139.495n 1.8v 139.505n 1.8v 149.495n 1.8v 149.505n 1.8v 159.495n 1.8v 159.505n 1.8v 169.495n 1.8v 169.505n 1.8v 179.495n 1.8v 179.505n 1.8v 189.495n 1.8v 189.505n 1.8v 199.495n 1.8v 199.505n 1.8v 209.495n 1.8v 209.505n 1.8v 219.495n 1.8v 219.505n 1.8v 229.495n 1.8v 229.505n 1.8v 239.495n 1.8v 239.505n 0.0v 249.495n 0.0v 249.505n 0.0v 259.495n 0.0v 259.505n 0.0v 269.495n 0.0v 269.505n 0.0v 279.495n 0.0v 279.505n 0.0v 289.495n 0.0v 289.505n 0.0v 299.495n 0.0v 299.505n 0.0v 309.495n 0.0v 309.505n 1.8v 319.495n 1.8v 319.505n 1.8v 329.495n 1.8v 329.505n 1.8v 339.495n 1.8v 339.505n 0.0v 349.495n 0.0v 349.505n 0.0v 359.495n 0.0v 359.505n 0.0v 369.495n 0.0v 369.505n 0.0v 379.495n 0.0v 379.505n 0.0v 389.495n 0.0v 389.505n 0.0v 399.495n 0.0v 399.505n 0.0v 409.495n 0.0v 409.505n 1.8v 419.495n 1.8v 419.505n 1.8v 429.495n 1.8v 429.505n 0.0v 439.495n 0.0v 439.505n 0.0v 449.495n 0.0v 449.505n 0.0v 459.495n 0.0v 459.505n 0.0v 469.495n 0.0v 469.505n 0.0v 479.495n 0.0v 479.505n 0.0v 489.495n 0.0v 489.505n 0.0v 499.495n 0.0v 499.505n 0.0v 509.495n 0.0v 509.505n 0.0v 519.495n 0.0v 519.505n 0.0v 529.495n 0.0v 529.505n 0.0v 539.495n 0.0v 539.505n 0.0v 549.495n 0.0v 549.505n 0.0v 559.495n 0.0v 559.505n 0.0v 569.495n 0.0v 569.505n 0.0v 579.495n 0.0v 579.505n 0.0v 589.495n 0.0v 589.505n 0.0v 599.495n 0.0v 599.505n 0.0v 609.495n 0.0v 609.505n 0.0v 619.495n 0.0v 619.505n 0.0v 629.495n 0.0v 629.505n 0.0v 639.495n 0.0v 639.505n 0.0v 649.495n 0.0v 649.505n 1.8v 659.495n 1.8v 659.505n 1.8v 669.495n 1.8v 669.505n 1.8v 679.495n 1.8v 679.505n 1.8v 689.495n 1.8v 689.505n 1.8v 699.495n 1.8v 699.505n 1.8v 709.495n 1.8v 709.505n 1.8v 719.495n 1.8v 719.505n 1.8v 729.495n 1.8v 729.505n 1.8v 739.495n 1.8v 739.505n 1.8v 749.495n 1.8v 749.505n 0.0v 759.495n 0.0v 759.505n 1.8v 769.495n 1.8v 769.505n 0.0v 779.495n 0.0v 779.505n 0.0v 789.495n 0.0v 789.505n 0.0v 799.495n 0.0v 799.505n 0.0v 809.495n 0.0v 809.505n 0.0v 819.495n 0.0v 819.505n 0.0v 829.495n 0.0v 829.505n 0.0v 839.495n 0.0v 839.505n 0.0v 849.495n 0.0v 849.505n 0.0v 859.495n 0.0v 859.505n 0.0v 869.495n 0.0v 869.505n 0.0v 879.495n 0.0v 879.505n 0.0v 889.495n 0.0v 889.505n 0.0v 899.495n 0.0v 899.505n 0.0v 909.495n 0.0v 909.505n 1.8v 919.495n 1.8v 919.505n 1.8v 929.495n 1.8v 929.505n 1.8v 939.495n 1.8v 939.505n 1.8v 949.495n 1.8v 949.505n 1.8v 959.495n 1.8v 959.505n 1.8v 969.495n 1.8v 969.505n 1.8v 979.495n 1.8v 979.505n 1.8v 989.495n 1.8v 989.505n 0.0v 999.495n 0.0v 999.505n 1.8v 1009.495n 1.8v 1009.505n 1.8v 1019.495n 1.8v 1019.505n 1.8v 1029.495n 1.8v 1029.505n 1.8v 1039.495n 1.8v 1039.505n 0.0v 1049.495n 0.0v 1049.505n 0.0v 1059.495n 0.0v 1059.505n 0.0v 1069.495n 0.0v 1069.505n 0.0v 1079.495n 0.0v 1079.505n 0.0v 1089.495n 0.0v 1089.505n 0.0v 1099.495n 0.0v 1099.505n 0.0v 1109.495n 0.0v 1109.505n 0.0v 1119.495n 0.0v 1119.505n 1.8v 1129.495n 1.8v 1129.505n 0.0v 1139.495n 0.0v 1139.505n 0.0v 1149.495n 0.0v 1149.505n 1.8v 1159.495n 1.8v 1159.505n 1.8v 1169.495n 1.8v 1169.505n 1.8v 1179.495n 1.8v 1179.505n 1.8v 1189.495n 1.8v 1189.505n 1.8v 1199.495n 1.8v 1199.505n 1.8v 1209.495n 1.8v 1209.505n 1.8v 1219.495n 1.8v 1219.505n 1.8v 1229.495n 1.8v 1229.505n 0.0v 1239.495n 0.0v 1239.505n 0.0v 1249.495n 0.0v 1249.505n 0.0v 1259.495n 0.0v 1259.505n 0.0v 1269.495n 0.0v 1269.505n 0.0v 1279.495n 0.0v 1279.505n 0.0v 1289.495n 0.0v 1289.505n 0.0v 1299.495n 0.0v 1299.505n 0.0v 1309.495n 0.0v 1309.505n 0.0v 1319.495n 0.0v 1319.505n 0.0v 1329.495n 0.0v 1329.505n 0.0v 1339.495n 0.0v 1339.505n 1.8v 1349.495n 1.8v 1349.505n 0.0v 1359.495n 0.0v 1359.505n 0.0v 1369.495n 0.0v 1369.505n 0.0v 1379.495n 0.0v 1379.505n 0.0v 1389.495n 0.0v 1389.505n 0.0v 1399.495n 0.0v 1399.505n 0.0v 1409.495n 0.0v 1409.505n 0.0v 1419.495n 0.0v 1419.505n 1.8v 1429.495n 1.8v 1429.505n 1.8v 1439.495n 1.8v 1439.505n 1.8v 1449.495n 1.8v 1449.505n 1.8v 1459.495n 1.8v 1459.505n 1.8v 1469.495n 1.8v 1469.505n 1.8v 1479.495n 1.8v 1479.505n 0.0v 1489.495n 0.0v 1489.505n 0.0v 1499.495n 0.0v 1499.505n 0.0v 1509.495n 0.0v 1509.505n 1.8v 1519.495n 1.8v 1519.505n 1.8v 1529.495n 1.8v 1529.505n 0.0v 1539.495n 0.0v 1539.505n 0.0v 1549.495n 0.0v 1549.505n 0.0v 1559.495n 0.0v 1559.505n 0.0v 1569.495n 0.0v 1569.505n 1.8v 1579.495n 1.8v 1579.505n 0.0v 1589.495n 0.0v 1589.505n 0.0v 1599.495n 0.0v 1599.505n 0.0v 1609.495n 0.0v 1609.505n 1.8v 1619.495n 1.8v 1619.505n 1.8v 1629.495n 1.8v 1629.505n 1.8v 1639.495n 1.8v 1639.505n 1.8v 1649.495n 1.8v 1649.505n 1.8v 1659.495n 1.8v 1659.505n 1.8v 1669.495n 1.8v 1669.505n 1.8v 1679.495n 1.8v 1679.505n 0.0v 1689.495n 0.0v 1689.505n 0.0v 1699.495n 0.0v 1699.505n 0.0v 1709.495n 0.0v 1709.505n 0.0v 1719.495n 0.0v 1719.505n 0.0v 1729.495n 0.0v 1729.505n 1.8v 1739.495n 1.8v 1739.505n 1.8v 1749.495n 1.8v 1749.505n 1.8v 1759.495n 1.8v 1759.505n 1.8v 1769.495n 1.8v 1769.505n 1.8v 1779.495n 1.8v 1779.505n 0.0v 1789.495n 0.0v 1789.505n 0.0v 1799.495n 0.0v 1799.505n 0.0v 1809.495n 0.0v 1809.505n 0.0v 1819.495n 0.0v 1819.505n 0.0v 1829.495n 0.0v 1829.505n 0.0v 1839.495n 0.0v 1839.505n 0.0v 1849.495n 0.0v 1849.505n 1.8v 1859.495n 1.8v 1859.505n 1.8v 1869.495n 1.8v 1869.505n 1.8v 1879.495n 1.8v 1879.505n 1.8v 1889.495n 1.8v 1889.505n 1.8v 1899.495n 1.8v 1899.505n 1.8v 1909.495n 1.8v 1909.505n 1.8v 1919.495n 1.8v 1919.505n 1.8v 1929.495n 1.8v 1929.505n 1.8v 1939.495n 1.8v 1939.505n 0.0v 1949.495n 0.0v 1949.505n 1.8v 1959.495n 1.8v 1959.505n 1.8v 1969.495n 1.8v 1969.505n 1.8v 1979.495n 1.8v 1979.505n 1.8v 1989.495n 1.8v 1989.505n 1.8v 1999.495n 1.8v 1999.505n 1.8v 2009.495n 1.8v 2009.505n 1.8v 2019.495n 1.8v 2019.505n 1.8v 2029.495n 1.8v 2029.505n 1.8v 2039.495n 1.8v 2039.505n 1.8v 2049.495n 1.8v 2049.505n 1.8v )
* (time, data): [(0, 0), (10, 1), (20, 1), (30, 1), (40, 1), (50, 1), (60, 1), (70, 1), (80, 0), (90, 0), (100, 0), (110, 0), (120, 0), (130, 0), (140, 0), (150, 0), (160, 0), (170, 0), (180, 0), (190, 0), (200, 0), (210, 0), (220, 0), (230, 0), (240, 0), (250, 0), (260, 0), (270, 0), (280, 0), (290, 0), (300, 0), (310, 0), (320, 1), (330, 1), (340, 1), (350, 1), (360, 1), (370, 1), (380, 1), (390, 0), (400, 0), (410, 0), (420, 0), (430, 1), (440, 1), (450, 1), (460, 1), (470, 1), (480, 1), (490, 1), (500, 1), (510, 0), (520, 0), (530, 0), (540, 0), (550, 0), (560, 0), (570, 0), (580, 0), (590, 0), (600, 1), (610, 1), (620, 1), (630, 1), (640, 1), (650, 0), (660, 0), (670, 0), (680, 0), (690, 0), (700, 0), (710, 0), (720, 0), (730, 0), (740, 0), (750, 0), (760, 0), (770, 0), (780, 0), (790, 0), (800, 0), (810, 0), (820, 0), (830, 0), (840, 0), (850, 0), (860, 0), (870, 0), (880, 0), (890, 0), (900, 1), (910, 0), (920, 0), (930, 0), (940, 0), (950, 0), (960, 0), (970, 0), (980, 0), (990, 1), (1000, 0), (1010, 0), (1020, 0), (1030, 0), (1040, 1), (1050, 1), (1060, 0), (1070, 0), (1080, 0), (1090, 0), (1100, 0), (1110, 0), (1120, 0), (1130, 1), (1140, 1), (1150, 0), (1160, 0), (1170, 0), (1180, 0), (1190, 0), (1200, 0), (1210, 1), (1220, 0), (1230, 0), (1240, 1), (1250, 0), (1260, 0), (1270, 0), (1280, 0), (1290, 0), (1300, 0), (1310, 0), (1320, 0), (1330, 0), (1340, 0), (1350, 0), (1360, 0), (1370, 0), (1380, 0), (1390, 1), (1400, 1), (1410, 0), (1420, 1), (1430, 1), (1440, 1), (1450, 1), (1460, 1), (1470, 1), (1480, 0), (1490, 0), (1500, 0), (1510, 1), (1520, 1), (1530, 0), (1540, 0), (1550, 0), (1560, 0), (1570, 0), (1580, 1), (1590, 1), (1600, 1), (1610, 0), (1620, 0), (1630, 0), (1640, 0), (1650, 0), (1660, 0), (1670, 0), (1680, 1), (1690, 0), (1700, 0), (1710, 1), (1720, 1), (1730, 1), (1740, 1), (1750, 1), (1760, 1), (1770, 1), (1780, 1), (1790, 1), (1800, 0), (1810, 0), (1820, 0), (1830, 0), (1840, 0), (1850, 0), (1860, 0), (1870, 0), (1880, 0), (1890, 0), (1900, 1), (1910, 1), (1920, 1), (1930, 1), (1940, 1), (1950, 1), (1960, 1), (1970, 1), (1980, 1), (1990, 1), (2000, 1), (2010, 1), (2020, 1), (2030, 1), (2040, 0), (2050, 0)]
Vdin0_10  din0_10  0 PWL (0n 0.0v 9.495n 0.0v 9.505n 1.8v 19.495n 1.8v 19.505n 1.8v 29.495n 1.8v 29.505n 1.8v 39.495n 1.8v 39.505n 1.8v 49.495n 1.8v 49.505n 1.8v 59.495n 1.8v 59.505n 1.8v 69.495n 1.8v 69.505n 1.8v 79.495n 1.8v 79.505n 0.0v 89.495n 0.0v 89.505n 0.0v 99.495n 0.0v 99.505n 0.0v 109.495n 0.0v 109.505n 0.0v 119.495n 0.0v 119.505n 0.0v 129.495n 0.0v 129.505n 0.0v 139.495n 0.0v 139.505n 0.0v 149.495n 0.0v 149.505n 0.0v 159.495n 0.0v 159.505n 0.0v 169.495n 0.0v 169.505n 0.0v 179.495n 0.0v 179.505n 0.0v 189.495n 0.0v 189.505n 0.0v 199.495n 0.0v 199.505n 0.0v 209.495n 0.0v 209.505n 0.0v 219.495n 0.0v 219.505n 0.0v 229.495n 0.0v 229.505n 0.0v 239.495n 0.0v 239.505n 0.0v 249.495n 0.0v 249.505n 0.0v 259.495n 0.0v 259.505n 0.0v 269.495n 0.0v 269.505n 0.0v 279.495n 0.0v 279.505n 0.0v 289.495n 0.0v 289.505n 0.0v 299.495n 0.0v 299.505n 0.0v 309.495n 0.0v 309.505n 0.0v 319.495n 0.0v 319.505n 1.8v 329.495n 1.8v 329.505n 1.8v 339.495n 1.8v 339.505n 1.8v 349.495n 1.8v 349.505n 1.8v 359.495n 1.8v 359.505n 1.8v 369.495n 1.8v 369.505n 1.8v 379.495n 1.8v 379.505n 1.8v 389.495n 1.8v 389.505n 0.0v 399.495n 0.0v 399.505n 0.0v 409.495n 0.0v 409.505n 0.0v 419.495n 0.0v 419.505n 0.0v 429.495n 0.0v 429.505n 1.8v 439.495n 1.8v 439.505n 1.8v 449.495n 1.8v 449.505n 1.8v 459.495n 1.8v 459.505n 1.8v 469.495n 1.8v 469.505n 1.8v 479.495n 1.8v 479.505n 1.8v 489.495n 1.8v 489.505n 1.8v 499.495n 1.8v 499.505n 1.8v 509.495n 1.8v 509.505n 0.0v 519.495n 0.0v 519.505n 0.0v 529.495n 0.0v 529.505n 0.0v 539.495n 0.0v 539.505n 0.0v 549.495n 0.0v 549.505n 0.0v 559.495n 0.0v 559.505n 0.0v 569.495n 0.0v 569.505n 0.0v 579.495n 0.0v 579.505n 0.0v 589.495n 0.0v 589.505n 0.0v 599.495n 0.0v 599.505n 1.8v 609.495n 1.8v 609.505n 1.8v 619.495n 1.8v 619.505n 1.8v 629.495n 1.8v 629.505n 1.8v 639.495n 1.8v 639.505n 1.8v 649.495n 1.8v 649.505n 0.0v 659.495n 0.0v 659.505n 0.0v 669.495n 0.0v 669.505n 0.0v 679.495n 0.0v 679.505n 0.0v 689.495n 0.0v 689.505n 0.0v 699.495n 0.0v 699.505n 0.0v 709.495n 0.0v 709.505n 0.0v 719.495n 0.0v 719.505n 0.0v 729.495n 0.0v 729.505n 0.0v 739.495n 0.0v 739.505n 0.0v 749.495n 0.0v 749.505n 0.0v 759.495n 0.0v 759.505n 0.0v 769.495n 0.0v 769.505n 0.0v 779.495n 0.0v 779.505n 0.0v 789.495n 0.0v 789.505n 0.0v 799.495n 0.0v 799.505n 0.0v 809.495n 0.0v 809.505n 0.0v 819.495n 0.0v 819.505n 0.0v 829.495n 0.0v 829.505n 0.0v 839.495n 0.0v 839.505n 0.0v 849.495n 0.0v 849.505n 0.0v 859.495n 0.0v 859.505n 0.0v 869.495n 0.0v 869.505n 0.0v 879.495n 0.0v 879.505n 0.0v 889.495n 0.0v 889.505n 0.0v 899.495n 0.0v 899.505n 1.8v 909.495n 1.8v 909.505n 0.0v 919.495n 0.0v 919.505n 0.0v 929.495n 0.0v 929.505n 0.0v 939.495n 0.0v 939.505n 0.0v 949.495n 0.0v 949.505n 0.0v 959.495n 0.0v 959.505n 0.0v 969.495n 0.0v 969.505n 0.0v 979.495n 0.0v 979.505n 0.0v 989.495n 0.0v 989.505n 1.8v 999.495n 1.8v 999.505n 0.0v 1009.495n 0.0v 1009.505n 0.0v 1019.495n 0.0v 1019.505n 0.0v 1029.495n 0.0v 1029.505n 0.0v 1039.495n 0.0v 1039.505n 1.8v 1049.495n 1.8v 1049.505n 1.8v 1059.495n 1.8v 1059.505n 0.0v 1069.495n 0.0v 1069.505n 0.0v 1079.495n 0.0v 1079.505n 0.0v 1089.495n 0.0v 1089.505n 0.0v 1099.495n 0.0v 1099.505n 0.0v 1109.495n 0.0v 1109.505n 0.0v 1119.495n 0.0v 1119.505n 0.0v 1129.495n 0.0v 1129.505n 1.8v 1139.495n 1.8v 1139.505n 1.8v 1149.495n 1.8v 1149.505n 0.0v 1159.495n 0.0v 1159.505n 0.0v 1169.495n 0.0v 1169.505n 0.0v 1179.495n 0.0v 1179.505n 0.0v 1189.495n 0.0v 1189.505n 0.0v 1199.495n 0.0v 1199.505n 0.0v 1209.495n 0.0v 1209.505n 1.8v 1219.495n 1.8v 1219.505n 0.0v 1229.495n 0.0v 1229.505n 0.0v 1239.495n 0.0v 1239.505n 1.8v 1249.495n 1.8v 1249.505n 0.0v 1259.495n 0.0v 1259.505n 0.0v 1269.495n 0.0v 1269.505n 0.0v 1279.495n 0.0v 1279.505n 0.0v 1289.495n 0.0v 1289.505n 0.0v 1299.495n 0.0v 1299.505n 0.0v 1309.495n 0.0v 1309.505n 0.0v 1319.495n 0.0v 1319.505n 0.0v 1329.495n 0.0v 1329.505n 0.0v 1339.495n 0.0v 1339.505n 0.0v 1349.495n 0.0v 1349.505n 0.0v 1359.495n 0.0v 1359.505n 0.0v 1369.495n 0.0v 1369.505n 0.0v 1379.495n 0.0v 1379.505n 0.0v 1389.495n 0.0v 1389.505n 1.8v 1399.495n 1.8v 1399.505n 1.8v 1409.495n 1.8v 1409.505n 0.0v 1419.495n 0.0v 1419.505n 1.8v 1429.495n 1.8v 1429.505n 1.8v 1439.495n 1.8v 1439.505n 1.8v 1449.495n 1.8v 1449.505n 1.8v 1459.495n 1.8v 1459.505n 1.8v 1469.495n 1.8v 1469.505n 1.8v 1479.495n 1.8v 1479.505n 0.0v 1489.495n 0.0v 1489.505n 0.0v 1499.495n 0.0v 1499.505n 0.0v 1509.495n 0.0v 1509.505n 1.8v 1519.495n 1.8v 1519.505n 1.8v 1529.495n 1.8v 1529.505n 0.0v 1539.495n 0.0v 1539.505n 0.0v 1549.495n 0.0v 1549.505n 0.0v 1559.495n 0.0v 1559.505n 0.0v 1569.495n 0.0v 1569.505n 0.0v 1579.495n 0.0v 1579.505n 1.8v 1589.495n 1.8v 1589.505n 1.8v 1599.495n 1.8v 1599.505n 1.8v 1609.495n 1.8v 1609.505n 0.0v 1619.495n 0.0v 1619.505n 0.0v 1629.495n 0.0v 1629.505n 0.0v 1639.495n 0.0v 1639.505n 0.0v 1649.495n 0.0v 1649.505n 0.0v 1659.495n 0.0v 1659.505n 0.0v 1669.495n 0.0v 1669.505n 0.0v 1679.495n 0.0v 1679.505n 1.8v 1689.495n 1.8v 1689.505n 0.0v 1699.495n 0.0v 1699.505n 0.0v 1709.495n 0.0v 1709.505n 1.8v 1719.495n 1.8v 1719.505n 1.8v 1729.495n 1.8v 1729.505n 1.8v 1739.495n 1.8v 1739.505n 1.8v 1749.495n 1.8v 1749.505n 1.8v 1759.495n 1.8v 1759.505n 1.8v 1769.495n 1.8v 1769.505n 1.8v 1779.495n 1.8v 1779.505n 1.8v 1789.495n 1.8v 1789.505n 1.8v 1799.495n 1.8v 1799.505n 0.0v 1809.495n 0.0v 1809.505n 0.0v 1819.495n 0.0v 1819.505n 0.0v 1829.495n 0.0v 1829.505n 0.0v 1839.495n 0.0v 1839.505n 0.0v 1849.495n 0.0v 1849.505n 0.0v 1859.495n 0.0v 1859.505n 0.0v 1869.495n 0.0v 1869.505n 0.0v 1879.495n 0.0v 1879.505n 0.0v 1889.495n 0.0v 1889.505n 0.0v 1899.495n 0.0v 1899.505n 1.8v 1909.495n 1.8v 1909.505n 1.8v 1919.495n 1.8v 1919.505n 1.8v 1929.495n 1.8v 1929.505n 1.8v 1939.495n 1.8v 1939.505n 1.8v 1949.495n 1.8v 1949.505n 1.8v 1959.495n 1.8v 1959.505n 1.8v 1969.495n 1.8v 1969.505n 1.8v 1979.495n 1.8v 1979.505n 1.8v 1989.495n 1.8v 1989.505n 1.8v 1999.495n 1.8v 1999.505n 1.8v 2009.495n 1.8v 2009.505n 1.8v 2019.495n 1.8v 2019.505n 1.8v 2029.495n 1.8v 2029.505n 1.8v 2039.495n 1.8v 2039.505n 0.0v 2049.495n 0.0v 2049.505n 0.0v )
* (time, data): [(0, 0), (10, 0), (20, 0), (30, 1), (40, 1), (50, 1), (60, 1), (70, 1), (80, 1), (90, 1), (100, 1), (110, 0), (120, 0), (130, 0), (140, 0), (150, 0), (160, 0), (170, 1), (180, 1), (190, 1), (200, 0), (210, 0), (220, 0), (230, 0), (240, 0), (250, 0), (260, 0), (270, 0), (280, 0), (290, 0), (300, 0), (310, 0), (320, 0), (330, 0), (340, 1), (350, 1), (360, 1), (370, 1), (380, 1), (390, 1), (400, 0), (410, 1), (420, 1), (430, 1), (440, 1), (450, 1), (460, 1), (470, 1), (480, 1), (490, 1), (500, 1), (510, 0), (520, 0), (530, 1), (540, 1), (550, 1), (560, 1), (570, 1), (580, 1), (590, 1), (600, 1), (610, 1), (620, 0), (630, 0), (640, 0), (650, 1), (660, 1), (670, 0), (680, 0), (690, 0), (700, 0), (710, 0), (720, 0), (730, 0), (740, 0), (750, 1), (760, 1), (770, 1), (780, 1), (790, 1), (800, 1), (810, 1), (820, 1), (830, 1), (840, 1), (850, 1), (860, 1), (870, 1), (880, 1), (890, 1), (900, 1), (910, 1), (920, 0), (930, 0), (940, 0), (950, 0), (960, 0), (970, 0), (980, 0), (990, 1), (1000, 1), (1010, 1), (1020, 1), (1030, 1), (1040, 0), (1050, 0), (1060, 1), (1070, 1), (1080, 1), (1090, 1), (1100, 0), (1110, 0), (1120, 1), (1130, 0), (1140, 0), (1150, 0), (1160, 0), (1170, 0), (1180, 0), (1190, 0), (1200, 0), (1210, 0), (1220, 1), (1230, 0), (1240, 0), (1250, 1), (1260, 1), (1270, 1), (1280, 1), (1290, 1), (1300, 1), (1310, 1), (1320, 1), (1330, 1), (1340, 1), (1350, 1), (1360, 1), (1370, 1), (1380, 1), (1390, 1), (1400, 1), (1410, 1), (1420, 0), (1430, 0), (1440, 0), (1450, 0), (1460, 0), (1470, 0), (1480, 1), (1490, 1), (1500, 1), (1510, 0), (1520, 0), (1530, 1), (1540, 1), (1550, 1), (1560, 1), (1570, 1), (1580, 1), (1590, 0), (1600, 0), (1610, 0), (1620, 0), (1630, 0), (1640, 0), (1650, 0), (1660, 1), (1670, 1), (1680, 0), (1690, 0), (1700, 0), (1710, 0), (1720, 0), (1730, 1), (1740, 1), (1750, 1), (1760, 1), (1770, 1), (1780, 0), (1790, 0), (1800, 1), (1810, 1), (1820, 1), (1830, 1), (1840, 1), (1850, 1), (1860, 1), (1870, 1), (1880, 1), (1890, 1), (1900, 0), (1910, 0), (1920, 0), (1930, 0), (1940, 1), (1950, 1), (1960, 1), (1970, 1), (1980, 1), (1990, 0), (2000, 0), (2010, 0), (2020, 0), (2030, 0), (2040, 1), (2050, 1)]
Vdin0_11  din0_11  0 PWL (0n 0.0v 9.495n 0.0v 9.505n 0.0v 19.495n 0.0v 19.505n 0.0v 29.495n 0.0v 29.505n 1.8v 39.495n 1.8v 39.505n 1.8v 49.495n 1.8v 49.505n 1.8v 59.495n 1.8v 59.505n 1.8v 69.495n 1.8v 69.505n 1.8v 79.495n 1.8v 79.505n 1.8v 89.495n 1.8v 89.505n 1.8v 99.495n 1.8v 99.505n 1.8v 109.495n 1.8v 109.505n 0.0v 119.495n 0.0v 119.505n 0.0v 129.495n 0.0v 129.505n 0.0v 139.495n 0.0v 139.505n 0.0v 149.495n 0.0v 149.505n 0.0v 159.495n 0.0v 159.505n 0.0v 169.495n 0.0v 169.505n 1.8v 179.495n 1.8v 179.505n 1.8v 189.495n 1.8v 189.505n 1.8v 199.495n 1.8v 199.505n 0.0v 209.495n 0.0v 209.505n 0.0v 219.495n 0.0v 219.505n 0.0v 229.495n 0.0v 229.505n 0.0v 239.495n 0.0v 239.505n 0.0v 249.495n 0.0v 249.505n 0.0v 259.495n 0.0v 259.505n 0.0v 269.495n 0.0v 269.505n 0.0v 279.495n 0.0v 279.505n 0.0v 289.495n 0.0v 289.505n 0.0v 299.495n 0.0v 299.505n 0.0v 309.495n 0.0v 309.505n 0.0v 319.495n 0.0v 319.505n 0.0v 329.495n 0.0v 329.505n 0.0v 339.495n 0.0v 339.505n 1.8v 349.495n 1.8v 349.505n 1.8v 359.495n 1.8v 359.505n 1.8v 369.495n 1.8v 369.505n 1.8v 379.495n 1.8v 379.505n 1.8v 389.495n 1.8v 389.505n 1.8v 399.495n 1.8v 399.505n 0.0v 409.495n 0.0v 409.505n 1.8v 419.495n 1.8v 419.505n 1.8v 429.495n 1.8v 429.505n 1.8v 439.495n 1.8v 439.505n 1.8v 449.495n 1.8v 449.505n 1.8v 459.495n 1.8v 459.505n 1.8v 469.495n 1.8v 469.505n 1.8v 479.495n 1.8v 479.505n 1.8v 489.495n 1.8v 489.505n 1.8v 499.495n 1.8v 499.505n 1.8v 509.495n 1.8v 509.505n 0.0v 519.495n 0.0v 519.505n 0.0v 529.495n 0.0v 529.505n 1.8v 539.495n 1.8v 539.505n 1.8v 549.495n 1.8v 549.505n 1.8v 559.495n 1.8v 559.505n 1.8v 569.495n 1.8v 569.505n 1.8v 579.495n 1.8v 579.505n 1.8v 589.495n 1.8v 589.505n 1.8v 599.495n 1.8v 599.505n 1.8v 609.495n 1.8v 609.505n 1.8v 619.495n 1.8v 619.505n 0.0v 629.495n 0.0v 629.505n 0.0v 639.495n 0.0v 639.505n 0.0v 649.495n 0.0v 649.505n 1.8v 659.495n 1.8v 659.505n 1.8v 669.495n 1.8v 669.505n 0.0v 679.495n 0.0v 679.505n 0.0v 689.495n 0.0v 689.505n 0.0v 699.495n 0.0v 699.505n 0.0v 709.495n 0.0v 709.505n 0.0v 719.495n 0.0v 719.505n 0.0v 729.495n 0.0v 729.505n 0.0v 739.495n 0.0v 739.505n 0.0v 749.495n 0.0v 749.505n 1.8v 759.495n 1.8v 759.505n 1.8v 769.495n 1.8v 769.505n 1.8v 779.495n 1.8v 779.505n 1.8v 789.495n 1.8v 789.505n 1.8v 799.495n 1.8v 799.505n 1.8v 809.495n 1.8v 809.505n 1.8v 819.495n 1.8v 819.505n 1.8v 829.495n 1.8v 829.505n 1.8v 839.495n 1.8v 839.505n 1.8v 849.495n 1.8v 849.505n 1.8v 859.495n 1.8v 859.505n 1.8v 869.495n 1.8v 869.505n 1.8v 879.495n 1.8v 879.505n 1.8v 889.495n 1.8v 889.505n 1.8v 899.495n 1.8v 899.505n 1.8v 909.495n 1.8v 909.505n 1.8v 919.495n 1.8v 919.505n 0.0v 929.495n 0.0v 929.505n 0.0v 939.495n 0.0v 939.505n 0.0v 949.495n 0.0v 949.505n 0.0v 959.495n 0.0v 959.505n 0.0v 969.495n 0.0v 969.505n 0.0v 979.495n 0.0v 979.505n 0.0v 989.495n 0.0v 989.505n 1.8v 999.495n 1.8v 999.505n 1.8v 1009.495n 1.8v 1009.505n 1.8v 1019.495n 1.8v 1019.505n 1.8v 1029.495n 1.8v 1029.505n 1.8v 1039.495n 1.8v 1039.505n 0.0v 1049.495n 0.0v 1049.505n 0.0v 1059.495n 0.0v 1059.505n 1.8v 1069.495n 1.8v 1069.505n 1.8v 1079.495n 1.8v 1079.505n 1.8v 1089.495n 1.8v 1089.505n 1.8v 1099.495n 1.8v 1099.505n 0.0v 1109.495n 0.0v 1109.505n 0.0v 1119.495n 0.0v 1119.505n 1.8v 1129.495n 1.8v 1129.505n 0.0v 1139.495n 0.0v 1139.505n 0.0v 1149.495n 0.0v 1149.505n 0.0v 1159.495n 0.0v 1159.505n 0.0v 1169.495n 0.0v 1169.505n 0.0v 1179.495n 0.0v 1179.505n 0.0v 1189.495n 0.0v 1189.505n 0.0v 1199.495n 0.0v 1199.505n 0.0v 1209.495n 0.0v 1209.505n 0.0v 1219.495n 0.0v 1219.505n 1.8v 1229.495n 1.8v 1229.505n 0.0v 1239.495n 0.0v 1239.505n 0.0v 1249.495n 0.0v 1249.505n 1.8v 1259.495n 1.8v 1259.505n 1.8v 1269.495n 1.8v 1269.505n 1.8v 1279.495n 1.8v 1279.505n 1.8v 1289.495n 1.8v 1289.505n 1.8v 1299.495n 1.8v 1299.505n 1.8v 1309.495n 1.8v 1309.505n 1.8v 1319.495n 1.8v 1319.505n 1.8v 1329.495n 1.8v 1329.505n 1.8v 1339.495n 1.8v 1339.505n 1.8v 1349.495n 1.8v 1349.505n 1.8v 1359.495n 1.8v 1359.505n 1.8v 1369.495n 1.8v 1369.505n 1.8v 1379.495n 1.8v 1379.505n 1.8v 1389.495n 1.8v 1389.505n 1.8v 1399.495n 1.8v 1399.505n 1.8v 1409.495n 1.8v 1409.505n 1.8v 1419.495n 1.8v 1419.505n 0.0v 1429.495n 0.0v 1429.505n 0.0v 1439.495n 0.0v 1439.505n 0.0v 1449.495n 0.0v 1449.505n 0.0v 1459.495n 0.0v 1459.505n 0.0v 1469.495n 0.0v 1469.505n 0.0v 1479.495n 0.0v 1479.505n 1.8v 1489.495n 1.8v 1489.505n 1.8v 1499.495n 1.8v 1499.505n 1.8v 1509.495n 1.8v 1509.505n 0.0v 1519.495n 0.0v 1519.505n 0.0v 1529.495n 0.0v 1529.505n 1.8v 1539.495n 1.8v 1539.505n 1.8v 1549.495n 1.8v 1549.505n 1.8v 1559.495n 1.8v 1559.505n 1.8v 1569.495n 1.8v 1569.505n 1.8v 1579.495n 1.8v 1579.505n 1.8v 1589.495n 1.8v 1589.505n 0.0v 1599.495n 0.0v 1599.505n 0.0v 1609.495n 0.0v 1609.505n 0.0v 1619.495n 0.0v 1619.505n 0.0v 1629.495n 0.0v 1629.505n 0.0v 1639.495n 0.0v 1639.505n 0.0v 1649.495n 0.0v 1649.505n 0.0v 1659.495n 0.0v 1659.505n 1.8v 1669.495n 1.8v 1669.505n 1.8v 1679.495n 1.8v 1679.505n 0.0v 1689.495n 0.0v 1689.505n 0.0v 1699.495n 0.0v 1699.505n 0.0v 1709.495n 0.0v 1709.505n 0.0v 1719.495n 0.0v 1719.505n 0.0v 1729.495n 0.0v 1729.505n 1.8v 1739.495n 1.8v 1739.505n 1.8v 1749.495n 1.8v 1749.505n 1.8v 1759.495n 1.8v 1759.505n 1.8v 1769.495n 1.8v 1769.505n 1.8v 1779.495n 1.8v 1779.505n 0.0v 1789.495n 0.0v 1789.505n 0.0v 1799.495n 0.0v 1799.505n 1.8v 1809.495n 1.8v 1809.505n 1.8v 1819.495n 1.8v 1819.505n 1.8v 1829.495n 1.8v 1829.505n 1.8v 1839.495n 1.8v 1839.505n 1.8v 1849.495n 1.8v 1849.505n 1.8v 1859.495n 1.8v 1859.505n 1.8v 1869.495n 1.8v 1869.505n 1.8v 1879.495n 1.8v 1879.505n 1.8v 1889.495n 1.8v 1889.505n 1.8v 1899.495n 1.8v 1899.505n 0.0v 1909.495n 0.0v 1909.505n 0.0v 1919.495n 0.0v 1919.505n 0.0v 1929.495n 0.0v 1929.505n 0.0v 1939.495n 0.0v 1939.505n 1.8v 1949.495n 1.8v 1949.505n 1.8v 1959.495n 1.8v 1959.505n 1.8v 1969.495n 1.8v 1969.505n 1.8v 1979.495n 1.8v 1979.505n 1.8v 1989.495n 1.8v 1989.505n 0.0v 1999.495n 0.0v 1999.505n 0.0v 2009.495n 0.0v 2009.505n 0.0v 2019.495n 0.0v 2019.505n 0.0v 2029.495n 0.0v 2029.505n 0.0v 2039.495n 0.0v 2039.505n 1.8v 2049.495n 1.8v 2049.505n 1.8v )
* (time, data): [(0, 0), (10, 0), (20, 1), (30, 0), (40, 0), (50, 0), (60, 0), (70, 0), (80, 1), (90, 1), (100, 1), (110, 0), (120, 0), (130, 0), (140, 0), (150, 0), (160, 0), (170, 1), (180, 1), (190, 1), (200, 0), (210, 0), (220, 0), (230, 0), (240, 1), (250, 1), (260, 1), (270, 0), (280, 0), (290, 0), (300, 0), (310, 1), (320, 1), (330, 1), (340, 1), (350, 1), (360, 1), (370, 1), (380, 1), (390, 1), (400, 1), (410, 0), (420, 0), (430, 1), (440, 1), (450, 1), (460, 1), (470, 1), (480, 1), (490, 1), (500, 1), (510, 0), (520, 0), (530, 1), (540, 1), (550, 1), (560, 1), (570, 1), (580, 1), (590, 1), (600, 1), (610, 1), (620, 0), (630, 0), (640, 0), (650, 0), (660, 0), (670, 0), (680, 0), (690, 0), (700, 0), (710, 0), (720, 0), (730, 0), (740, 0), (750, 1), (760, 1), (770, 1), (780, 1), (790, 1), (800, 1), (810, 1), (820, 1), (830, 1), (840, 1), (850, 1), (860, 0), (870, 0), (880, 0), (890, 0), (900, 1), (910, 0), (920, 1), (930, 1), (940, 1), (950, 1), (960, 1), (970, 1), (980, 1), (990, 0), (1000, 0), (1010, 0), (1020, 0), (1030, 0), (1040, 0), (1050, 0), (1060, 0), (1070, 0), (1080, 0), (1090, 0), (1100, 0), (1110, 0), (1120, 0), (1130, 0), (1140, 0), (1150, 0), (1160, 0), (1170, 0), (1180, 0), (1190, 0), (1200, 0), (1210, 0), (1220, 1), (1230, 0), (1240, 1), (1250, 0), (1260, 0), (1270, 0), (1280, 0), (1290, 0), (1300, 0), (1310, 0), (1320, 0), (1330, 0), (1340, 0), (1350, 0), (1360, 0), (1370, 0), (1380, 0), (1390, 0), (1400, 0), (1410, 1), (1420, 0), (1430, 0), (1440, 0), (1450, 0), (1460, 0), (1470, 0), (1480, 1), (1490, 1), (1500, 1), (1510, 1), (1520, 1), (1530, 1), (1540, 1), (1550, 1), (1560, 1), (1570, 1), (1580, 1), (1590, 0), (1600, 0), (1610, 0), (1620, 0), (1630, 0), (1640, 0), (1650, 0), (1660, 0), (1670, 0), (1680, 1), (1690, 0), (1700, 0), (1710, 0), (1720, 0), (1730, 1), (1740, 1), (1750, 1), (1760, 1), (1770, 1), (1780, 1), (1790, 1), (1800, 1), (1810, 1), (1820, 1), (1830, 1), (1840, 1), (1850, 0), (1860, 0), (1870, 0), (1880, 0), (1890, 0), (1900, 0), (1910, 0), (1920, 0), (1930, 0), (1940, 1), (1950, 0), (1960, 0), (1970, 0), (1980, 0), (1990, 0), (2000, 0), (2010, 0), (2020, 0), (2030, 0), (2040, 1), (2050, 1)]
Vdin0_12  din0_12  0 PWL (0n 0.0v 9.495n 0.0v 9.505n 0.0v 19.495n 0.0v 19.505n 1.8v 29.495n 1.8v 29.505n 0.0v 39.495n 0.0v 39.505n 0.0v 49.495n 0.0v 49.505n 0.0v 59.495n 0.0v 59.505n 0.0v 69.495n 0.0v 69.505n 0.0v 79.495n 0.0v 79.505n 1.8v 89.495n 1.8v 89.505n 1.8v 99.495n 1.8v 99.505n 1.8v 109.495n 1.8v 109.505n 0.0v 119.495n 0.0v 119.505n 0.0v 129.495n 0.0v 129.505n 0.0v 139.495n 0.0v 139.505n 0.0v 149.495n 0.0v 149.505n 0.0v 159.495n 0.0v 159.505n 0.0v 169.495n 0.0v 169.505n 1.8v 179.495n 1.8v 179.505n 1.8v 189.495n 1.8v 189.505n 1.8v 199.495n 1.8v 199.505n 0.0v 209.495n 0.0v 209.505n 0.0v 219.495n 0.0v 219.505n 0.0v 229.495n 0.0v 229.505n 0.0v 239.495n 0.0v 239.505n 1.8v 249.495n 1.8v 249.505n 1.8v 259.495n 1.8v 259.505n 1.8v 269.495n 1.8v 269.505n 0.0v 279.495n 0.0v 279.505n 0.0v 289.495n 0.0v 289.505n 0.0v 299.495n 0.0v 299.505n 0.0v 309.495n 0.0v 309.505n 1.8v 319.495n 1.8v 319.505n 1.8v 329.495n 1.8v 329.505n 1.8v 339.495n 1.8v 339.505n 1.8v 349.495n 1.8v 349.505n 1.8v 359.495n 1.8v 359.505n 1.8v 369.495n 1.8v 369.505n 1.8v 379.495n 1.8v 379.505n 1.8v 389.495n 1.8v 389.505n 1.8v 399.495n 1.8v 399.505n 1.8v 409.495n 1.8v 409.505n 0.0v 419.495n 0.0v 419.505n 0.0v 429.495n 0.0v 429.505n 1.8v 439.495n 1.8v 439.505n 1.8v 449.495n 1.8v 449.505n 1.8v 459.495n 1.8v 459.505n 1.8v 469.495n 1.8v 469.505n 1.8v 479.495n 1.8v 479.505n 1.8v 489.495n 1.8v 489.505n 1.8v 499.495n 1.8v 499.505n 1.8v 509.495n 1.8v 509.505n 0.0v 519.495n 0.0v 519.505n 0.0v 529.495n 0.0v 529.505n 1.8v 539.495n 1.8v 539.505n 1.8v 549.495n 1.8v 549.505n 1.8v 559.495n 1.8v 559.505n 1.8v 569.495n 1.8v 569.505n 1.8v 579.495n 1.8v 579.505n 1.8v 589.495n 1.8v 589.505n 1.8v 599.495n 1.8v 599.505n 1.8v 609.495n 1.8v 609.505n 1.8v 619.495n 1.8v 619.505n 0.0v 629.495n 0.0v 629.505n 0.0v 639.495n 0.0v 639.505n 0.0v 649.495n 0.0v 649.505n 0.0v 659.495n 0.0v 659.505n 0.0v 669.495n 0.0v 669.505n 0.0v 679.495n 0.0v 679.505n 0.0v 689.495n 0.0v 689.505n 0.0v 699.495n 0.0v 699.505n 0.0v 709.495n 0.0v 709.505n 0.0v 719.495n 0.0v 719.505n 0.0v 729.495n 0.0v 729.505n 0.0v 739.495n 0.0v 739.505n 0.0v 749.495n 0.0v 749.505n 1.8v 759.495n 1.8v 759.505n 1.8v 769.495n 1.8v 769.505n 1.8v 779.495n 1.8v 779.505n 1.8v 789.495n 1.8v 789.505n 1.8v 799.495n 1.8v 799.505n 1.8v 809.495n 1.8v 809.505n 1.8v 819.495n 1.8v 819.505n 1.8v 829.495n 1.8v 829.505n 1.8v 839.495n 1.8v 839.505n 1.8v 849.495n 1.8v 849.505n 1.8v 859.495n 1.8v 859.505n 0.0v 869.495n 0.0v 869.505n 0.0v 879.495n 0.0v 879.505n 0.0v 889.495n 0.0v 889.505n 0.0v 899.495n 0.0v 899.505n 1.8v 909.495n 1.8v 909.505n 0.0v 919.495n 0.0v 919.505n 1.8v 929.495n 1.8v 929.505n 1.8v 939.495n 1.8v 939.505n 1.8v 949.495n 1.8v 949.505n 1.8v 959.495n 1.8v 959.505n 1.8v 969.495n 1.8v 969.505n 1.8v 979.495n 1.8v 979.505n 1.8v 989.495n 1.8v 989.505n 0.0v 999.495n 0.0v 999.505n 0.0v 1009.495n 0.0v 1009.505n 0.0v 1019.495n 0.0v 1019.505n 0.0v 1029.495n 0.0v 1029.505n 0.0v 1039.495n 0.0v 1039.505n 0.0v 1049.495n 0.0v 1049.505n 0.0v 1059.495n 0.0v 1059.505n 0.0v 1069.495n 0.0v 1069.505n 0.0v 1079.495n 0.0v 1079.505n 0.0v 1089.495n 0.0v 1089.505n 0.0v 1099.495n 0.0v 1099.505n 0.0v 1109.495n 0.0v 1109.505n 0.0v 1119.495n 0.0v 1119.505n 0.0v 1129.495n 0.0v 1129.505n 0.0v 1139.495n 0.0v 1139.505n 0.0v 1149.495n 0.0v 1149.505n 0.0v 1159.495n 0.0v 1159.505n 0.0v 1169.495n 0.0v 1169.505n 0.0v 1179.495n 0.0v 1179.505n 0.0v 1189.495n 0.0v 1189.505n 0.0v 1199.495n 0.0v 1199.505n 0.0v 1209.495n 0.0v 1209.505n 0.0v 1219.495n 0.0v 1219.505n 1.8v 1229.495n 1.8v 1229.505n 0.0v 1239.495n 0.0v 1239.505n 1.8v 1249.495n 1.8v 1249.505n 0.0v 1259.495n 0.0v 1259.505n 0.0v 1269.495n 0.0v 1269.505n 0.0v 1279.495n 0.0v 1279.505n 0.0v 1289.495n 0.0v 1289.505n 0.0v 1299.495n 0.0v 1299.505n 0.0v 1309.495n 0.0v 1309.505n 0.0v 1319.495n 0.0v 1319.505n 0.0v 1329.495n 0.0v 1329.505n 0.0v 1339.495n 0.0v 1339.505n 0.0v 1349.495n 0.0v 1349.505n 0.0v 1359.495n 0.0v 1359.505n 0.0v 1369.495n 0.0v 1369.505n 0.0v 1379.495n 0.0v 1379.505n 0.0v 1389.495n 0.0v 1389.505n 0.0v 1399.495n 0.0v 1399.505n 0.0v 1409.495n 0.0v 1409.505n 1.8v 1419.495n 1.8v 1419.505n 0.0v 1429.495n 0.0v 1429.505n 0.0v 1439.495n 0.0v 1439.505n 0.0v 1449.495n 0.0v 1449.505n 0.0v 1459.495n 0.0v 1459.505n 0.0v 1469.495n 0.0v 1469.505n 0.0v 1479.495n 0.0v 1479.505n 1.8v 1489.495n 1.8v 1489.505n 1.8v 1499.495n 1.8v 1499.505n 1.8v 1509.495n 1.8v 1509.505n 1.8v 1519.495n 1.8v 1519.505n 1.8v 1529.495n 1.8v 1529.505n 1.8v 1539.495n 1.8v 1539.505n 1.8v 1549.495n 1.8v 1549.505n 1.8v 1559.495n 1.8v 1559.505n 1.8v 1569.495n 1.8v 1569.505n 1.8v 1579.495n 1.8v 1579.505n 1.8v 1589.495n 1.8v 1589.505n 0.0v 1599.495n 0.0v 1599.505n 0.0v 1609.495n 0.0v 1609.505n 0.0v 1619.495n 0.0v 1619.505n 0.0v 1629.495n 0.0v 1629.505n 0.0v 1639.495n 0.0v 1639.505n 0.0v 1649.495n 0.0v 1649.505n 0.0v 1659.495n 0.0v 1659.505n 0.0v 1669.495n 0.0v 1669.505n 0.0v 1679.495n 0.0v 1679.505n 1.8v 1689.495n 1.8v 1689.505n 0.0v 1699.495n 0.0v 1699.505n 0.0v 1709.495n 0.0v 1709.505n 0.0v 1719.495n 0.0v 1719.505n 0.0v 1729.495n 0.0v 1729.505n 1.8v 1739.495n 1.8v 1739.505n 1.8v 1749.495n 1.8v 1749.505n 1.8v 1759.495n 1.8v 1759.505n 1.8v 1769.495n 1.8v 1769.505n 1.8v 1779.495n 1.8v 1779.505n 1.8v 1789.495n 1.8v 1789.505n 1.8v 1799.495n 1.8v 1799.505n 1.8v 1809.495n 1.8v 1809.505n 1.8v 1819.495n 1.8v 1819.505n 1.8v 1829.495n 1.8v 1829.505n 1.8v 1839.495n 1.8v 1839.505n 1.8v 1849.495n 1.8v 1849.505n 0.0v 1859.495n 0.0v 1859.505n 0.0v 1869.495n 0.0v 1869.505n 0.0v 1879.495n 0.0v 1879.505n 0.0v 1889.495n 0.0v 1889.505n 0.0v 1899.495n 0.0v 1899.505n 0.0v 1909.495n 0.0v 1909.505n 0.0v 1919.495n 0.0v 1919.505n 0.0v 1929.495n 0.0v 1929.505n 0.0v 1939.495n 0.0v 1939.505n 1.8v 1949.495n 1.8v 1949.505n 0.0v 1959.495n 0.0v 1959.505n 0.0v 1969.495n 0.0v 1969.505n 0.0v 1979.495n 0.0v 1979.505n 0.0v 1989.495n 0.0v 1989.505n 0.0v 1999.495n 0.0v 1999.505n 0.0v 2009.495n 0.0v 2009.505n 0.0v 2019.495n 0.0v 2019.505n 0.0v 2029.495n 0.0v 2029.505n 0.0v 2039.495n 0.0v 2039.505n 1.8v 2049.495n 1.8v 2049.505n 1.8v )
* (time, data): [(0, 0), (10, 1), (20, 0), (30, 0), (40, 0), (50, 0), (60, 0), (70, 0), (80, 0), (90, 0), (100, 0), (110, 0), (120, 0), (130, 0), (140, 0), (150, 0), (160, 0), (170, 1), (180, 1), (190, 1), (200, 1), (210, 1), (220, 1), (230, 1), (240, 0), (250, 0), (260, 0), (270, 1), (280, 0), (290, 0), (300, 0), (310, 0), (320, 0), (330, 0), (340, 1), (350, 1), (360, 1), (370, 1), (380, 1), (390, 0), (400, 1), (410, 0), (420, 0), (430, 1), (440, 1), (450, 1), (460, 1), (470, 1), (480, 1), (490, 1), (500, 1), (510, 0), (520, 0), (530, 1), (540, 1), (550, 1), (560, 1), (570, 1), (580, 1), (590, 1), (600, 0), (610, 0), (620, 0), (630, 0), (640, 0), (650, 1), (660, 1), (670, 1), (680, 1), (690, 1), (700, 1), (710, 1), (720, 1), (730, 1), (740, 0), (750, 0), (760, 0), (770, 0), (780, 0), (790, 0), (800, 0), (810, 0), (820, 0), (830, 0), (840, 0), (850, 0), (860, 1), (870, 1), (880, 1), (890, 1), (900, 1), (910, 1), (920, 1), (930, 1), (940, 1), (950, 1), (960, 1), (970, 1), (980, 1), (990, 0), (1000, 1), (1010, 1), (1020, 1), (1030, 1), (1040, 0), (1050, 0), (1060, 1), (1070, 1), (1080, 1), (1090, 1), (1100, 0), (1110, 0), (1120, 1), (1130, 0), (1140, 0), (1150, 0), (1160, 0), (1170, 0), (1180, 0), (1190, 0), (1200, 0), (1210, 0), (1220, 0), (1230, 0), (1240, 1), (1250, 1), (1260, 1), (1270, 1), (1280, 1), (1290, 1), (1300, 1), (1310, 1), (1320, 1), (1330, 1), (1340, 0), (1350, 0), (1360, 0), (1370, 0), (1380, 0), (1390, 1), (1400, 1), (1410, 1), (1420, 0), (1430, 0), (1440, 0), (1450, 0), (1460, 0), (1470, 0), (1480, 0), (1490, 0), (1500, 0), (1510, 0), (1520, 0), (1530, 0), (1540, 0), (1550, 1), (1560, 1), (1570, 0), (1580, 0), (1590, 0), (1600, 0), (1610, 0), (1620, 0), (1630, 0), (1640, 0), (1650, 0), (1660, 0), (1670, 0), (1680, 1), (1690, 1), (1700, 1), (1710, 1), (1720, 1), (1730, 1), (1740, 1), (1750, 1), (1760, 1), (1770, 1), (1780, 1), (1790, 1), (1800, 0), (1810, 0), (1820, 0), (1830, 0), (1840, 0), (1850, 0), (1860, 0), (1870, 0), (1880, 0), (1890, 0), (1900, 0), (1910, 0), (1920, 0), (1930, 0), (1940, 0), (1950, 1), (1960, 1), (1970, 0), (1980, 0), (1990, 0), (2000, 0), (2010, 0), (2020, 0), (2030, 0), (2040, 0), (2050, 0)]
Vdin0_13  din0_13  0 PWL (0n 0.0v 9.495n 0.0v 9.505n 1.8v 19.495n 1.8v 19.505n 0.0v 29.495n 0.0v 29.505n 0.0v 39.495n 0.0v 39.505n 0.0v 49.495n 0.0v 49.505n 0.0v 59.495n 0.0v 59.505n 0.0v 69.495n 0.0v 69.505n 0.0v 79.495n 0.0v 79.505n 0.0v 89.495n 0.0v 89.505n 0.0v 99.495n 0.0v 99.505n 0.0v 109.495n 0.0v 109.505n 0.0v 119.495n 0.0v 119.505n 0.0v 129.495n 0.0v 129.505n 0.0v 139.495n 0.0v 139.505n 0.0v 149.495n 0.0v 149.505n 0.0v 159.495n 0.0v 159.505n 0.0v 169.495n 0.0v 169.505n 1.8v 179.495n 1.8v 179.505n 1.8v 189.495n 1.8v 189.505n 1.8v 199.495n 1.8v 199.505n 1.8v 209.495n 1.8v 209.505n 1.8v 219.495n 1.8v 219.505n 1.8v 229.495n 1.8v 229.505n 1.8v 239.495n 1.8v 239.505n 0.0v 249.495n 0.0v 249.505n 0.0v 259.495n 0.0v 259.505n 0.0v 269.495n 0.0v 269.505n 1.8v 279.495n 1.8v 279.505n 0.0v 289.495n 0.0v 289.505n 0.0v 299.495n 0.0v 299.505n 0.0v 309.495n 0.0v 309.505n 0.0v 319.495n 0.0v 319.505n 0.0v 329.495n 0.0v 329.505n 0.0v 339.495n 0.0v 339.505n 1.8v 349.495n 1.8v 349.505n 1.8v 359.495n 1.8v 359.505n 1.8v 369.495n 1.8v 369.505n 1.8v 379.495n 1.8v 379.505n 1.8v 389.495n 1.8v 389.505n 0.0v 399.495n 0.0v 399.505n 1.8v 409.495n 1.8v 409.505n 0.0v 419.495n 0.0v 419.505n 0.0v 429.495n 0.0v 429.505n 1.8v 439.495n 1.8v 439.505n 1.8v 449.495n 1.8v 449.505n 1.8v 459.495n 1.8v 459.505n 1.8v 469.495n 1.8v 469.505n 1.8v 479.495n 1.8v 479.505n 1.8v 489.495n 1.8v 489.505n 1.8v 499.495n 1.8v 499.505n 1.8v 509.495n 1.8v 509.505n 0.0v 519.495n 0.0v 519.505n 0.0v 529.495n 0.0v 529.505n 1.8v 539.495n 1.8v 539.505n 1.8v 549.495n 1.8v 549.505n 1.8v 559.495n 1.8v 559.505n 1.8v 569.495n 1.8v 569.505n 1.8v 579.495n 1.8v 579.505n 1.8v 589.495n 1.8v 589.505n 1.8v 599.495n 1.8v 599.505n 0.0v 609.495n 0.0v 609.505n 0.0v 619.495n 0.0v 619.505n 0.0v 629.495n 0.0v 629.505n 0.0v 639.495n 0.0v 639.505n 0.0v 649.495n 0.0v 649.505n 1.8v 659.495n 1.8v 659.505n 1.8v 669.495n 1.8v 669.505n 1.8v 679.495n 1.8v 679.505n 1.8v 689.495n 1.8v 689.505n 1.8v 699.495n 1.8v 699.505n 1.8v 709.495n 1.8v 709.505n 1.8v 719.495n 1.8v 719.505n 1.8v 729.495n 1.8v 729.505n 1.8v 739.495n 1.8v 739.505n 0.0v 749.495n 0.0v 749.505n 0.0v 759.495n 0.0v 759.505n 0.0v 769.495n 0.0v 769.505n 0.0v 779.495n 0.0v 779.505n 0.0v 789.495n 0.0v 789.505n 0.0v 799.495n 0.0v 799.505n 0.0v 809.495n 0.0v 809.505n 0.0v 819.495n 0.0v 819.505n 0.0v 829.495n 0.0v 829.505n 0.0v 839.495n 0.0v 839.505n 0.0v 849.495n 0.0v 849.505n 0.0v 859.495n 0.0v 859.505n 1.8v 869.495n 1.8v 869.505n 1.8v 879.495n 1.8v 879.505n 1.8v 889.495n 1.8v 889.505n 1.8v 899.495n 1.8v 899.505n 1.8v 909.495n 1.8v 909.505n 1.8v 919.495n 1.8v 919.505n 1.8v 929.495n 1.8v 929.505n 1.8v 939.495n 1.8v 939.505n 1.8v 949.495n 1.8v 949.505n 1.8v 959.495n 1.8v 959.505n 1.8v 969.495n 1.8v 969.505n 1.8v 979.495n 1.8v 979.505n 1.8v 989.495n 1.8v 989.505n 0.0v 999.495n 0.0v 999.505n 1.8v 1009.495n 1.8v 1009.505n 1.8v 1019.495n 1.8v 1019.505n 1.8v 1029.495n 1.8v 1029.505n 1.8v 1039.495n 1.8v 1039.505n 0.0v 1049.495n 0.0v 1049.505n 0.0v 1059.495n 0.0v 1059.505n 1.8v 1069.495n 1.8v 1069.505n 1.8v 1079.495n 1.8v 1079.505n 1.8v 1089.495n 1.8v 1089.505n 1.8v 1099.495n 1.8v 1099.505n 0.0v 1109.495n 0.0v 1109.505n 0.0v 1119.495n 0.0v 1119.505n 1.8v 1129.495n 1.8v 1129.505n 0.0v 1139.495n 0.0v 1139.505n 0.0v 1149.495n 0.0v 1149.505n 0.0v 1159.495n 0.0v 1159.505n 0.0v 1169.495n 0.0v 1169.505n 0.0v 1179.495n 0.0v 1179.505n 0.0v 1189.495n 0.0v 1189.505n 0.0v 1199.495n 0.0v 1199.505n 0.0v 1209.495n 0.0v 1209.505n 0.0v 1219.495n 0.0v 1219.505n 0.0v 1229.495n 0.0v 1229.505n 0.0v 1239.495n 0.0v 1239.505n 1.8v 1249.495n 1.8v 1249.505n 1.8v 1259.495n 1.8v 1259.505n 1.8v 1269.495n 1.8v 1269.505n 1.8v 1279.495n 1.8v 1279.505n 1.8v 1289.495n 1.8v 1289.505n 1.8v 1299.495n 1.8v 1299.505n 1.8v 1309.495n 1.8v 1309.505n 1.8v 1319.495n 1.8v 1319.505n 1.8v 1329.495n 1.8v 1329.505n 1.8v 1339.495n 1.8v 1339.505n 0.0v 1349.495n 0.0v 1349.505n 0.0v 1359.495n 0.0v 1359.505n 0.0v 1369.495n 0.0v 1369.505n 0.0v 1379.495n 0.0v 1379.505n 0.0v 1389.495n 0.0v 1389.505n 1.8v 1399.495n 1.8v 1399.505n 1.8v 1409.495n 1.8v 1409.505n 1.8v 1419.495n 1.8v 1419.505n 0.0v 1429.495n 0.0v 1429.505n 0.0v 1439.495n 0.0v 1439.505n 0.0v 1449.495n 0.0v 1449.505n 0.0v 1459.495n 0.0v 1459.505n 0.0v 1469.495n 0.0v 1469.505n 0.0v 1479.495n 0.0v 1479.505n 0.0v 1489.495n 0.0v 1489.505n 0.0v 1499.495n 0.0v 1499.505n 0.0v 1509.495n 0.0v 1509.505n 0.0v 1519.495n 0.0v 1519.505n 0.0v 1529.495n 0.0v 1529.505n 0.0v 1539.495n 0.0v 1539.505n 0.0v 1549.495n 0.0v 1549.505n 1.8v 1559.495n 1.8v 1559.505n 1.8v 1569.495n 1.8v 1569.505n 0.0v 1579.495n 0.0v 1579.505n 0.0v 1589.495n 0.0v 1589.505n 0.0v 1599.495n 0.0v 1599.505n 0.0v 1609.495n 0.0v 1609.505n 0.0v 1619.495n 0.0v 1619.505n 0.0v 1629.495n 0.0v 1629.505n 0.0v 1639.495n 0.0v 1639.505n 0.0v 1649.495n 0.0v 1649.505n 0.0v 1659.495n 0.0v 1659.505n 0.0v 1669.495n 0.0v 1669.505n 0.0v 1679.495n 0.0v 1679.505n 1.8v 1689.495n 1.8v 1689.505n 1.8v 1699.495n 1.8v 1699.505n 1.8v 1709.495n 1.8v 1709.505n 1.8v 1719.495n 1.8v 1719.505n 1.8v 1729.495n 1.8v 1729.505n 1.8v 1739.495n 1.8v 1739.505n 1.8v 1749.495n 1.8v 1749.505n 1.8v 1759.495n 1.8v 1759.505n 1.8v 1769.495n 1.8v 1769.505n 1.8v 1779.495n 1.8v 1779.505n 1.8v 1789.495n 1.8v 1789.505n 1.8v 1799.495n 1.8v 1799.505n 0.0v 1809.495n 0.0v 1809.505n 0.0v 1819.495n 0.0v 1819.505n 0.0v 1829.495n 0.0v 1829.505n 0.0v 1839.495n 0.0v 1839.505n 0.0v 1849.495n 0.0v 1849.505n 0.0v 1859.495n 0.0v 1859.505n 0.0v 1869.495n 0.0v 1869.505n 0.0v 1879.495n 0.0v 1879.505n 0.0v 1889.495n 0.0v 1889.505n 0.0v 1899.495n 0.0v 1899.505n 0.0v 1909.495n 0.0v 1909.505n 0.0v 1919.495n 0.0v 1919.505n 0.0v 1929.495n 0.0v 1929.505n 0.0v 1939.495n 0.0v 1939.505n 0.0v 1949.495n 0.0v 1949.505n 1.8v 1959.495n 1.8v 1959.505n 1.8v 1969.495n 1.8v 1969.505n 0.0v 1979.495n 0.0v 1979.505n 0.0v 1989.495n 0.0v 1989.505n 0.0v 1999.495n 0.0v 1999.505n 0.0v 2009.495n 0.0v 2009.505n 0.0v 2019.495n 0.0v 2019.505n 0.0v 2029.495n 0.0v 2029.505n 0.0v 2039.495n 0.0v 2039.505n 0.0v 2049.495n 0.0v 2049.505n 0.0v )
* (time, data): [(0, 0), (10, 0), (20, 0), (30, 0), (40, 0), (50, 0), (60, 0), (70, 0), (80, 0), (90, 0), (100, 0), (110, 0), (120, 0), (130, 0), (140, 0), (150, 0), (160, 0), (170, 0), (180, 0), (190, 0), (200, 0), (210, 0), (220, 0), (230, 0), (240, 0), (250, 0), (260, 0), (270, 0), (280, 0), (290, 0), (300, 0), (310, 1), (320, 1), (330, 1), (340, 1), (350, 1), (360, 1), (370, 1), (380, 1), (390, 1), (400, 0), (410, 0), (420, 0), (430, 1), (440, 1), (450, 1), (460, 1), (470, 1), (480, 1), (490, 1), (500, 0), (510, 1), (520, 1), (530, 0), (540, 0), (550, 0), (560, 0), (570, 0), (580, 0), (590, 0), (600, 1), (610, 1), (620, 0), (630, 0), (640, 0), (650, 0), (660, 0), (670, 0), (680, 0), (690, 0), (700, 0), (710, 0), (720, 0), (730, 0), (740, 1), (750, 1), (760, 0), (770, 1), (780, 1), (790, 1), (800, 1), (810, 1), (820, 1), (830, 1), (840, 1), (850, 1), (860, 0), (870, 0), (880, 0), (890, 0), (900, 1), (910, 0), (920, 0), (930, 0), (940, 0), (950, 0), (960, 0), (970, 0), (980, 0), (990, 1), (1000, 0), (1010, 0), (1020, 0), (1030, 0), (1040, 1), (1050, 1), (1060, 1), (1070, 1), (1080, 1), (1090, 1), (1100, 1), (1110, 1), (1120, 0), (1130, 1), (1140, 1), (1150, 0), (1160, 0), (1170, 0), (1180, 0), (1190, 0), (1200, 0), (1210, 0), (1220, 0), (1230, 1), (1240, 1), (1250, 1), (1260, 1), (1270, 1), (1280, 1), (1290, 1), (1300, 1), (1310, 1), (1320, 1), (1330, 1), (1340, 1), (1350, 1), (1360, 1), (1370, 1), (1380, 1), (1390, 1), (1400, 1), (1410, 1), (1420, 0), (1430, 0), (1440, 0), (1450, 0), (1460, 0), (1470, 0), (1480, 0), (1490, 0), (1500, 0), (1510, 1), (1520, 1), (1530, 1), (1540, 1), (1550, 0), (1560, 0), (1570, 0), (1580, 0), (1590, 1), (1600, 1), (1610, 0), (1620, 0), (1630, 0), (1640, 0), (1650, 0), (1660, 1), (1670, 1), (1680, 0), (1690, 1), (1700, 1), (1710, 0), (1720, 0), (1730, 1), (1740, 1), (1750, 1), (1760, 1), (1770, 1), (1780, 0), (1790, 0), (1800, 1), (1810, 1), (1820, 1), (1830, 1), (1840, 1), (1850, 0), (1860, 0), (1870, 0), (1880, 0), (1890, 0), (1900, 1), (1910, 1), (1920, 1), (1930, 1), (1940, 0), (1950, 1), (1960, 1), (1970, 1), (1980, 1), (1990, 0), (2000, 0), (2010, 0), (2020, 0), (2030, 0), (2040, 1), (2050, 1)]
Vdin0_14  din0_14  0 PWL (0n 0.0v 9.495n 0.0v 9.505n 0.0v 19.495n 0.0v 19.505n 0.0v 29.495n 0.0v 29.505n 0.0v 39.495n 0.0v 39.505n 0.0v 49.495n 0.0v 49.505n 0.0v 59.495n 0.0v 59.505n 0.0v 69.495n 0.0v 69.505n 0.0v 79.495n 0.0v 79.505n 0.0v 89.495n 0.0v 89.505n 0.0v 99.495n 0.0v 99.505n 0.0v 109.495n 0.0v 109.505n 0.0v 119.495n 0.0v 119.505n 0.0v 129.495n 0.0v 129.505n 0.0v 139.495n 0.0v 139.505n 0.0v 149.495n 0.0v 149.505n 0.0v 159.495n 0.0v 159.505n 0.0v 169.495n 0.0v 169.505n 0.0v 179.495n 0.0v 179.505n 0.0v 189.495n 0.0v 189.505n 0.0v 199.495n 0.0v 199.505n 0.0v 209.495n 0.0v 209.505n 0.0v 219.495n 0.0v 219.505n 0.0v 229.495n 0.0v 229.505n 0.0v 239.495n 0.0v 239.505n 0.0v 249.495n 0.0v 249.505n 0.0v 259.495n 0.0v 259.505n 0.0v 269.495n 0.0v 269.505n 0.0v 279.495n 0.0v 279.505n 0.0v 289.495n 0.0v 289.505n 0.0v 299.495n 0.0v 299.505n 0.0v 309.495n 0.0v 309.505n 1.8v 319.495n 1.8v 319.505n 1.8v 329.495n 1.8v 329.505n 1.8v 339.495n 1.8v 339.505n 1.8v 349.495n 1.8v 349.505n 1.8v 359.495n 1.8v 359.505n 1.8v 369.495n 1.8v 369.505n 1.8v 379.495n 1.8v 379.505n 1.8v 389.495n 1.8v 389.505n 1.8v 399.495n 1.8v 399.505n 0.0v 409.495n 0.0v 409.505n 0.0v 419.495n 0.0v 419.505n 0.0v 429.495n 0.0v 429.505n 1.8v 439.495n 1.8v 439.505n 1.8v 449.495n 1.8v 449.505n 1.8v 459.495n 1.8v 459.505n 1.8v 469.495n 1.8v 469.505n 1.8v 479.495n 1.8v 479.505n 1.8v 489.495n 1.8v 489.505n 1.8v 499.495n 1.8v 499.505n 0.0v 509.495n 0.0v 509.505n 1.8v 519.495n 1.8v 519.505n 1.8v 529.495n 1.8v 529.505n 0.0v 539.495n 0.0v 539.505n 0.0v 549.495n 0.0v 549.505n 0.0v 559.495n 0.0v 559.505n 0.0v 569.495n 0.0v 569.505n 0.0v 579.495n 0.0v 579.505n 0.0v 589.495n 0.0v 589.505n 0.0v 599.495n 0.0v 599.505n 1.8v 609.495n 1.8v 609.505n 1.8v 619.495n 1.8v 619.505n 0.0v 629.495n 0.0v 629.505n 0.0v 639.495n 0.0v 639.505n 0.0v 649.495n 0.0v 649.505n 0.0v 659.495n 0.0v 659.505n 0.0v 669.495n 0.0v 669.505n 0.0v 679.495n 0.0v 679.505n 0.0v 689.495n 0.0v 689.505n 0.0v 699.495n 0.0v 699.505n 0.0v 709.495n 0.0v 709.505n 0.0v 719.495n 0.0v 719.505n 0.0v 729.495n 0.0v 729.505n 0.0v 739.495n 0.0v 739.505n 1.8v 749.495n 1.8v 749.505n 1.8v 759.495n 1.8v 759.505n 0.0v 769.495n 0.0v 769.505n 1.8v 779.495n 1.8v 779.505n 1.8v 789.495n 1.8v 789.505n 1.8v 799.495n 1.8v 799.505n 1.8v 809.495n 1.8v 809.505n 1.8v 819.495n 1.8v 819.505n 1.8v 829.495n 1.8v 829.505n 1.8v 839.495n 1.8v 839.505n 1.8v 849.495n 1.8v 849.505n 1.8v 859.495n 1.8v 859.505n 0.0v 869.495n 0.0v 869.505n 0.0v 879.495n 0.0v 879.505n 0.0v 889.495n 0.0v 889.505n 0.0v 899.495n 0.0v 899.505n 1.8v 909.495n 1.8v 909.505n 0.0v 919.495n 0.0v 919.505n 0.0v 929.495n 0.0v 929.505n 0.0v 939.495n 0.0v 939.505n 0.0v 949.495n 0.0v 949.505n 0.0v 959.495n 0.0v 959.505n 0.0v 969.495n 0.0v 969.505n 0.0v 979.495n 0.0v 979.505n 0.0v 989.495n 0.0v 989.505n 1.8v 999.495n 1.8v 999.505n 0.0v 1009.495n 0.0v 1009.505n 0.0v 1019.495n 0.0v 1019.505n 0.0v 1029.495n 0.0v 1029.505n 0.0v 1039.495n 0.0v 1039.505n 1.8v 1049.495n 1.8v 1049.505n 1.8v 1059.495n 1.8v 1059.505n 1.8v 1069.495n 1.8v 1069.505n 1.8v 1079.495n 1.8v 1079.505n 1.8v 1089.495n 1.8v 1089.505n 1.8v 1099.495n 1.8v 1099.505n 1.8v 1109.495n 1.8v 1109.505n 1.8v 1119.495n 1.8v 1119.505n 0.0v 1129.495n 0.0v 1129.505n 1.8v 1139.495n 1.8v 1139.505n 1.8v 1149.495n 1.8v 1149.505n 0.0v 1159.495n 0.0v 1159.505n 0.0v 1169.495n 0.0v 1169.505n 0.0v 1179.495n 0.0v 1179.505n 0.0v 1189.495n 0.0v 1189.505n 0.0v 1199.495n 0.0v 1199.505n 0.0v 1209.495n 0.0v 1209.505n 0.0v 1219.495n 0.0v 1219.505n 0.0v 1229.495n 0.0v 1229.505n 1.8v 1239.495n 1.8v 1239.505n 1.8v 1249.495n 1.8v 1249.505n 1.8v 1259.495n 1.8v 1259.505n 1.8v 1269.495n 1.8v 1269.505n 1.8v 1279.495n 1.8v 1279.505n 1.8v 1289.495n 1.8v 1289.505n 1.8v 1299.495n 1.8v 1299.505n 1.8v 1309.495n 1.8v 1309.505n 1.8v 1319.495n 1.8v 1319.505n 1.8v 1329.495n 1.8v 1329.505n 1.8v 1339.495n 1.8v 1339.505n 1.8v 1349.495n 1.8v 1349.505n 1.8v 1359.495n 1.8v 1359.505n 1.8v 1369.495n 1.8v 1369.505n 1.8v 1379.495n 1.8v 1379.505n 1.8v 1389.495n 1.8v 1389.505n 1.8v 1399.495n 1.8v 1399.505n 1.8v 1409.495n 1.8v 1409.505n 1.8v 1419.495n 1.8v 1419.505n 0.0v 1429.495n 0.0v 1429.505n 0.0v 1439.495n 0.0v 1439.505n 0.0v 1449.495n 0.0v 1449.505n 0.0v 1459.495n 0.0v 1459.505n 0.0v 1469.495n 0.0v 1469.505n 0.0v 1479.495n 0.0v 1479.505n 0.0v 1489.495n 0.0v 1489.505n 0.0v 1499.495n 0.0v 1499.505n 0.0v 1509.495n 0.0v 1509.505n 1.8v 1519.495n 1.8v 1519.505n 1.8v 1529.495n 1.8v 1529.505n 1.8v 1539.495n 1.8v 1539.505n 1.8v 1549.495n 1.8v 1549.505n 0.0v 1559.495n 0.0v 1559.505n 0.0v 1569.495n 0.0v 1569.505n 0.0v 1579.495n 0.0v 1579.505n 0.0v 1589.495n 0.0v 1589.505n 1.8v 1599.495n 1.8v 1599.505n 1.8v 1609.495n 1.8v 1609.505n 0.0v 1619.495n 0.0v 1619.505n 0.0v 1629.495n 0.0v 1629.505n 0.0v 1639.495n 0.0v 1639.505n 0.0v 1649.495n 0.0v 1649.505n 0.0v 1659.495n 0.0v 1659.505n 1.8v 1669.495n 1.8v 1669.505n 1.8v 1679.495n 1.8v 1679.505n 0.0v 1689.495n 0.0v 1689.505n 1.8v 1699.495n 1.8v 1699.505n 1.8v 1709.495n 1.8v 1709.505n 0.0v 1719.495n 0.0v 1719.505n 0.0v 1729.495n 0.0v 1729.505n 1.8v 1739.495n 1.8v 1739.505n 1.8v 1749.495n 1.8v 1749.505n 1.8v 1759.495n 1.8v 1759.505n 1.8v 1769.495n 1.8v 1769.505n 1.8v 1779.495n 1.8v 1779.505n 0.0v 1789.495n 0.0v 1789.505n 0.0v 1799.495n 0.0v 1799.505n 1.8v 1809.495n 1.8v 1809.505n 1.8v 1819.495n 1.8v 1819.505n 1.8v 1829.495n 1.8v 1829.505n 1.8v 1839.495n 1.8v 1839.505n 1.8v 1849.495n 1.8v 1849.505n 0.0v 1859.495n 0.0v 1859.505n 0.0v 1869.495n 0.0v 1869.505n 0.0v 1879.495n 0.0v 1879.505n 0.0v 1889.495n 0.0v 1889.505n 0.0v 1899.495n 0.0v 1899.505n 1.8v 1909.495n 1.8v 1909.505n 1.8v 1919.495n 1.8v 1919.505n 1.8v 1929.495n 1.8v 1929.505n 1.8v 1939.495n 1.8v 1939.505n 0.0v 1949.495n 0.0v 1949.505n 1.8v 1959.495n 1.8v 1959.505n 1.8v 1969.495n 1.8v 1969.505n 1.8v 1979.495n 1.8v 1979.505n 1.8v 1989.495n 1.8v 1989.505n 0.0v 1999.495n 0.0v 1999.505n 0.0v 2009.495n 0.0v 2009.505n 0.0v 2019.495n 0.0v 2019.505n 0.0v 2029.495n 0.0v 2029.505n 0.0v 2039.495n 0.0v 2039.505n 1.8v 2049.495n 1.8v 2049.505n 1.8v )
* (time, data): [(0, 0), (10, 1), (20, 1), (30, 0), (40, 0), (50, 0), (60, 0), (70, 0), (80, 0), (90, 0), (100, 0), (110, 1), (120, 1), (130, 1), (140, 1), (150, 1), (160, 1), (170, 1), (180, 1), (190, 1), (200, 1), (210, 1), (220, 1), (230, 1), (240, 0), (250, 0), (260, 0), (270, 0), (280, 1), (290, 1), (300, 1), (310, 0), (320, 1), (330, 1), (340, 0), (350, 0), (360, 0), (370, 0), (380, 0), (390, 0), (400, 0), (410, 0), (420, 0), (430, 1), (440, 1), (450, 1), (460, 1), (470, 1), (480, 1), (490, 1), (500, 1), (510, 1), (520, 1), (530, 1), (540, 0), (550, 0), (560, 0), (570, 0), (580, 0), (590, 0), (600, 1), (610, 1), (620, 0), (630, 0), (640, 0), (650, 0), (660, 0), (670, 0), (680, 0), (690, 0), (700, 0), (710, 0), (720, 0), (730, 0), (740, 1), (750, 0), (760, 0), (770, 1), (780, 1), (790, 1), (800, 1), (810, 1), (820, 1), (830, 1), (840, 1), (850, 1), (860, 1), (870, 1), (880, 1), (890, 1), (900, 1), (910, 0), (920, 0), (930, 0), (940, 0), (950, 0), (960, 0), (970, 0), (980, 0), (990, 0), (1000, 0), (1010, 0), (1020, 0), (1030, 0), (1040, 0), (1050, 0), (1060, 0), (1070, 0), (1080, 0), (1090, 0), (1100, 1), (1110, 1), (1120, 0), (1130, 0), (1140, 0), (1150, 0), (1160, 0), (1170, 0), (1180, 0), (1190, 0), (1200, 0), (1210, 0), (1220, 0), (1230, 0), (1240, 1), (1250, 1), (1260, 1), (1270, 1), (1280, 1), (1290, 1), (1300, 1), (1310, 1), (1320, 1), (1330, 1), (1340, 1), (1350, 0), (1360, 0), (1370, 0), (1380, 0), (1390, 0), (1400, 0), (1410, 1), (1420, 0), (1430, 0), (1440, 0), (1450, 0), (1460, 0), (1470, 0), (1480, 1), (1490, 1), (1500, 1), (1510, 0), (1520, 0), (1530, 1), (1540, 1), (1550, 1), (1560, 1), (1570, 0), (1580, 0), (1590, 0), (1600, 0), (1610, 0), (1620, 0), (1630, 0), (1640, 0), (1650, 0), (1660, 1), (1670, 1), (1680, 1), (1690, 1), (1700, 1), (1710, 0), (1720, 0), (1730, 1), (1740, 1), (1750, 1), (1760, 1), (1770, 1), (1780, 1), (1790, 1), (1800, 1), (1810, 1), (1820, 1), (1830, 1), (1840, 0), (1850, 1), (1860, 1), (1870, 1), (1880, 1), (1890, 1), (1900, 1), (1910, 1), (1920, 1), (1930, 1), (1940, 0), (1950, 0), (1960, 0), (1970, 1), (1980, 1), (1990, 0), (2000, 0), (2010, 0), (2020, 0), (2030, 0), (2040, 1), (2050, 1)]
Vdin0_15  din0_15  0 PWL (0n 0.0v 9.495n 0.0v 9.505n 1.8v 19.495n 1.8v 19.505n 1.8v 29.495n 1.8v 29.505n 0.0v 39.495n 0.0v 39.505n 0.0v 49.495n 0.0v 49.505n 0.0v 59.495n 0.0v 59.505n 0.0v 69.495n 0.0v 69.505n 0.0v 79.495n 0.0v 79.505n 0.0v 89.495n 0.0v 89.505n 0.0v 99.495n 0.0v 99.505n 0.0v 109.495n 0.0v 109.505n 1.8v 119.495n 1.8v 119.505n 1.8v 129.495n 1.8v 129.505n 1.8v 139.495n 1.8v 139.505n 1.8v 149.495n 1.8v 149.505n 1.8v 159.495n 1.8v 159.505n 1.8v 169.495n 1.8v 169.505n 1.8v 179.495n 1.8v 179.505n 1.8v 189.495n 1.8v 189.505n 1.8v 199.495n 1.8v 199.505n 1.8v 209.495n 1.8v 209.505n 1.8v 219.495n 1.8v 219.505n 1.8v 229.495n 1.8v 229.505n 1.8v 239.495n 1.8v 239.505n 0.0v 249.495n 0.0v 249.505n 0.0v 259.495n 0.0v 259.505n 0.0v 269.495n 0.0v 269.505n 0.0v 279.495n 0.0v 279.505n 1.8v 289.495n 1.8v 289.505n 1.8v 299.495n 1.8v 299.505n 1.8v 309.495n 1.8v 309.505n 0.0v 319.495n 0.0v 319.505n 1.8v 329.495n 1.8v 329.505n 1.8v 339.495n 1.8v 339.505n 0.0v 349.495n 0.0v 349.505n 0.0v 359.495n 0.0v 359.505n 0.0v 369.495n 0.0v 369.505n 0.0v 379.495n 0.0v 379.505n 0.0v 389.495n 0.0v 389.505n 0.0v 399.495n 0.0v 399.505n 0.0v 409.495n 0.0v 409.505n 0.0v 419.495n 0.0v 419.505n 0.0v 429.495n 0.0v 429.505n 1.8v 439.495n 1.8v 439.505n 1.8v 449.495n 1.8v 449.505n 1.8v 459.495n 1.8v 459.505n 1.8v 469.495n 1.8v 469.505n 1.8v 479.495n 1.8v 479.505n 1.8v 489.495n 1.8v 489.505n 1.8v 499.495n 1.8v 499.505n 1.8v 509.495n 1.8v 509.505n 1.8v 519.495n 1.8v 519.505n 1.8v 529.495n 1.8v 529.505n 1.8v 539.495n 1.8v 539.505n 0.0v 549.495n 0.0v 549.505n 0.0v 559.495n 0.0v 559.505n 0.0v 569.495n 0.0v 569.505n 0.0v 579.495n 0.0v 579.505n 0.0v 589.495n 0.0v 589.505n 0.0v 599.495n 0.0v 599.505n 1.8v 609.495n 1.8v 609.505n 1.8v 619.495n 1.8v 619.505n 0.0v 629.495n 0.0v 629.505n 0.0v 639.495n 0.0v 639.505n 0.0v 649.495n 0.0v 649.505n 0.0v 659.495n 0.0v 659.505n 0.0v 669.495n 0.0v 669.505n 0.0v 679.495n 0.0v 679.505n 0.0v 689.495n 0.0v 689.505n 0.0v 699.495n 0.0v 699.505n 0.0v 709.495n 0.0v 709.505n 0.0v 719.495n 0.0v 719.505n 0.0v 729.495n 0.0v 729.505n 0.0v 739.495n 0.0v 739.505n 1.8v 749.495n 1.8v 749.505n 0.0v 759.495n 0.0v 759.505n 0.0v 769.495n 0.0v 769.505n 1.8v 779.495n 1.8v 779.505n 1.8v 789.495n 1.8v 789.505n 1.8v 799.495n 1.8v 799.505n 1.8v 809.495n 1.8v 809.505n 1.8v 819.495n 1.8v 819.505n 1.8v 829.495n 1.8v 829.505n 1.8v 839.495n 1.8v 839.505n 1.8v 849.495n 1.8v 849.505n 1.8v 859.495n 1.8v 859.505n 1.8v 869.495n 1.8v 869.505n 1.8v 879.495n 1.8v 879.505n 1.8v 889.495n 1.8v 889.505n 1.8v 899.495n 1.8v 899.505n 1.8v 909.495n 1.8v 909.505n 0.0v 919.495n 0.0v 919.505n 0.0v 929.495n 0.0v 929.505n 0.0v 939.495n 0.0v 939.505n 0.0v 949.495n 0.0v 949.505n 0.0v 959.495n 0.0v 959.505n 0.0v 969.495n 0.0v 969.505n 0.0v 979.495n 0.0v 979.505n 0.0v 989.495n 0.0v 989.505n 0.0v 999.495n 0.0v 999.505n 0.0v 1009.495n 0.0v 1009.505n 0.0v 1019.495n 0.0v 1019.505n 0.0v 1029.495n 0.0v 1029.505n 0.0v 1039.495n 0.0v 1039.505n 0.0v 1049.495n 0.0v 1049.505n 0.0v 1059.495n 0.0v 1059.505n 0.0v 1069.495n 0.0v 1069.505n 0.0v 1079.495n 0.0v 1079.505n 0.0v 1089.495n 0.0v 1089.505n 0.0v 1099.495n 0.0v 1099.505n 1.8v 1109.495n 1.8v 1109.505n 1.8v 1119.495n 1.8v 1119.505n 0.0v 1129.495n 0.0v 1129.505n 0.0v 1139.495n 0.0v 1139.505n 0.0v 1149.495n 0.0v 1149.505n 0.0v 1159.495n 0.0v 1159.505n 0.0v 1169.495n 0.0v 1169.505n 0.0v 1179.495n 0.0v 1179.505n 0.0v 1189.495n 0.0v 1189.505n 0.0v 1199.495n 0.0v 1199.505n 0.0v 1209.495n 0.0v 1209.505n 0.0v 1219.495n 0.0v 1219.505n 0.0v 1229.495n 0.0v 1229.505n 0.0v 1239.495n 0.0v 1239.505n 1.8v 1249.495n 1.8v 1249.505n 1.8v 1259.495n 1.8v 1259.505n 1.8v 1269.495n 1.8v 1269.505n 1.8v 1279.495n 1.8v 1279.505n 1.8v 1289.495n 1.8v 1289.505n 1.8v 1299.495n 1.8v 1299.505n 1.8v 1309.495n 1.8v 1309.505n 1.8v 1319.495n 1.8v 1319.505n 1.8v 1329.495n 1.8v 1329.505n 1.8v 1339.495n 1.8v 1339.505n 1.8v 1349.495n 1.8v 1349.505n 0.0v 1359.495n 0.0v 1359.505n 0.0v 1369.495n 0.0v 1369.505n 0.0v 1379.495n 0.0v 1379.505n 0.0v 1389.495n 0.0v 1389.505n 0.0v 1399.495n 0.0v 1399.505n 0.0v 1409.495n 0.0v 1409.505n 1.8v 1419.495n 1.8v 1419.505n 0.0v 1429.495n 0.0v 1429.505n 0.0v 1439.495n 0.0v 1439.505n 0.0v 1449.495n 0.0v 1449.505n 0.0v 1459.495n 0.0v 1459.505n 0.0v 1469.495n 0.0v 1469.505n 0.0v 1479.495n 0.0v 1479.505n 1.8v 1489.495n 1.8v 1489.505n 1.8v 1499.495n 1.8v 1499.505n 1.8v 1509.495n 1.8v 1509.505n 0.0v 1519.495n 0.0v 1519.505n 0.0v 1529.495n 0.0v 1529.505n 1.8v 1539.495n 1.8v 1539.505n 1.8v 1549.495n 1.8v 1549.505n 1.8v 1559.495n 1.8v 1559.505n 1.8v 1569.495n 1.8v 1569.505n 0.0v 1579.495n 0.0v 1579.505n 0.0v 1589.495n 0.0v 1589.505n 0.0v 1599.495n 0.0v 1599.505n 0.0v 1609.495n 0.0v 1609.505n 0.0v 1619.495n 0.0v 1619.505n 0.0v 1629.495n 0.0v 1629.505n 0.0v 1639.495n 0.0v 1639.505n 0.0v 1649.495n 0.0v 1649.505n 0.0v 1659.495n 0.0v 1659.505n 1.8v 1669.495n 1.8v 1669.505n 1.8v 1679.495n 1.8v 1679.505n 1.8v 1689.495n 1.8v 1689.505n 1.8v 1699.495n 1.8v 1699.505n 1.8v 1709.495n 1.8v 1709.505n 0.0v 1719.495n 0.0v 1719.505n 0.0v 1729.495n 0.0v 1729.505n 1.8v 1739.495n 1.8v 1739.505n 1.8v 1749.495n 1.8v 1749.505n 1.8v 1759.495n 1.8v 1759.505n 1.8v 1769.495n 1.8v 1769.505n 1.8v 1779.495n 1.8v 1779.505n 1.8v 1789.495n 1.8v 1789.505n 1.8v 1799.495n 1.8v 1799.505n 1.8v 1809.495n 1.8v 1809.505n 1.8v 1819.495n 1.8v 1819.505n 1.8v 1829.495n 1.8v 1829.505n 1.8v 1839.495n 1.8v 1839.505n 0.0v 1849.495n 0.0v 1849.505n 1.8v 1859.495n 1.8v 1859.505n 1.8v 1869.495n 1.8v 1869.505n 1.8v 1879.495n 1.8v 1879.505n 1.8v 1889.495n 1.8v 1889.505n 1.8v 1899.495n 1.8v 1899.505n 1.8v 1909.495n 1.8v 1909.505n 1.8v 1919.495n 1.8v 1919.505n 1.8v 1929.495n 1.8v 1929.505n 1.8v 1939.495n 1.8v 1939.505n 0.0v 1949.495n 0.0v 1949.505n 0.0v 1959.495n 0.0v 1959.505n 0.0v 1969.495n 0.0v 1969.505n 1.8v 1979.495n 1.8v 1979.505n 1.8v 1989.495n 1.8v 1989.505n 0.0v 1999.495n 0.0v 1999.505n 0.0v 2009.495n 0.0v 2009.505n 0.0v 2019.495n 0.0v 2019.505n 0.0v 2029.495n 0.0v 2029.505n 0.0v 2039.495n 0.0v 2039.505n 1.8v 2049.495n 1.8v 2049.505n 1.8v )
* (time, data): [(0, 0), (10, 1), (20, 1), (30, 0), (40, 0), (50, 0), (60, 0), (70, 0), (80, 1), (90, 1), (100, 1), (110, 0), (120, 0), (130, 0), (140, 0), (150, 0), (160, 0), (170, 1), (180, 1), (190, 1), (200, 1), (210, 1), (220, 1), (230, 1), (240, 1), (250, 1), (260, 1), (270, 1), (280, 1), (290, 1), (300, 1), (310, 1), (320, 1), (330, 1), (340, 1), (350, 1), (360, 1), (370, 1), (380, 1), (390, 1), (400, 1), (410, 1), (420, 1), (430, 0), (440, 0), (450, 0), (460, 0), (470, 0), (480, 0), (490, 0), (500, 0), (510, 1), (520, 1), (530, 0), (540, 0), (550, 0), (560, 0), (570, 0), (580, 0), (590, 0), (600, 0), (610, 0), (620, 0), (630, 0), (640, 0), (650, 1), (660, 1), (670, 1), (680, 1), (690, 1), (700, 1), (710, 1), (720, 1), (730, 1), (740, 1), (750, 1), (760, 0), (770, 1), (780, 1), (790, 1), (800, 1), (810, 1), (820, 1), (830, 1), (840, 1), (850, 1), (860, 1), (870, 1), (880, 1), (890, 1), (900, 0), (910, 1), (920, 1), (930, 1), (940, 1), (950, 1), (960, 1), (970, 1), (980, 1), (990, 0), (1000, 0), (1010, 0), (1020, 0), (1030, 0), (1040, 0), (1050, 0), (1060, 0), (1070, 0), (1080, 0), (1090, 0), (1100, 0), (1110, 0), (1120, 1), (1130, 0), (1140, 0), (1150, 1), (1160, 1), (1170, 1), (1180, 1), (1190, 1), (1200, 1), (1210, 0), (1220, 1), (1230, 0), (1240, 0), (1250, 0), (1260, 1), (1270, 1), (1280, 1), (1290, 1), (1300, 1), (1310, 1), (1320, 1), (1330, 1), (1340, 1), (1350, 1), (1360, 1), (1370, 1), (1380, 1), (1390, 0), (1400, 0), (1410, 1), (1420, 1), (1430, 1), (1440, 1), (1450, 1), (1460, 1), (1470, 1), (1480, 0), (1490, 0), (1500, 0), (1510, 1), (1520, 1), (1530, 1), (1540, 1), (1550, 1), (1560, 1), (1570, 1), (1580, 0), (1590, 1), (1600, 1), (1610, 0), (1620, 0), (1630, 0), (1640, 0), (1650, 0), (1660, 0), (1670, 0), (1680, 1), (1690, 1), (1700, 1), (1710, 0), (1720, 0), (1730, 0), (1740, 0), (1750, 0), (1760, 0), (1770, 0), (1780, 0), (1790, 0), (1800, 1), (1810, 1), (1820, 1), (1830, 1), (1840, 0), (1850, 0), (1860, 0), (1870, 0), (1880, 0), (1890, 0), (1900, 1), (1910, 1), (1920, 1), (1930, 1), (1940, 0), (1950, 1), (1960, 1), (1970, 1), (1980, 1), (1990, 1), (2000, 1), (2010, 1), (2020, 1), (2030, 1), (2040, 0), (2050, 0)]
Vdin0_16  din0_16  0 PWL (0n 0.0v 9.495n 0.0v 9.505n 1.8v 19.495n 1.8v 19.505n 1.8v 29.495n 1.8v 29.505n 0.0v 39.495n 0.0v 39.505n 0.0v 49.495n 0.0v 49.505n 0.0v 59.495n 0.0v 59.505n 0.0v 69.495n 0.0v 69.505n 0.0v 79.495n 0.0v 79.505n 1.8v 89.495n 1.8v 89.505n 1.8v 99.495n 1.8v 99.505n 1.8v 109.495n 1.8v 109.505n 0.0v 119.495n 0.0v 119.505n 0.0v 129.495n 0.0v 129.505n 0.0v 139.495n 0.0v 139.505n 0.0v 149.495n 0.0v 149.505n 0.0v 159.495n 0.0v 159.505n 0.0v 169.495n 0.0v 169.505n 1.8v 179.495n 1.8v 179.505n 1.8v 189.495n 1.8v 189.505n 1.8v 199.495n 1.8v 199.505n 1.8v 209.495n 1.8v 209.505n 1.8v 219.495n 1.8v 219.505n 1.8v 229.495n 1.8v 229.505n 1.8v 239.495n 1.8v 239.505n 1.8v 249.495n 1.8v 249.505n 1.8v 259.495n 1.8v 259.505n 1.8v 269.495n 1.8v 269.505n 1.8v 279.495n 1.8v 279.505n 1.8v 289.495n 1.8v 289.505n 1.8v 299.495n 1.8v 299.505n 1.8v 309.495n 1.8v 309.505n 1.8v 319.495n 1.8v 319.505n 1.8v 329.495n 1.8v 329.505n 1.8v 339.495n 1.8v 339.505n 1.8v 349.495n 1.8v 349.505n 1.8v 359.495n 1.8v 359.505n 1.8v 369.495n 1.8v 369.505n 1.8v 379.495n 1.8v 379.505n 1.8v 389.495n 1.8v 389.505n 1.8v 399.495n 1.8v 399.505n 1.8v 409.495n 1.8v 409.505n 1.8v 419.495n 1.8v 419.505n 1.8v 429.495n 1.8v 429.505n 0.0v 439.495n 0.0v 439.505n 0.0v 449.495n 0.0v 449.505n 0.0v 459.495n 0.0v 459.505n 0.0v 469.495n 0.0v 469.505n 0.0v 479.495n 0.0v 479.505n 0.0v 489.495n 0.0v 489.505n 0.0v 499.495n 0.0v 499.505n 0.0v 509.495n 0.0v 509.505n 1.8v 519.495n 1.8v 519.505n 1.8v 529.495n 1.8v 529.505n 0.0v 539.495n 0.0v 539.505n 0.0v 549.495n 0.0v 549.505n 0.0v 559.495n 0.0v 559.505n 0.0v 569.495n 0.0v 569.505n 0.0v 579.495n 0.0v 579.505n 0.0v 589.495n 0.0v 589.505n 0.0v 599.495n 0.0v 599.505n 0.0v 609.495n 0.0v 609.505n 0.0v 619.495n 0.0v 619.505n 0.0v 629.495n 0.0v 629.505n 0.0v 639.495n 0.0v 639.505n 0.0v 649.495n 0.0v 649.505n 1.8v 659.495n 1.8v 659.505n 1.8v 669.495n 1.8v 669.505n 1.8v 679.495n 1.8v 679.505n 1.8v 689.495n 1.8v 689.505n 1.8v 699.495n 1.8v 699.505n 1.8v 709.495n 1.8v 709.505n 1.8v 719.495n 1.8v 719.505n 1.8v 729.495n 1.8v 729.505n 1.8v 739.495n 1.8v 739.505n 1.8v 749.495n 1.8v 749.505n 1.8v 759.495n 1.8v 759.505n 0.0v 769.495n 0.0v 769.505n 1.8v 779.495n 1.8v 779.505n 1.8v 789.495n 1.8v 789.505n 1.8v 799.495n 1.8v 799.505n 1.8v 809.495n 1.8v 809.505n 1.8v 819.495n 1.8v 819.505n 1.8v 829.495n 1.8v 829.505n 1.8v 839.495n 1.8v 839.505n 1.8v 849.495n 1.8v 849.505n 1.8v 859.495n 1.8v 859.505n 1.8v 869.495n 1.8v 869.505n 1.8v 879.495n 1.8v 879.505n 1.8v 889.495n 1.8v 889.505n 1.8v 899.495n 1.8v 899.505n 0.0v 909.495n 0.0v 909.505n 1.8v 919.495n 1.8v 919.505n 1.8v 929.495n 1.8v 929.505n 1.8v 939.495n 1.8v 939.505n 1.8v 949.495n 1.8v 949.505n 1.8v 959.495n 1.8v 959.505n 1.8v 969.495n 1.8v 969.505n 1.8v 979.495n 1.8v 979.505n 1.8v 989.495n 1.8v 989.505n 0.0v 999.495n 0.0v 999.505n 0.0v 1009.495n 0.0v 1009.505n 0.0v 1019.495n 0.0v 1019.505n 0.0v 1029.495n 0.0v 1029.505n 0.0v 1039.495n 0.0v 1039.505n 0.0v 1049.495n 0.0v 1049.505n 0.0v 1059.495n 0.0v 1059.505n 0.0v 1069.495n 0.0v 1069.505n 0.0v 1079.495n 0.0v 1079.505n 0.0v 1089.495n 0.0v 1089.505n 0.0v 1099.495n 0.0v 1099.505n 0.0v 1109.495n 0.0v 1109.505n 0.0v 1119.495n 0.0v 1119.505n 1.8v 1129.495n 1.8v 1129.505n 0.0v 1139.495n 0.0v 1139.505n 0.0v 1149.495n 0.0v 1149.505n 1.8v 1159.495n 1.8v 1159.505n 1.8v 1169.495n 1.8v 1169.505n 1.8v 1179.495n 1.8v 1179.505n 1.8v 1189.495n 1.8v 1189.505n 1.8v 1199.495n 1.8v 1199.505n 1.8v 1209.495n 1.8v 1209.505n 0.0v 1219.495n 0.0v 1219.505n 1.8v 1229.495n 1.8v 1229.505n 0.0v 1239.495n 0.0v 1239.505n 0.0v 1249.495n 0.0v 1249.505n 0.0v 1259.495n 0.0v 1259.505n 1.8v 1269.495n 1.8v 1269.505n 1.8v 1279.495n 1.8v 1279.505n 1.8v 1289.495n 1.8v 1289.505n 1.8v 1299.495n 1.8v 1299.505n 1.8v 1309.495n 1.8v 1309.505n 1.8v 1319.495n 1.8v 1319.505n 1.8v 1329.495n 1.8v 1329.505n 1.8v 1339.495n 1.8v 1339.505n 1.8v 1349.495n 1.8v 1349.505n 1.8v 1359.495n 1.8v 1359.505n 1.8v 1369.495n 1.8v 1369.505n 1.8v 1379.495n 1.8v 1379.505n 1.8v 1389.495n 1.8v 1389.505n 0.0v 1399.495n 0.0v 1399.505n 0.0v 1409.495n 0.0v 1409.505n 1.8v 1419.495n 1.8v 1419.505n 1.8v 1429.495n 1.8v 1429.505n 1.8v 1439.495n 1.8v 1439.505n 1.8v 1449.495n 1.8v 1449.505n 1.8v 1459.495n 1.8v 1459.505n 1.8v 1469.495n 1.8v 1469.505n 1.8v 1479.495n 1.8v 1479.505n 0.0v 1489.495n 0.0v 1489.505n 0.0v 1499.495n 0.0v 1499.505n 0.0v 1509.495n 0.0v 1509.505n 1.8v 1519.495n 1.8v 1519.505n 1.8v 1529.495n 1.8v 1529.505n 1.8v 1539.495n 1.8v 1539.505n 1.8v 1549.495n 1.8v 1549.505n 1.8v 1559.495n 1.8v 1559.505n 1.8v 1569.495n 1.8v 1569.505n 1.8v 1579.495n 1.8v 1579.505n 0.0v 1589.495n 0.0v 1589.505n 1.8v 1599.495n 1.8v 1599.505n 1.8v 1609.495n 1.8v 1609.505n 0.0v 1619.495n 0.0v 1619.505n 0.0v 1629.495n 0.0v 1629.505n 0.0v 1639.495n 0.0v 1639.505n 0.0v 1649.495n 0.0v 1649.505n 0.0v 1659.495n 0.0v 1659.505n 0.0v 1669.495n 0.0v 1669.505n 0.0v 1679.495n 0.0v 1679.505n 1.8v 1689.495n 1.8v 1689.505n 1.8v 1699.495n 1.8v 1699.505n 1.8v 1709.495n 1.8v 1709.505n 0.0v 1719.495n 0.0v 1719.505n 0.0v 1729.495n 0.0v 1729.505n 0.0v 1739.495n 0.0v 1739.505n 0.0v 1749.495n 0.0v 1749.505n 0.0v 1759.495n 0.0v 1759.505n 0.0v 1769.495n 0.0v 1769.505n 0.0v 1779.495n 0.0v 1779.505n 0.0v 1789.495n 0.0v 1789.505n 0.0v 1799.495n 0.0v 1799.505n 1.8v 1809.495n 1.8v 1809.505n 1.8v 1819.495n 1.8v 1819.505n 1.8v 1829.495n 1.8v 1829.505n 1.8v 1839.495n 1.8v 1839.505n 0.0v 1849.495n 0.0v 1849.505n 0.0v 1859.495n 0.0v 1859.505n 0.0v 1869.495n 0.0v 1869.505n 0.0v 1879.495n 0.0v 1879.505n 0.0v 1889.495n 0.0v 1889.505n 0.0v 1899.495n 0.0v 1899.505n 1.8v 1909.495n 1.8v 1909.505n 1.8v 1919.495n 1.8v 1919.505n 1.8v 1929.495n 1.8v 1929.505n 1.8v 1939.495n 1.8v 1939.505n 0.0v 1949.495n 0.0v 1949.505n 1.8v 1959.495n 1.8v 1959.505n 1.8v 1969.495n 1.8v 1969.505n 1.8v 1979.495n 1.8v 1979.505n 1.8v 1989.495n 1.8v 1989.505n 1.8v 1999.495n 1.8v 1999.505n 1.8v 2009.495n 1.8v 2009.505n 1.8v 2019.495n 1.8v 2019.505n 1.8v 2029.495n 1.8v 2029.505n 1.8v 2039.495n 1.8v 2039.505n 0.0v 2049.495n 0.0v 2049.505n 0.0v )
* (time, data): [(0, 0), (10, 0), (20, 0), (30, 0), (40, 0), (50, 0), (60, 0), (70, 0), (80, 1), (90, 1), (100, 1), (110, 1), (120, 1), (130, 1), (140, 1), (150, 1), (160, 1), (170, 0), (180, 0), (190, 0), (200, 1), (210, 1), (220, 1), (230, 1), (240, 1), (250, 1), (260, 1), (270, 0), (280, 0), (290, 0), (300, 0), (310, 1), (320, 1), (330, 1), (340, 1), (350, 1), (360, 1), (370, 1), (380, 1), (390, 0), (400, 1), (410, 1), (420, 1), (430, 0), (440, 0), (450, 0), (460, 0), (470, 0), (480, 0), (490, 0), (500, 1), (510, 1), (520, 1), (530, 0), (540, 0), (550, 0), (560, 0), (570, 0), (580, 0), (590, 0), (600, 1), (610, 1), (620, 1), (630, 1), (640, 1), (650, 1), (660, 1), (670, 1), (680, 1), (690, 1), (700, 1), (710, 1), (720, 1), (730, 1), (740, 1), (750, 1), (760, 0), (770, 0), (780, 0), (790, 0), (800, 0), (810, 0), (820, 0), (830, 0), (840, 0), (850, 0), (860, 0), (870, 0), (880, 0), (890, 0), (900, 0), (910, 0), (920, 1), (930, 1), (940, 1), (950, 1), (960, 1), (970, 1), (980, 1), (990, 1), (1000, 0), (1010, 0), (1020, 0), (1030, 0), (1040, 1), (1050, 1), (1060, 0), (1070, 0), (1080, 0), (1090, 0), (1100, 1), (1110, 1), (1120, 0), (1130, 1), (1140, 1), (1150, 0), (1160, 0), (1170, 0), (1180, 0), (1190, 0), (1200, 0), (1210, 1), (1220, 0), (1230, 0), (1240, 0), (1250, 1), (1260, 1), (1270, 1), (1280, 1), (1290, 1), (1300, 1), (1310, 1), (1320, 1), (1330, 1), (1340, 0), (1350, 1), (1360, 1), (1370, 1), (1380, 1), (1390, 1), (1400, 1), (1410, 0), (1420, 0), (1430, 0), (1440, 0), (1450, 0), (1460, 0), (1470, 0), (1480, 1), (1490, 1), (1500, 1), (1510, 1), (1520, 1), (1530, 0), (1540, 0), (1550, 1), (1560, 1), (1570, 0), (1580, 0), (1590, 1), (1600, 1), (1610, 1), (1620, 1), (1630, 1), (1640, 1), (1650, 1), (1660, 1), (1670, 1), (1680, 1), (1690, 0), (1700, 0), (1710, 0), (1720, 0), (1730, 0), (1740, 0), (1750, 0), (1760, 0), (1770, 0), (1780, 1), (1790, 1), (1800, 0), (1810, 0), (1820, 0), (1830, 0), (1840, 0), (1850, 1), (1860, 1), (1870, 1), (1880, 1), (1890, 1), (1900, 1), (1910, 1), (1920, 1), (1930, 1), (1940, 0), (1950, 1), (1960, 1), (1970, 1), (1980, 1), (1990, 1), (2000, 1), (2010, 1), (2020, 1), (2030, 1), (2040, 0), (2050, 0)]
Vdin0_17  din0_17  0 PWL (0n 0.0v 9.495n 0.0v 9.505n 0.0v 19.495n 0.0v 19.505n 0.0v 29.495n 0.0v 29.505n 0.0v 39.495n 0.0v 39.505n 0.0v 49.495n 0.0v 49.505n 0.0v 59.495n 0.0v 59.505n 0.0v 69.495n 0.0v 69.505n 0.0v 79.495n 0.0v 79.505n 1.8v 89.495n 1.8v 89.505n 1.8v 99.495n 1.8v 99.505n 1.8v 109.495n 1.8v 109.505n 1.8v 119.495n 1.8v 119.505n 1.8v 129.495n 1.8v 129.505n 1.8v 139.495n 1.8v 139.505n 1.8v 149.495n 1.8v 149.505n 1.8v 159.495n 1.8v 159.505n 1.8v 169.495n 1.8v 169.505n 0.0v 179.495n 0.0v 179.505n 0.0v 189.495n 0.0v 189.505n 0.0v 199.495n 0.0v 199.505n 1.8v 209.495n 1.8v 209.505n 1.8v 219.495n 1.8v 219.505n 1.8v 229.495n 1.8v 229.505n 1.8v 239.495n 1.8v 239.505n 1.8v 249.495n 1.8v 249.505n 1.8v 259.495n 1.8v 259.505n 1.8v 269.495n 1.8v 269.505n 0.0v 279.495n 0.0v 279.505n 0.0v 289.495n 0.0v 289.505n 0.0v 299.495n 0.0v 299.505n 0.0v 309.495n 0.0v 309.505n 1.8v 319.495n 1.8v 319.505n 1.8v 329.495n 1.8v 329.505n 1.8v 339.495n 1.8v 339.505n 1.8v 349.495n 1.8v 349.505n 1.8v 359.495n 1.8v 359.505n 1.8v 369.495n 1.8v 369.505n 1.8v 379.495n 1.8v 379.505n 1.8v 389.495n 1.8v 389.505n 0.0v 399.495n 0.0v 399.505n 1.8v 409.495n 1.8v 409.505n 1.8v 419.495n 1.8v 419.505n 1.8v 429.495n 1.8v 429.505n 0.0v 439.495n 0.0v 439.505n 0.0v 449.495n 0.0v 449.505n 0.0v 459.495n 0.0v 459.505n 0.0v 469.495n 0.0v 469.505n 0.0v 479.495n 0.0v 479.505n 0.0v 489.495n 0.0v 489.505n 0.0v 499.495n 0.0v 499.505n 1.8v 509.495n 1.8v 509.505n 1.8v 519.495n 1.8v 519.505n 1.8v 529.495n 1.8v 529.505n 0.0v 539.495n 0.0v 539.505n 0.0v 549.495n 0.0v 549.505n 0.0v 559.495n 0.0v 559.505n 0.0v 569.495n 0.0v 569.505n 0.0v 579.495n 0.0v 579.505n 0.0v 589.495n 0.0v 589.505n 0.0v 599.495n 0.0v 599.505n 1.8v 609.495n 1.8v 609.505n 1.8v 619.495n 1.8v 619.505n 1.8v 629.495n 1.8v 629.505n 1.8v 639.495n 1.8v 639.505n 1.8v 649.495n 1.8v 649.505n 1.8v 659.495n 1.8v 659.505n 1.8v 669.495n 1.8v 669.505n 1.8v 679.495n 1.8v 679.505n 1.8v 689.495n 1.8v 689.505n 1.8v 699.495n 1.8v 699.505n 1.8v 709.495n 1.8v 709.505n 1.8v 719.495n 1.8v 719.505n 1.8v 729.495n 1.8v 729.505n 1.8v 739.495n 1.8v 739.505n 1.8v 749.495n 1.8v 749.505n 1.8v 759.495n 1.8v 759.505n 0.0v 769.495n 0.0v 769.505n 0.0v 779.495n 0.0v 779.505n 0.0v 789.495n 0.0v 789.505n 0.0v 799.495n 0.0v 799.505n 0.0v 809.495n 0.0v 809.505n 0.0v 819.495n 0.0v 819.505n 0.0v 829.495n 0.0v 829.505n 0.0v 839.495n 0.0v 839.505n 0.0v 849.495n 0.0v 849.505n 0.0v 859.495n 0.0v 859.505n 0.0v 869.495n 0.0v 869.505n 0.0v 879.495n 0.0v 879.505n 0.0v 889.495n 0.0v 889.505n 0.0v 899.495n 0.0v 899.505n 0.0v 909.495n 0.0v 909.505n 0.0v 919.495n 0.0v 919.505n 1.8v 929.495n 1.8v 929.505n 1.8v 939.495n 1.8v 939.505n 1.8v 949.495n 1.8v 949.505n 1.8v 959.495n 1.8v 959.505n 1.8v 969.495n 1.8v 969.505n 1.8v 979.495n 1.8v 979.505n 1.8v 989.495n 1.8v 989.505n 1.8v 999.495n 1.8v 999.505n 0.0v 1009.495n 0.0v 1009.505n 0.0v 1019.495n 0.0v 1019.505n 0.0v 1029.495n 0.0v 1029.505n 0.0v 1039.495n 0.0v 1039.505n 1.8v 1049.495n 1.8v 1049.505n 1.8v 1059.495n 1.8v 1059.505n 0.0v 1069.495n 0.0v 1069.505n 0.0v 1079.495n 0.0v 1079.505n 0.0v 1089.495n 0.0v 1089.505n 0.0v 1099.495n 0.0v 1099.505n 1.8v 1109.495n 1.8v 1109.505n 1.8v 1119.495n 1.8v 1119.505n 0.0v 1129.495n 0.0v 1129.505n 1.8v 1139.495n 1.8v 1139.505n 1.8v 1149.495n 1.8v 1149.505n 0.0v 1159.495n 0.0v 1159.505n 0.0v 1169.495n 0.0v 1169.505n 0.0v 1179.495n 0.0v 1179.505n 0.0v 1189.495n 0.0v 1189.505n 0.0v 1199.495n 0.0v 1199.505n 0.0v 1209.495n 0.0v 1209.505n 1.8v 1219.495n 1.8v 1219.505n 0.0v 1229.495n 0.0v 1229.505n 0.0v 1239.495n 0.0v 1239.505n 0.0v 1249.495n 0.0v 1249.505n 1.8v 1259.495n 1.8v 1259.505n 1.8v 1269.495n 1.8v 1269.505n 1.8v 1279.495n 1.8v 1279.505n 1.8v 1289.495n 1.8v 1289.505n 1.8v 1299.495n 1.8v 1299.505n 1.8v 1309.495n 1.8v 1309.505n 1.8v 1319.495n 1.8v 1319.505n 1.8v 1329.495n 1.8v 1329.505n 1.8v 1339.495n 1.8v 1339.505n 0.0v 1349.495n 0.0v 1349.505n 1.8v 1359.495n 1.8v 1359.505n 1.8v 1369.495n 1.8v 1369.505n 1.8v 1379.495n 1.8v 1379.505n 1.8v 1389.495n 1.8v 1389.505n 1.8v 1399.495n 1.8v 1399.505n 1.8v 1409.495n 1.8v 1409.505n 0.0v 1419.495n 0.0v 1419.505n 0.0v 1429.495n 0.0v 1429.505n 0.0v 1439.495n 0.0v 1439.505n 0.0v 1449.495n 0.0v 1449.505n 0.0v 1459.495n 0.0v 1459.505n 0.0v 1469.495n 0.0v 1469.505n 0.0v 1479.495n 0.0v 1479.505n 1.8v 1489.495n 1.8v 1489.505n 1.8v 1499.495n 1.8v 1499.505n 1.8v 1509.495n 1.8v 1509.505n 1.8v 1519.495n 1.8v 1519.505n 1.8v 1529.495n 1.8v 1529.505n 0.0v 1539.495n 0.0v 1539.505n 0.0v 1549.495n 0.0v 1549.505n 1.8v 1559.495n 1.8v 1559.505n 1.8v 1569.495n 1.8v 1569.505n 0.0v 1579.495n 0.0v 1579.505n 0.0v 1589.495n 0.0v 1589.505n 1.8v 1599.495n 1.8v 1599.505n 1.8v 1609.495n 1.8v 1609.505n 1.8v 1619.495n 1.8v 1619.505n 1.8v 1629.495n 1.8v 1629.505n 1.8v 1639.495n 1.8v 1639.505n 1.8v 1649.495n 1.8v 1649.505n 1.8v 1659.495n 1.8v 1659.505n 1.8v 1669.495n 1.8v 1669.505n 1.8v 1679.495n 1.8v 1679.505n 1.8v 1689.495n 1.8v 1689.505n 0.0v 1699.495n 0.0v 1699.505n 0.0v 1709.495n 0.0v 1709.505n 0.0v 1719.495n 0.0v 1719.505n 0.0v 1729.495n 0.0v 1729.505n 0.0v 1739.495n 0.0v 1739.505n 0.0v 1749.495n 0.0v 1749.505n 0.0v 1759.495n 0.0v 1759.505n 0.0v 1769.495n 0.0v 1769.505n 0.0v 1779.495n 0.0v 1779.505n 1.8v 1789.495n 1.8v 1789.505n 1.8v 1799.495n 1.8v 1799.505n 0.0v 1809.495n 0.0v 1809.505n 0.0v 1819.495n 0.0v 1819.505n 0.0v 1829.495n 0.0v 1829.505n 0.0v 1839.495n 0.0v 1839.505n 0.0v 1849.495n 0.0v 1849.505n 1.8v 1859.495n 1.8v 1859.505n 1.8v 1869.495n 1.8v 1869.505n 1.8v 1879.495n 1.8v 1879.505n 1.8v 1889.495n 1.8v 1889.505n 1.8v 1899.495n 1.8v 1899.505n 1.8v 1909.495n 1.8v 1909.505n 1.8v 1919.495n 1.8v 1919.505n 1.8v 1929.495n 1.8v 1929.505n 1.8v 1939.495n 1.8v 1939.505n 0.0v 1949.495n 0.0v 1949.505n 1.8v 1959.495n 1.8v 1959.505n 1.8v 1969.495n 1.8v 1969.505n 1.8v 1979.495n 1.8v 1979.505n 1.8v 1989.495n 1.8v 1989.505n 1.8v 1999.495n 1.8v 1999.505n 1.8v 2009.495n 1.8v 2009.505n 1.8v 2019.495n 1.8v 2019.505n 1.8v 2029.495n 1.8v 2029.505n 1.8v 2039.495n 1.8v 2039.505n 0.0v 2049.495n 0.0v 2049.505n 0.0v )
* (time, data): [(0, 0), (10, 0), (20, 1), (30, 0), (40, 0), (50, 0), (60, 0), (70, 0), (80, 1), (90, 1), (100, 1), (110, 0), (120, 0), (130, 0), (140, 0), (150, 0), (160, 0), (170, 0), (180, 0), (190, 0), (200, 0), (210, 0), (220, 0), (230, 0), (240, 1), (250, 1), (260, 1), (270, 1), (280, 1), (290, 1), (300, 1), (310, 0), (320, 1), (330, 1), (340, 1), (350, 1), (360, 1), (370, 1), (380, 1), (390, 0), (400, 0), (410, 0), (420, 0), (430, 0), (440, 0), (450, 0), (460, 0), (470, 0), (480, 0), (490, 0), (500, 1), (510, 1), (520, 1), (530, 1), (540, 0), (550, 0), (560, 0), (570, 0), (580, 0), (590, 0), (600, 0), (610, 0), (620, 1), (630, 1), (640, 1), (650, 0), (660, 0), (670, 1), (680, 1), (690, 1), (700, 1), (710, 1), (720, 1), (730, 1), (740, 0), (750, 1), (760, 0), (770, 1), (780, 1), (790, 1), (800, 1), (810, 1), (820, 1), (830, 1), (840, 1), (850, 1), (860, 0), (870, 0), (880, 0), (890, 0), (900, 1), (910, 0), (920, 0), (930, 0), (940, 0), (950, 0), (960, 0), (970, 0), (980, 0), (990, 1), (1000, 1), (1010, 1), (1020, 1), (1030, 1), (1040, 1), (1050, 1), (1060, 0), (1070, 0), (1080, 0), (1090, 0), (1100, 1), (1110, 1), (1120, 1), (1130, 1), (1140, 1), (1150, 1), (1160, 1), (1170, 1), (1180, 1), (1190, 1), (1200, 1), (1210, 1), (1220, 1), (1230, 0), (1240, 0), (1250, 1), (1260, 0), (1270, 0), (1280, 0), (1290, 0), (1300, 0), (1310, 0), (1320, 0), (1330, 0), (1340, 0), (1350, 0), (1360, 0), (1370, 0), (1380, 0), (1390, 0), (1400, 0), (1410, 0), (1420, 1), (1430, 1), (1440, 1), (1450, 1), (1460, 1), (1470, 1), (1480, 0), (1490, 0), (1500, 0), (1510, 1), (1520, 1), (1530, 0), (1540, 0), (1550, 1), (1560, 1), (1570, 1), (1580, 1), (1590, 0), (1600, 0), (1610, 0), (1620, 0), (1630, 0), (1640, 0), (1650, 0), (1660, 1), (1670, 1), (1680, 1), (1690, 0), (1700, 0), (1710, 0), (1720, 0), (1730, 1), (1740, 1), (1750, 1), (1760, 1), (1770, 1), (1780, 1), (1790, 1), (1800, 1), (1810, 1), (1820, 1), (1830, 1), (1840, 0), (1850, 0), (1860, 0), (1870, 0), (1880, 0), (1890, 0), (1900, 0), (1910, 0), (1920, 0), (1930, 0), (1940, 0), (1950, 0), (1960, 0), (1970, 0), (1980, 0), (1990, 1), (2000, 1), (2010, 1), (2020, 1), (2030, 1), (2040, 1), (2050, 1)]
Vdin0_18  din0_18  0 PWL (0n 0.0v 9.495n 0.0v 9.505n 0.0v 19.495n 0.0v 19.505n 1.8v 29.495n 1.8v 29.505n 0.0v 39.495n 0.0v 39.505n 0.0v 49.495n 0.0v 49.505n 0.0v 59.495n 0.0v 59.505n 0.0v 69.495n 0.0v 69.505n 0.0v 79.495n 0.0v 79.505n 1.8v 89.495n 1.8v 89.505n 1.8v 99.495n 1.8v 99.505n 1.8v 109.495n 1.8v 109.505n 0.0v 119.495n 0.0v 119.505n 0.0v 129.495n 0.0v 129.505n 0.0v 139.495n 0.0v 139.505n 0.0v 149.495n 0.0v 149.505n 0.0v 159.495n 0.0v 159.505n 0.0v 169.495n 0.0v 169.505n 0.0v 179.495n 0.0v 179.505n 0.0v 189.495n 0.0v 189.505n 0.0v 199.495n 0.0v 199.505n 0.0v 209.495n 0.0v 209.505n 0.0v 219.495n 0.0v 219.505n 0.0v 229.495n 0.0v 229.505n 0.0v 239.495n 0.0v 239.505n 1.8v 249.495n 1.8v 249.505n 1.8v 259.495n 1.8v 259.505n 1.8v 269.495n 1.8v 269.505n 1.8v 279.495n 1.8v 279.505n 1.8v 289.495n 1.8v 289.505n 1.8v 299.495n 1.8v 299.505n 1.8v 309.495n 1.8v 309.505n 0.0v 319.495n 0.0v 319.505n 1.8v 329.495n 1.8v 329.505n 1.8v 339.495n 1.8v 339.505n 1.8v 349.495n 1.8v 349.505n 1.8v 359.495n 1.8v 359.505n 1.8v 369.495n 1.8v 369.505n 1.8v 379.495n 1.8v 379.505n 1.8v 389.495n 1.8v 389.505n 0.0v 399.495n 0.0v 399.505n 0.0v 409.495n 0.0v 409.505n 0.0v 419.495n 0.0v 419.505n 0.0v 429.495n 0.0v 429.505n 0.0v 439.495n 0.0v 439.505n 0.0v 449.495n 0.0v 449.505n 0.0v 459.495n 0.0v 459.505n 0.0v 469.495n 0.0v 469.505n 0.0v 479.495n 0.0v 479.505n 0.0v 489.495n 0.0v 489.505n 0.0v 499.495n 0.0v 499.505n 1.8v 509.495n 1.8v 509.505n 1.8v 519.495n 1.8v 519.505n 1.8v 529.495n 1.8v 529.505n 1.8v 539.495n 1.8v 539.505n 0.0v 549.495n 0.0v 549.505n 0.0v 559.495n 0.0v 559.505n 0.0v 569.495n 0.0v 569.505n 0.0v 579.495n 0.0v 579.505n 0.0v 589.495n 0.0v 589.505n 0.0v 599.495n 0.0v 599.505n 0.0v 609.495n 0.0v 609.505n 0.0v 619.495n 0.0v 619.505n 1.8v 629.495n 1.8v 629.505n 1.8v 639.495n 1.8v 639.505n 1.8v 649.495n 1.8v 649.505n 0.0v 659.495n 0.0v 659.505n 0.0v 669.495n 0.0v 669.505n 1.8v 679.495n 1.8v 679.505n 1.8v 689.495n 1.8v 689.505n 1.8v 699.495n 1.8v 699.505n 1.8v 709.495n 1.8v 709.505n 1.8v 719.495n 1.8v 719.505n 1.8v 729.495n 1.8v 729.505n 1.8v 739.495n 1.8v 739.505n 0.0v 749.495n 0.0v 749.505n 1.8v 759.495n 1.8v 759.505n 0.0v 769.495n 0.0v 769.505n 1.8v 779.495n 1.8v 779.505n 1.8v 789.495n 1.8v 789.505n 1.8v 799.495n 1.8v 799.505n 1.8v 809.495n 1.8v 809.505n 1.8v 819.495n 1.8v 819.505n 1.8v 829.495n 1.8v 829.505n 1.8v 839.495n 1.8v 839.505n 1.8v 849.495n 1.8v 849.505n 1.8v 859.495n 1.8v 859.505n 0.0v 869.495n 0.0v 869.505n 0.0v 879.495n 0.0v 879.505n 0.0v 889.495n 0.0v 889.505n 0.0v 899.495n 0.0v 899.505n 1.8v 909.495n 1.8v 909.505n 0.0v 919.495n 0.0v 919.505n 0.0v 929.495n 0.0v 929.505n 0.0v 939.495n 0.0v 939.505n 0.0v 949.495n 0.0v 949.505n 0.0v 959.495n 0.0v 959.505n 0.0v 969.495n 0.0v 969.505n 0.0v 979.495n 0.0v 979.505n 0.0v 989.495n 0.0v 989.505n 1.8v 999.495n 1.8v 999.505n 1.8v 1009.495n 1.8v 1009.505n 1.8v 1019.495n 1.8v 1019.505n 1.8v 1029.495n 1.8v 1029.505n 1.8v 1039.495n 1.8v 1039.505n 1.8v 1049.495n 1.8v 1049.505n 1.8v 1059.495n 1.8v 1059.505n 0.0v 1069.495n 0.0v 1069.505n 0.0v 1079.495n 0.0v 1079.505n 0.0v 1089.495n 0.0v 1089.505n 0.0v 1099.495n 0.0v 1099.505n 1.8v 1109.495n 1.8v 1109.505n 1.8v 1119.495n 1.8v 1119.505n 1.8v 1129.495n 1.8v 1129.505n 1.8v 1139.495n 1.8v 1139.505n 1.8v 1149.495n 1.8v 1149.505n 1.8v 1159.495n 1.8v 1159.505n 1.8v 1169.495n 1.8v 1169.505n 1.8v 1179.495n 1.8v 1179.505n 1.8v 1189.495n 1.8v 1189.505n 1.8v 1199.495n 1.8v 1199.505n 1.8v 1209.495n 1.8v 1209.505n 1.8v 1219.495n 1.8v 1219.505n 1.8v 1229.495n 1.8v 1229.505n 0.0v 1239.495n 0.0v 1239.505n 0.0v 1249.495n 0.0v 1249.505n 1.8v 1259.495n 1.8v 1259.505n 0.0v 1269.495n 0.0v 1269.505n 0.0v 1279.495n 0.0v 1279.505n 0.0v 1289.495n 0.0v 1289.505n 0.0v 1299.495n 0.0v 1299.505n 0.0v 1309.495n 0.0v 1309.505n 0.0v 1319.495n 0.0v 1319.505n 0.0v 1329.495n 0.0v 1329.505n 0.0v 1339.495n 0.0v 1339.505n 0.0v 1349.495n 0.0v 1349.505n 0.0v 1359.495n 0.0v 1359.505n 0.0v 1369.495n 0.0v 1369.505n 0.0v 1379.495n 0.0v 1379.505n 0.0v 1389.495n 0.0v 1389.505n 0.0v 1399.495n 0.0v 1399.505n 0.0v 1409.495n 0.0v 1409.505n 0.0v 1419.495n 0.0v 1419.505n 1.8v 1429.495n 1.8v 1429.505n 1.8v 1439.495n 1.8v 1439.505n 1.8v 1449.495n 1.8v 1449.505n 1.8v 1459.495n 1.8v 1459.505n 1.8v 1469.495n 1.8v 1469.505n 1.8v 1479.495n 1.8v 1479.505n 0.0v 1489.495n 0.0v 1489.505n 0.0v 1499.495n 0.0v 1499.505n 0.0v 1509.495n 0.0v 1509.505n 1.8v 1519.495n 1.8v 1519.505n 1.8v 1529.495n 1.8v 1529.505n 0.0v 1539.495n 0.0v 1539.505n 0.0v 1549.495n 0.0v 1549.505n 1.8v 1559.495n 1.8v 1559.505n 1.8v 1569.495n 1.8v 1569.505n 1.8v 1579.495n 1.8v 1579.505n 1.8v 1589.495n 1.8v 1589.505n 0.0v 1599.495n 0.0v 1599.505n 0.0v 1609.495n 0.0v 1609.505n 0.0v 1619.495n 0.0v 1619.505n 0.0v 1629.495n 0.0v 1629.505n 0.0v 1639.495n 0.0v 1639.505n 0.0v 1649.495n 0.0v 1649.505n 0.0v 1659.495n 0.0v 1659.505n 1.8v 1669.495n 1.8v 1669.505n 1.8v 1679.495n 1.8v 1679.505n 1.8v 1689.495n 1.8v 1689.505n 0.0v 1699.495n 0.0v 1699.505n 0.0v 1709.495n 0.0v 1709.505n 0.0v 1719.495n 0.0v 1719.505n 0.0v 1729.495n 0.0v 1729.505n 1.8v 1739.495n 1.8v 1739.505n 1.8v 1749.495n 1.8v 1749.505n 1.8v 1759.495n 1.8v 1759.505n 1.8v 1769.495n 1.8v 1769.505n 1.8v 1779.495n 1.8v 1779.505n 1.8v 1789.495n 1.8v 1789.505n 1.8v 1799.495n 1.8v 1799.505n 1.8v 1809.495n 1.8v 1809.505n 1.8v 1819.495n 1.8v 1819.505n 1.8v 1829.495n 1.8v 1829.505n 1.8v 1839.495n 1.8v 1839.505n 0.0v 1849.495n 0.0v 1849.505n 0.0v 1859.495n 0.0v 1859.505n 0.0v 1869.495n 0.0v 1869.505n 0.0v 1879.495n 0.0v 1879.505n 0.0v 1889.495n 0.0v 1889.505n 0.0v 1899.495n 0.0v 1899.505n 0.0v 1909.495n 0.0v 1909.505n 0.0v 1919.495n 0.0v 1919.505n 0.0v 1929.495n 0.0v 1929.505n 0.0v 1939.495n 0.0v 1939.505n 0.0v 1949.495n 0.0v 1949.505n 0.0v 1959.495n 0.0v 1959.505n 0.0v 1969.495n 0.0v 1969.505n 0.0v 1979.495n 0.0v 1979.505n 0.0v 1989.495n 0.0v 1989.505n 1.8v 1999.495n 1.8v 1999.505n 1.8v 2009.495n 1.8v 2009.505n 1.8v 2019.495n 1.8v 2019.505n 1.8v 2029.495n 1.8v 2029.505n 1.8v 2039.495n 1.8v 2039.505n 1.8v 2049.495n 1.8v 2049.505n 1.8v )
* (time, data): [(0, 0), (10, 0), (20, 1), (30, 0), (40, 0), (50, 0), (60, 0), (70, 0), (80, 0), (90, 0), (100, 0), (110, 1), (120, 1), (130, 1), (140, 1), (150, 1), (160, 1), (170, 0), (180, 0), (190, 0), (200, 0), (210, 0), (220, 0), (230, 0), (240, 0), (250, 0), (260, 0), (270, 1), (280, 0), (290, 0), (300, 0), (310, 1), (320, 0), (330, 0), (340, 1), (350, 1), (360, 1), (370, 1), (380, 1), (390, 1), (400, 0), (410, 0), (420, 0), (430, 0), (440, 0), (450, 0), (460, 0), (470, 0), (480, 0), (490, 0), (500, 1), (510, 1), (520, 1), (530, 0), (540, 0), (550, 0), (560, 0), (570, 0), (580, 0), (590, 0), (600, 1), (610, 1), (620, 1), (630, 1), (640, 1), (650, 0), (660, 0), (670, 1), (680, 1), (690, 1), (700, 1), (710, 1), (720, 1), (730, 1), (740, 1), (750, 0), (760, 0), (770, 1), (780, 1), (790, 1), (800, 1), (810, 1), (820, 1), (830, 1), (840, 1), (850, 1), (860, 0), (870, 0), (880, 0), (890, 0), (900, 0), (910, 1), (920, 1), (930, 1), (940, 1), (950, 1), (960, 1), (970, 1), (980, 1), (990, 0), (1000, 1), (1010, 1), (1020, 1), (1030, 1), (1040, 1), (1050, 1), (1060, 1), (1070, 1), (1080, 1), (1090, 1), (1100, 1), (1110, 1), (1120, 1), (1130, 1), (1140, 1), (1150, 1), (1160, 1), (1170, 1), (1180, 1), (1190, 1), (1200, 1), (1210, 1), (1220, 1), (1230, 0), (1240, 1), (1250, 1), (1260, 1), (1270, 1), (1280, 1), (1290, 1), (1300, 1), (1310, 1), (1320, 1), (1330, 1), (1340, 1), (1350, 0), (1360, 0), (1370, 0), (1380, 0), (1390, 0), (1400, 0), (1410, 1), (1420, 0), (1430, 0), (1440, 0), (1450, 0), (1460, 0), (1470, 0), (1480, 1), (1490, 1), (1500, 1), (1510, 1), (1520, 1), (1530, 1), (1540, 1), (1550, 0), (1560, 0), (1570, 1), (1580, 1), (1590, 1), (1600, 1), (1610, 0), (1620, 0), (1630, 0), (1640, 0), (1650, 0), (1660, 0), (1670, 0), (1680, 1), (1690, 0), (1700, 0), (1710, 0), (1720, 0), (1730, 0), (1740, 0), (1750, 0), (1760, 0), (1770, 0), (1780, 0), (1790, 0), (1800, 0), (1810, 0), (1820, 0), (1830, 0), (1840, 0), (1850, 1), (1860, 1), (1870, 1), (1880, 1), (1890, 1), (1900, 0), (1910, 0), (1920, 0), (1930, 0), (1940, 0), (1950, 1), (1960, 1), (1970, 0), (1980, 0), (1990, 0), (2000, 0), (2010, 0), (2020, 0), (2030, 0), (2040, 1), (2050, 1)]
Vdin0_19  din0_19  0 PWL (0n 0.0v 9.495n 0.0v 9.505n 0.0v 19.495n 0.0v 19.505n 1.8v 29.495n 1.8v 29.505n 0.0v 39.495n 0.0v 39.505n 0.0v 49.495n 0.0v 49.505n 0.0v 59.495n 0.0v 59.505n 0.0v 69.495n 0.0v 69.505n 0.0v 79.495n 0.0v 79.505n 0.0v 89.495n 0.0v 89.505n 0.0v 99.495n 0.0v 99.505n 0.0v 109.495n 0.0v 109.505n 1.8v 119.495n 1.8v 119.505n 1.8v 129.495n 1.8v 129.505n 1.8v 139.495n 1.8v 139.505n 1.8v 149.495n 1.8v 149.505n 1.8v 159.495n 1.8v 159.505n 1.8v 169.495n 1.8v 169.505n 0.0v 179.495n 0.0v 179.505n 0.0v 189.495n 0.0v 189.505n 0.0v 199.495n 0.0v 199.505n 0.0v 209.495n 0.0v 209.505n 0.0v 219.495n 0.0v 219.505n 0.0v 229.495n 0.0v 229.505n 0.0v 239.495n 0.0v 239.505n 0.0v 249.495n 0.0v 249.505n 0.0v 259.495n 0.0v 259.505n 0.0v 269.495n 0.0v 269.505n 1.8v 279.495n 1.8v 279.505n 0.0v 289.495n 0.0v 289.505n 0.0v 299.495n 0.0v 299.505n 0.0v 309.495n 0.0v 309.505n 1.8v 319.495n 1.8v 319.505n 0.0v 329.495n 0.0v 329.505n 0.0v 339.495n 0.0v 339.505n 1.8v 349.495n 1.8v 349.505n 1.8v 359.495n 1.8v 359.505n 1.8v 369.495n 1.8v 369.505n 1.8v 379.495n 1.8v 379.505n 1.8v 389.495n 1.8v 389.505n 1.8v 399.495n 1.8v 399.505n 0.0v 409.495n 0.0v 409.505n 0.0v 419.495n 0.0v 419.505n 0.0v 429.495n 0.0v 429.505n 0.0v 439.495n 0.0v 439.505n 0.0v 449.495n 0.0v 449.505n 0.0v 459.495n 0.0v 459.505n 0.0v 469.495n 0.0v 469.505n 0.0v 479.495n 0.0v 479.505n 0.0v 489.495n 0.0v 489.505n 0.0v 499.495n 0.0v 499.505n 1.8v 509.495n 1.8v 509.505n 1.8v 519.495n 1.8v 519.505n 1.8v 529.495n 1.8v 529.505n 0.0v 539.495n 0.0v 539.505n 0.0v 549.495n 0.0v 549.505n 0.0v 559.495n 0.0v 559.505n 0.0v 569.495n 0.0v 569.505n 0.0v 579.495n 0.0v 579.505n 0.0v 589.495n 0.0v 589.505n 0.0v 599.495n 0.0v 599.505n 1.8v 609.495n 1.8v 609.505n 1.8v 619.495n 1.8v 619.505n 1.8v 629.495n 1.8v 629.505n 1.8v 639.495n 1.8v 639.505n 1.8v 649.495n 1.8v 649.505n 0.0v 659.495n 0.0v 659.505n 0.0v 669.495n 0.0v 669.505n 1.8v 679.495n 1.8v 679.505n 1.8v 689.495n 1.8v 689.505n 1.8v 699.495n 1.8v 699.505n 1.8v 709.495n 1.8v 709.505n 1.8v 719.495n 1.8v 719.505n 1.8v 729.495n 1.8v 729.505n 1.8v 739.495n 1.8v 739.505n 1.8v 749.495n 1.8v 749.505n 0.0v 759.495n 0.0v 759.505n 0.0v 769.495n 0.0v 769.505n 1.8v 779.495n 1.8v 779.505n 1.8v 789.495n 1.8v 789.505n 1.8v 799.495n 1.8v 799.505n 1.8v 809.495n 1.8v 809.505n 1.8v 819.495n 1.8v 819.505n 1.8v 829.495n 1.8v 829.505n 1.8v 839.495n 1.8v 839.505n 1.8v 849.495n 1.8v 849.505n 1.8v 859.495n 1.8v 859.505n 0.0v 869.495n 0.0v 869.505n 0.0v 879.495n 0.0v 879.505n 0.0v 889.495n 0.0v 889.505n 0.0v 899.495n 0.0v 899.505n 0.0v 909.495n 0.0v 909.505n 1.8v 919.495n 1.8v 919.505n 1.8v 929.495n 1.8v 929.505n 1.8v 939.495n 1.8v 939.505n 1.8v 949.495n 1.8v 949.505n 1.8v 959.495n 1.8v 959.505n 1.8v 969.495n 1.8v 969.505n 1.8v 979.495n 1.8v 979.505n 1.8v 989.495n 1.8v 989.505n 0.0v 999.495n 0.0v 999.505n 1.8v 1009.495n 1.8v 1009.505n 1.8v 1019.495n 1.8v 1019.505n 1.8v 1029.495n 1.8v 1029.505n 1.8v 1039.495n 1.8v 1039.505n 1.8v 1049.495n 1.8v 1049.505n 1.8v 1059.495n 1.8v 1059.505n 1.8v 1069.495n 1.8v 1069.505n 1.8v 1079.495n 1.8v 1079.505n 1.8v 1089.495n 1.8v 1089.505n 1.8v 1099.495n 1.8v 1099.505n 1.8v 1109.495n 1.8v 1109.505n 1.8v 1119.495n 1.8v 1119.505n 1.8v 1129.495n 1.8v 1129.505n 1.8v 1139.495n 1.8v 1139.505n 1.8v 1149.495n 1.8v 1149.505n 1.8v 1159.495n 1.8v 1159.505n 1.8v 1169.495n 1.8v 1169.505n 1.8v 1179.495n 1.8v 1179.505n 1.8v 1189.495n 1.8v 1189.505n 1.8v 1199.495n 1.8v 1199.505n 1.8v 1209.495n 1.8v 1209.505n 1.8v 1219.495n 1.8v 1219.505n 1.8v 1229.495n 1.8v 1229.505n 0.0v 1239.495n 0.0v 1239.505n 1.8v 1249.495n 1.8v 1249.505n 1.8v 1259.495n 1.8v 1259.505n 1.8v 1269.495n 1.8v 1269.505n 1.8v 1279.495n 1.8v 1279.505n 1.8v 1289.495n 1.8v 1289.505n 1.8v 1299.495n 1.8v 1299.505n 1.8v 1309.495n 1.8v 1309.505n 1.8v 1319.495n 1.8v 1319.505n 1.8v 1329.495n 1.8v 1329.505n 1.8v 1339.495n 1.8v 1339.505n 1.8v 1349.495n 1.8v 1349.505n 0.0v 1359.495n 0.0v 1359.505n 0.0v 1369.495n 0.0v 1369.505n 0.0v 1379.495n 0.0v 1379.505n 0.0v 1389.495n 0.0v 1389.505n 0.0v 1399.495n 0.0v 1399.505n 0.0v 1409.495n 0.0v 1409.505n 1.8v 1419.495n 1.8v 1419.505n 0.0v 1429.495n 0.0v 1429.505n 0.0v 1439.495n 0.0v 1439.505n 0.0v 1449.495n 0.0v 1449.505n 0.0v 1459.495n 0.0v 1459.505n 0.0v 1469.495n 0.0v 1469.505n 0.0v 1479.495n 0.0v 1479.505n 1.8v 1489.495n 1.8v 1489.505n 1.8v 1499.495n 1.8v 1499.505n 1.8v 1509.495n 1.8v 1509.505n 1.8v 1519.495n 1.8v 1519.505n 1.8v 1529.495n 1.8v 1529.505n 1.8v 1539.495n 1.8v 1539.505n 1.8v 1549.495n 1.8v 1549.505n 0.0v 1559.495n 0.0v 1559.505n 0.0v 1569.495n 0.0v 1569.505n 1.8v 1579.495n 1.8v 1579.505n 1.8v 1589.495n 1.8v 1589.505n 1.8v 1599.495n 1.8v 1599.505n 1.8v 1609.495n 1.8v 1609.505n 0.0v 1619.495n 0.0v 1619.505n 0.0v 1629.495n 0.0v 1629.505n 0.0v 1639.495n 0.0v 1639.505n 0.0v 1649.495n 0.0v 1649.505n 0.0v 1659.495n 0.0v 1659.505n 0.0v 1669.495n 0.0v 1669.505n 0.0v 1679.495n 0.0v 1679.505n 1.8v 1689.495n 1.8v 1689.505n 0.0v 1699.495n 0.0v 1699.505n 0.0v 1709.495n 0.0v 1709.505n 0.0v 1719.495n 0.0v 1719.505n 0.0v 1729.495n 0.0v 1729.505n 0.0v 1739.495n 0.0v 1739.505n 0.0v 1749.495n 0.0v 1749.505n 0.0v 1759.495n 0.0v 1759.505n 0.0v 1769.495n 0.0v 1769.505n 0.0v 1779.495n 0.0v 1779.505n 0.0v 1789.495n 0.0v 1789.505n 0.0v 1799.495n 0.0v 1799.505n 0.0v 1809.495n 0.0v 1809.505n 0.0v 1819.495n 0.0v 1819.505n 0.0v 1829.495n 0.0v 1829.505n 0.0v 1839.495n 0.0v 1839.505n 0.0v 1849.495n 0.0v 1849.505n 1.8v 1859.495n 1.8v 1859.505n 1.8v 1869.495n 1.8v 1869.505n 1.8v 1879.495n 1.8v 1879.505n 1.8v 1889.495n 1.8v 1889.505n 1.8v 1899.495n 1.8v 1899.505n 0.0v 1909.495n 0.0v 1909.505n 0.0v 1919.495n 0.0v 1919.505n 0.0v 1929.495n 0.0v 1929.505n 0.0v 1939.495n 0.0v 1939.505n 0.0v 1949.495n 0.0v 1949.505n 1.8v 1959.495n 1.8v 1959.505n 1.8v 1969.495n 1.8v 1969.505n 0.0v 1979.495n 0.0v 1979.505n 0.0v 1989.495n 0.0v 1989.505n 0.0v 1999.495n 0.0v 1999.505n 0.0v 2009.495n 0.0v 2009.505n 0.0v 2019.495n 0.0v 2019.505n 0.0v 2029.495n 0.0v 2029.505n 0.0v 2039.495n 0.0v 2039.505n 1.8v 2049.495n 1.8v 2049.505n 1.8v )
* (time, data): [(0, 0), (10, 0), (20, 0), (30, 0), (40, 0), (50, 0), (60, 0), (70, 0), (80, 0), (90, 0), (100, 0), (110, 1), (120, 1), (130, 1), (140, 1), (150, 1), (160, 1), (170, 1), (180, 1), (190, 1), (200, 0), (210, 0), (220, 0), (230, 0), (240, 0), (250, 0), (260, 0), (270, 0), (280, 1), (290, 1), (300, 1), (310, 1), (320, 1), (330, 1), (340, 1), (350, 1), (360, 1), (370, 1), (380, 1), (390, 0), (400, 0), (410, 1), (420, 1), (430, 1), (440, 1), (450, 1), (460, 1), (470, 1), (480, 1), (490, 1), (500, 1), (510, 0), (520, 0), (530, 0), (540, 0), (550, 0), (560, 0), (570, 0), (580, 0), (590, 0), (600, 1), (610, 1), (620, 0), (630, 0), (640, 0), (650, 1), (660, 1), (670, 0), (680, 0), (690, 0), (700, 0), (710, 0), (720, 0), (730, 0), (740, 1), (750, 0), (760, 1), (770, 0), (780, 0), (790, 0), (800, 0), (810, 0), (820, 0), (830, 0), (840, 0), (850, 0), (860, 1), (870, 1), (880, 1), (890, 1), (900, 1), (910, 1), (920, 1), (930, 1), (940, 1), (950, 1), (960, 1), (970, 1), (980, 1), (990, 0), (1000, 1), (1010, 1), (1020, 1), (1030, 1), (1040, 0), (1050, 0), (1060, 1), (1070, 1), (1080, 1), (1090, 1), (1100, 0), (1110, 0), (1120, 1), (1130, 0), (1140, 0), (1150, 1), (1160, 1), (1170, 1), (1180, 1), (1190, 1), (1200, 1), (1210, 1), (1220, 0), (1230, 1), (1240, 0), (1250, 0), (1260, 1), (1270, 1), (1280, 1), (1290, 1), (1300, 1), (1310, 1), (1320, 1), (1330, 1), (1340, 1), (1350, 1), (1360, 1), (1370, 1), (1380, 1), (1390, 0), (1400, 0), (1410, 1), (1420, 1), (1430, 1), (1440, 1), (1450, 1), (1460, 1), (1470, 1), (1480, 0), (1490, 0), (1500, 0), (1510, 0), (1520, 0), (1530, 1), (1540, 1), (1550, 0), (1560, 0), (1570, 1), (1580, 1), (1590, 0), (1600, 0), (1610, 0), (1620, 0), (1630, 0), (1640, 0), (1650, 0), (1660, 0), (1670, 0), (1680, 0), (1690, 0), (1700, 0), (1710, 0), (1720, 0), (1730, 0), (1740, 0), (1750, 0), (1760, 0), (1770, 0), (1780, 1), (1790, 1), (1800, 0), (1810, 0), (1820, 0), (1830, 0), (1840, 0), (1850, 1), (1860, 1), (1870, 1), (1880, 1), (1890, 1), (1900, 1), (1910, 1), (1920, 1), (1930, 1), (1940, 1), (1950, 1), (1960, 1), (1970, 0), (1980, 0), (1990, 1), (2000, 1), (2010, 1), (2020, 1), (2030, 1), (2040, 0), (2050, 0)]
Vdin0_20  din0_20  0 PWL (0n 0.0v 9.495n 0.0v 9.505n 0.0v 19.495n 0.0v 19.505n 0.0v 29.495n 0.0v 29.505n 0.0v 39.495n 0.0v 39.505n 0.0v 49.495n 0.0v 49.505n 0.0v 59.495n 0.0v 59.505n 0.0v 69.495n 0.0v 69.505n 0.0v 79.495n 0.0v 79.505n 0.0v 89.495n 0.0v 89.505n 0.0v 99.495n 0.0v 99.505n 0.0v 109.495n 0.0v 109.505n 1.8v 119.495n 1.8v 119.505n 1.8v 129.495n 1.8v 129.505n 1.8v 139.495n 1.8v 139.505n 1.8v 149.495n 1.8v 149.505n 1.8v 159.495n 1.8v 159.505n 1.8v 169.495n 1.8v 169.505n 1.8v 179.495n 1.8v 179.505n 1.8v 189.495n 1.8v 189.505n 1.8v 199.495n 1.8v 199.505n 0.0v 209.495n 0.0v 209.505n 0.0v 219.495n 0.0v 219.505n 0.0v 229.495n 0.0v 229.505n 0.0v 239.495n 0.0v 239.505n 0.0v 249.495n 0.0v 249.505n 0.0v 259.495n 0.0v 259.505n 0.0v 269.495n 0.0v 269.505n 0.0v 279.495n 0.0v 279.505n 1.8v 289.495n 1.8v 289.505n 1.8v 299.495n 1.8v 299.505n 1.8v 309.495n 1.8v 309.505n 1.8v 319.495n 1.8v 319.505n 1.8v 329.495n 1.8v 329.505n 1.8v 339.495n 1.8v 339.505n 1.8v 349.495n 1.8v 349.505n 1.8v 359.495n 1.8v 359.505n 1.8v 369.495n 1.8v 369.505n 1.8v 379.495n 1.8v 379.505n 1.8v 389.495n 1.8v 389.505n 0.0v 399.495n 0.0v 399.505n 0.0v 409.495n 0.0v 409.505n 1.8v 419.495n 1.8v 419.505n 1.8v 429.495n 1.8v 429.505n 1.8v 439.495n 1.8v 439.505n 1.8v 449.495n 1.8v 449.505n 1.8v 459.495n 1.8v 459.505n 1.8v 469.495n 1.8v 469.505n 1.8v 479.495n 1.8v 479.505n 1.8v 489.495n 1.8v 489.505n 1.8v 499.495n 1.8v 499.505n 1.8v 509.495n 1.8v 509.505n 0.0v 519.495n 0.0v 519.505n 0.0v 529.495n 0.0v 529.505n 0.0v 539.495n 0.0v 539.505n 0.0v 549.495n 0.0v 549.505n 0.0v 559.495n 0.0v 559.505n 0.0v 569.495n 0.0v 569.505n 0.0v 579.495n 0.0v 579.505n 0.0v 589.495n 0.0v 589.505n 0.0v 599.495n 0.0v 599.505n 1.8v 609.495n 1.8v 609.505n 1.8v 619.495n 1.8v 619.505n 0.0v 629.495n 0.0v 629.505n 0.0v 639.495n 0.0v 639.505n 0.0v 649.495n 0.0v 649.505n 1.8v 659.495n 1.8v 659.505n 1.8v 669.495n 1.8v 669.505n 0.0v 679.495n 0.0v 679.505n 0.0v 689.495n 0.0v 689.505n 0.0v 699.495n 0.0v 699.505n 0.0v 709.495n 0.0v 709.505n 0.0v 719.495n 0.0v 719.505n 0.0v 729.495n 0.0v 729.505n 0.0v 739.495n 0.0v 739.505n 1.8v 749.495n 1.8v 749.505n 0.0v 759.495n 0.0v 759.505n 1.8v 769.495n 1.8v 769.505n 0.0v 779.495n 0.0v 779.505n 0.0v 789.495n 0.0v 789.505n 0.0v 799.495n 0.0v 799.505n 0.0v 809.495n 0.0v 809.505n 0.0v 819.495n 0.0v 819.505n 0.0v 829.495n 0.0v 829.505n 0.0v 839.495n 0.0v 839.505n 0.0v 849.495n 0.0v 849.505n 0.0v 859.495n 0.0v 859.505n 1.8v 869.495n 1.8v 869.505n 1.8v 879.495n 1.8v 879.505n 1.8v 889.495n 1.8v 889.505n 1.8v 899.495n 1.8v 899.505n 1.8v 909.495n 1.8v 909.505n 1.8v 919.495n 1.8v 919.505n 1.8v 929.495n 1.8v 929.505n 1.8v 939.495n 1.8v 939.505n 1.8v 949.495n 1.8v 949.505n 1.8v 959.495n 1.8v 959.505n 1.8v 969.495n 1.8v 969.505n 1.8v 979.495n 1.8v 979.505n 1.8v 989.495n 1.8v 989.505n 0.0v 999.495n 0.0v 999.505n 1.8v 1009.495n 1.8v 1009.505n 1.8v 1019.495n 1.8v 1019.505n 1.8v 1029.495n 1.8v 1029.505n 1.8v 1039.495n 1.8v 1039.505n 0.0v 1049.495n 0.0v 1049.505n 0.0v 1059.495n 0.0v 1059.505n 1.8v 1069.495n 1.8v 1069.505n 1.8v 1079.495n 1.8v 1079.505n 1.8v 1089.495n 1.8v 1089.505n 1.8v 1099.495n 1.8v 1099.505n 0.0v 1109.495n 0.0v 1109.505n 0.0v 1119.495n 0.0v 1119.505n 1.8v 1129.495n 1.8v 1129.505n 0.0v 1139.495n 0.0v 1139.505n 0.0v 1149.495n 0.0v 1149.505n 1.8v 1159.495n 1.8v 1159.505n 1.8v 1169.495n 1.8v 1169.505n 1.8v 1179.495n 1.8v 1179.505n 1.8v 1189.495n 1.8v 1189.505n 1.8v 1199.495n 1.8v 1199.505n 1.8v 1209.495n 1.8v 1209.505n 1.8v 1219.495n 1.8v 1219.505n 0.0v 1229.495n 0.0v 1229.505n 1.8v 1239.495n 1.8v 1239.505n 0.0v 1249.495n 0.0v 1249.505n 0.0v 1259.495n 0.0v 1259.505n 1.8v 1269.495n 1.8v 1269.505n 1.8v 1279.495n 1.8v 1279.505n 1.8v 1289.495n 1.8v 1289.505n 1.8v 1299.495n 1.8v 1299.505n 1.8v 1309.495n 1.8v 1309.505n 1.8v 1319.495n 1.8v 1319.505n 1.8v 1329.495n 1.8v 1329.505n 1.8v 1339.495n 1.8v 1339.505n 1.8v 1349.495n 1.8v 1349.505n 1.8v 1359.495n 1.8v 1359.505n 1.8v 1369.495n 1.8v 1369.505n 1.8v 1379.495n 1.8v 1379.505n 1.8v 1389.495n 1.8v 1389.505n 0.0v 1399.495n 0.0v 1399.505n 0.0v 1409.495n 0.0v 1409.505n 1.8v 1419.495n 1.8v 1419.505n 1.8v 1429.495n 1.8v 1429.505n 1.8v 1439.495n 1.8v 1439.505n 1.8v 1449.495n 1.8v 1449.505n 1.8v 1459.495n 1.8v 1459.505n 1.8v 1469.495n 1.8v 1469.505n 1.8v 1479.495n 1.8v 1479.505n 0.0v 1489.495n 0.0v 1489.505n 0.0v 1499.495n 0.0v 1499.505n 0.0v 1509.495n 0.0v 1509.505n 0.0v 1519.495n 0.0v 1519.505n 0.0v 1529.495n 0.0v 1529.505n 1.8v 1539.495n 1.8v 1539.505n 1.8v 1549.495n 1.8v 1549.505n 0.0v 1559.495n 0.0v 1559.505n 0.0v 1569.495n 0.0v 1569.505n 1.8v 1579.495n 1.8v 1579.505n 1.8v 1589.495n 1.8v 1589.505n 0.0v 1599.495n 0.0v 1599.505n 0.0v 1609.495n 0.0v 1609.505n 0.0v 1619.495n 0.0v 1619.505n 0.0v 1629.495n 0.0v 1629.505n 0.0v 1639.495n 0.0v 1639.505n 0.0v 1649.495n 0.0v 1649.505n 0.0v 1659.495n 0.0v 1659.505n 0.0v 1669.495n 0.0v 1669.505n 0.0v 1679.495n 0.0v 1679.505n 0.0v 1689.495n 0.0v 1689.505n 0.0v 1699.495n 0.0v 1699.505n 0.0v 1709.495n 0.0v 1709.505n 0.0v 1719.495n 0.0v 1719.505n 0.0v 1729.495n 0.0v 1729.505n 0.0v 1739.495n 0.0v 1739.505n 0.0v 1749.495n 0.0v 1749.505n 0.0v 1759.495n 0.0v 1759.505n 0.0v 1769.495n 0.0v 1769.505n 0.0v 1779.495n 0.0v 1779.505n 1.8v 1789.495n 1.8v 1789.505n 1.8v 1799.495n 1.8v 1799.505n 0.0v 1809.495n 0.0v 1809.505n 0.0v 1819.495n 0.0v 1819.505n 0.0v 1829.495n 0.0v 1829.505n 0.0v 1839.495n 0.0v 1839.505n 0.0v 1849.495n 0.0v 1849.505n 1.8v 1859.495n 1.8v 1859.505n 1.8v 1869.495n 1.8v 1869.505n 1.8v 1879.495n 1.8v 1879.505n 1.8v 1889.495n 1.8v 1889.505n 1.8v 1899.495n 1.8v 1899.505n 1.8v 1909.495n 1.8v 1909.505n 1.8v 1919.495n 1.8v 1919.505n 1.8v 1929.495n 1.8v 1929.505n 1.8v 1939.495n 1.8v 1939.505n 1.8v 1949.495n 1.8v 1949.505n 1.8v 1959.495n 1.8v 1959.505n 1.8v 1969.495n 1.8v 1969.505n 0.0v 1979.495n 0.0v 1979.505n 0.0v 1989.495n 0.0v 1989.505n 1.8v 1999.495n 1.8v 1999.505n 1.8v 2009.495n 1.8v 2009.505n 1.8v 2019.495n 1.8v 2019.505n 1.8v 2029.495n 1.8v 2029.505n 1.8v 2039.495n 1.8v 2039.505n 0.0v 2049.495n 0.0v 2049.505n 0.0v )
* (time, data): [(0, 0), (10, 0), (20, 1), (30, 1), (40, 1), (50, 1), (60, 1), (70, 1), (80, 1), (90, 1), (100, 1), (110, 0), (120, 0), (130, 0), (140, 0), (150, 0), (160, 0), (170, 0), (180, 0), (190, 0), (200, 0), (210, 0), (220, 0), (230, 0), (240, 0), (250, 0), (260, 0), (270, 0), (280, 1), (290, 1), (300, 1), (310, 1), (320, 0), (330, 0), (340, 1), (350, 1), (360, 1), (370, 1), (380, 1), (390, 1), (400, 1), (410, 0), (420, 0), (430, 1), (440, 1), (450, 1), (460, 1), (470, 1), (480, 1), (490, 1), (500, 1), (510, 0), (520, 0), (530, 0), (540, 1), (550, 1), (560, 1), (570, 1), (580, 1), (590, 1), (600, 0), (610, 0), (620, 0), (630, 0), (640, 0), (650, 1), (660, 1), (670, 0), (680, 0), (690, 0), (700, 0), (710, 0), (720, 0), (730, 0), (740, 1), (750, 1), (760, 0), (770, 0), (780, 0), (790, 0), (800, 0), (810, 0), (820, 0), (830, 0), (840, 0), (850, 0), (860, 1), (870, 1), (880, 1), (890, 1), (900, 0), (910, 1), (920, 0), (930, 0), (940, 0), (950, 0), (960, 0), (970, 0), (980, 0), (990, 1), (1000, 1), (1010, 1), (1020, 1), (1030, 1), (1040, 1), (1050, 1), (1060, 1), (1070, 1), (1080, 1), (1090, 1), (1100, 1), (1110, 1), (1120, 0), (1130, 1), (1140, 1), (1150, 1), (1160, 1), (1170, 1), (1180, 1), (1190, 1), (1200, 1), (1210, 0), (1220, 0), (1230, 0), (1240, 0), (1250, 0), (1260, 1), (1270, 1), (1280, 1), (1290, 1), (1300, 1), (1310, 1), (1320, 1), (1330, 1), (1340, 0), (1350, 1), (1360, 1), (1370, 1), (1380, 1), (1390, 1), (1400, 1), (1410, 0), (1420, 1), (1430, 1), (1440, 1), (1450, 1), (1460, 1), (1470, 1), (1480, 1), (1490, 1), (1500, 1), (1510, 0), (1520, 0), (1530, 0), (1540, 0), (1550, 0), (1560, 0), (1570, 1), (1580, 0), (1590, 1), (1600, 1), (1610, 1), (1620, 1), (1630, 1), (1640, 1), (1650, 1), (1660, 1), (1670, 1), (1680, 1), (1690, 0), (1700, 0), (1710, 0), (1720, 0), (1730, 1), (1740, 1), (1750, 1), (1760, 1), (1770, 1), (1780, 1), (1790, 1), (1800, 1), (1810, 1), (1820, 1), (1830, 1), (1840, 0), (1850, 0), (1860, 0), (1870, 0), (1880, 0), (1890, 0), (1900, 1), (1910, 1), (1920, 1), (1930, 1), (1940, 0), (1950, 1), (1960, 1), (1970, 0), (1980, 0), (1990, 0), (2000, 0), (2010, 0), (2020, 0), (2030, 0), (2040, 0), (2050, 0)]
Vdin0_21  din0_21  0 PWL (0n 0.0v 9.495n 0.0v 9.505n 0.0v 19.495n 0.0v 19.505n 1.8v 29.495n 1.8v 29.505n 1.8v 39.495n 1.8v 39.505n 1.8v 49.495n 1.8v 49.505n 1.8v 59.495n 1.8v 59.505n 1.8v 69.495n 1.8v 69.505n 1.8v 79.495n 1.8v 79.505n 1.8v 89.495n 1.8v 89.505n 1.8v 99.495n 1.8v 99.505n 1.8v 109.495n 1.8v 109.505n 0.0v 119.495n 0.0v 119.505n 0.0v 129.495n 0.0v 129.505n 0.0v 139.495n 0.0v 139.505n 0.0v 149.495n 0.0v 149.505n 0.0v 159.495n 0.0v 159.505n 0.0v 169.495n 0.0v 169.505n 0.0v 179.495n 0.0v 179.505n 0.0v 189.495n 0.0v 189.505n 0.0v 199.495n 0.0v 199.505n 0.0v 209.495n 0.0v 209.505n 0.0v 219.495n 0.0v 219.505n 0.0v 229.495n 0.0v 229.505n 0.0v 239.495n 0.0v 239.505n 0.0v 249.495n 0.0v 249.505n 0.0v 259.495n 0.0v 259.505n 0.0v 269.495n 0.0v 269.505n 0.0v 279.495n 0.0v 279.505n 1.8v 289.495n 1.8v 289.505n 1.8v 299.495n 1.8v 299.505n 1.8v 309.495n 1.8v 309.505n 1.8v 319.495n 1.8v 319.505n 0.0v 329.495n 0.0v 329.505n 0.0v 339.495n 0.0v 339.505n 1.8v 349.495n 1.8v 349.505n 1.8v 359.495n 1.8v 359.505n 1.8v 369.495n 1.8v 369.505n 1.8v 379.495n 1.8v 379.505n 1.8v 389.495n 1.8v 389.505n 1.8v 399.495n 1.8v 399.505n 1.8v 409.495n 1.8v 409.505n 0.0v 419.495n 0.0v 419.505n 0.0v 429.495n 0.0v 429.505n 1.8v 439.495n 1.8v 439.505n 1.8v 449.495n 1.8v 449.505n 1.8v 459.495n 1.8v 459.505n 1.8v 469.495n 1.8v 469.505n 1.8v 479.495n 1.8v 479.505n 1.8v 489.495n 1.8v 489.505n 1.8v 499.495n 1.8v 499.505n 1.8v 509.495n 1.8v 509.505n 0.0v 519.495n 0.0v 519.505n 0.0v 529.495n 0.0v 529.505n 0.0v 539.495n 0.0v 539.505n 1.8v 549.495n 1.8v 549.505n 1.8v 559.495n 1.8v 559.505n 1.8v 569.495n 1.8v 569.505n 1.8v 579.495n 1.8v 579.505n 1.8v 589.495n 1.8v 589.505n 1.8v 599.495n 1.8v 599.505n 0.0v 609.495n 0.0v 609.505n 0.0v 619.495n 0.0v 619.505n 0.0v 629.495n 0.0v 629.505n 0.0v 639.495n 0.0v 639.505n 0.0v 649.495n 0.0v 649.505n 1.8v 659.495n 1.8v 659.505n 1.8v 669.495n 1.8v 669.505n 0.0v 679.495n 0.0v 679.505n 0.0v 689.495n 0.0v 689.505n 0.0v 699.495n 0.0v 699.505n 0.0v 709.495n 0.0v 709.505n 0.0v 719.495n 0.0v 719.505n 0.0v 729.495n 0.0v 729.505n 0.0v 739.495n 0.0v 739.505n 1.8v 749.495n 1.8v 749.505n 1.8v 759.495n 1.8v 759.505n 0.0v 769.495n 0.0v 769.505n 0.0v 779.495n 0.0v 779.505n 0.0v 789.495n 0.0v 789.505n 0.0v 799.495n 0.0v 799.505n 0.0v 809.495n 0.0v 809.505n 0.0v 819.495n 0.0v 819.505n 0.0v 829.495n 0.0v 829.505n 0.0v 839.495n 0.0v 839.505n 0.0v 849.495n 0.0v 849.505n 0.0v 859.495n 0.0v 859.505n 1.8v 869.495n 1.8v 869.505n 1.8v 879.495n 1.8v 879.505n 1.8v 889.495n 1.8v 889.505n 1.8v 899.495n 1.8v 899.505n 0.0v 909.495n 0.0v 909.505n 1.8v 919.495n 1.8v 919.505n 0.0v 929.495n 0.0v 929.505n 0.0v 939.495n 0.0v 939.505n 0.0v 949.495n 0.0v 949.505n 0.0v 959.495n 0.0v 959.505n 0.0v 969.495n 0.0v 969.505n 0.0v 979.495n 0.0v 979.505n 0.0v 989.495n 0.0v 989.505n 1.8v 999.495n 1.8v 999.505n 1.8v 1009.495n 1.8v 1009.505n 1.8v 1019.495n 1.8v 1019.505n 1.8v 1029.495n 1.8v 1029.505n 1.8v 1039.495n 1.8v 1039.505n 1.8v 1049.495n 1.8v 1049.505n 1.8v 1059.495n 1.8v 1059.505n 1.8v 1069.495n 1.8v 1069.505n 1.8v 1079.495n 1.8v 1079.505n 1.8v 1089.495n 1.8v 1089.505n 1.8v 1099.495n 1.8v 1099.505n 1.8v 1109.495n 1.8v 1109.505n 1.8v 1119.495n 1.8v 1119.505n 0.0v 1129.495n 0.0v 1129.505n 1.8v 1139.495n 1.8v 1139.505n 1.8v 1149.495n 1.8v 1149.505n 1.8v 1159.495n 1.8v 1159.505n 1.8v 1169.495n 1.8v 1169.505n 1.8v 1179.495n 1.8v 1179.505n 1.8v 1189.495n 1.8v 1189.505n 1.8v 1199.495n 1.8v 1199.505n 1.8v 1209.495n 1.8v 1209.505n 0.0v 1219.495n 0.0v 1219.505n 0.0v 1229.495n 0.0v 1229.505n 0.0v 1239.495n 0.0v 1239.505n 0.0v 1249.495n 0.0v 1249.505n 0.0v 1259.495n 0.0v 1259.505n 1.8v 1269.495n 1.8v 1269.505n 1.8v 1279.495n 1.8v 1279.505n 1.8v 1289.495n 1.8v 1289.505n 1.8v 1299.495n 1.8v 1299.505n 1.8v 1309.495n 1.8v 1309.505n 1.8v 1319.495n 1.8v 1319.505n 1.8v 1329.495n 1.8v 1329.505n 1.8v 1339.495n 1.8v 1339.505n 0.0v 1349.495n 0.0v 1349.505n 1.8v 1359.495n 1.8v 1359.505n 1.8v 1369.495n 1.8v 1369.505n 1.8v 1379.495n 1.8v 1379.505n 1.8v 1389.495n 1.8v 1389.505n 1.8v 1399.495n 1.8v 1399.505n 1.8v 1409.495n 1.8v 1409.505n 0.0v 1419.495n 0.0v 1419.505n 1.8v 1429.495n 1.8v 1429.505n 1.8v 1439.495n 1.8v 1439.505n 1.8v 1449.495n 1.8v 1449.505n 1.8v 1459.495n 1.8v 1459.505n 1.8v 1469.495n 1.8v 1469.505n 1.8v 1479.495n 1.8v 1479.505n 1.8v 1489.495n 1.8v 1489.505n 1.8v 1499.495n 1.8v 1499.505n 1.8v 1509.495n 1.8v 1509.505n 0.0v 1519.495n 0.0v 1519.505n 0.0v 1529.495n 0.0v 1529.505n 0.0v 1539.495n 0.0v 1539.505n 0.0v 1549.495n 0.0v 1549.505n 0.0v 1559.495n 0.0v 1559.505n 0.0v 1569.495n 0.0v 1569.505n 1.8v 1579.495n 1.8v 1579.505n 0.0v 1589.495n 0.0v 1589.505n 1.8v 1599.495n 1.8v 1599.505n 1.8v 1609.495n 1.8v 1609.505n 1.8v 1619.495n 1.8v 1619.505n 1.8v 1629.495n 1.8v 1629.505n 1.8v 1639.495n 1.8v 1639.505n 1.8v 1649.495n 1.8v 1649.505n 1.8v 1659.495n 1.8v 1659.505n 1.8v 1669.495n 1.8v 1669.505n 1.8v 1679.495n 1.8v 1679.505n 1.8v 1689.495n 1.8v 1689.505n 0.0v 1699.495n 0.0v 1699.505n 0.0v 1709.495n 0.0v 1709.505n 0.0v 1719.495n 0.0v 1719.505n 0.0v 1729.495n 0.0v 1729.505n 1.8v 1739.495n 1.8v 1739.505n 1.8v 1749.495n 1.8v 1749.505n 1.8v 1759.495n 1.8v 1759.505n 1.8v 1769.495n 1.8v 1769.505n 1.8v 1779.495n 1.8v 1779.505n 1.8v 1789.495n 1.8v 1789.505n 1.8v 1799.495n 1.8v 1799.505n 1.8v 1809.495n 1.8v 1809.505n 1.8v 1819.495n 1.8v 1819.505n 1.8v 1829.495n 1.8v 1829.505n 1.8v 1839.495n 1.8v 1839.505n 0.0v 1849.495n 0.0v 1849.505n 0.0v 1859.495n 0.0v 1859.505n 0.0v 1869.495n 0.0v 1869.505n 0.0v 1879.495n 0.0v 1879.505n 0.0v 1889.495n 0.0v 1889.505n 0.0v 1899.495n 0.0v 1899.505n 1.8v 1909.495n 1.8v 1909.505n 1.8v 1919.495n 1.8v 1919.505n 1.8v 1929.495n 1.8v 1929.505n 1.8v 1939.495n 1.8v 1939.505n 0.0v 1949.495n 0.0v 1949.505n 1.8v 1959.495n 1.8v 1959.505n 1.8v 1969.495n 1.8v 1969.505n 0.0v 1979.495n 0.0v 1979.505n 0.0v 1989.495n 0.0v 1989.505n 0.0v 1999.495n 0.0v 1999.505n 0.0v 2009.495n 0.0v 2009.505n 0.0v 2019.495n 0.0v 2019.505n 0.0v 2029.495n 0.0v 2029.505n 0.0v 2039.495n 0.0v 2039.505n 0.0v 2049.495n 0.0v 2049.505n 0.0v )
* (time, data): [(0, 0), (10, 1), (20, 0), (30, 1), (40, 1), (50, 1), (60, 1), (70, 1), (80, 1), (90, 1), (100, 1), (110, 1), (120, 1), (130, 1), (140, 1), (150, 1), (160, 1), (170, 1), (180, 1), (190, 1), (200, 1), (210, 1), (220, 1), (230, 1), (240, 0), (250, 0), (260, 0), (270, 0), (280, 0), (290, 0), (300, 0), (310, 0), (320, 1), (330, 1), (340, 0), (350, 0), (360, 0), (370, 0), (380, 0), (390, 0), (400, 1), (410, 1), (420, 1), (430, 1), (440, 1), (450, 1), (460, 1), (470, 1), (480, 1), (490, 1), (500, 0), (510, 1), (520, 1), (530, 1), (540, 1), (550, 1), (560, 1), (570, 1), (580, 1), (590, 1), (600, 0), (610, 0), (620, 1), (630, 1), (640, 1), (650, 0), (660, 0), (670, 1), (680, 1), (690, 1), (700, 1), (710, 1), (720, 1), (730, 1), (740, 1), (750, 0), (760, 1), (770, 0), (780, 0), (790, 0), (800, 0), (810, 0), (820, 0), (830, 0), (840, 0), (850, 0), (860, 1), (870, 1), (880, 1), (890, 1), (900, 1), (910, 0), (920, 0), (930, 0), (940, 0), (950, 0), (960, 0), (970, 0), (980, 0), (990, 0), (1000, 0), (1010, 0), (1020, 0), (1030, 0), (1040, 0), (1050, 0), (1060, 1), (1070, 1), (1080, 1), (1090, 1), (1100, 0), (1110, 0), (1120, 1), (1130, 1), (1140, 1), (1150, 1), (1160, 1), (1170, 1), (1180, 1), (1190, 1), (1200, 1), (1210, 0), (1220, 0), (1230, 1), (1240, 1), (1250, 0), (1260, 0), (1270, 0), (1280, 0), (1290, 0), (1300, 0), (1310, 0), (1320, 0), (1330, 0), (1340, 1), (1350, 0), (1360, 0), (1370, 0), (1380, 0), (1390, 0), (1400, 0), (1410, 1), (1420, 0), (1430, 0), (1440, 0), (1450, 0), (1460, 0), (1470, 0), (1480, 1), (1490, 1), (1500, 1), (1510, 0), (1520, 0), (1530, 1), (1540, 1), (1550, 0), (1560, 0), (1570, 0), (1580, 1), (1590, 0), (1600, 0), (1610, 0), (1620, 0), (1630, 0), (1640, 0), (1650, 0), (1660, 0), (1670, 0), (1680, 0), (1690, 0), (1700, 0), (1710, 1), (1720, 1), (1730, 1), (1740, 1), (1750, 1), (1760, 1), (1770, 1), (1780, 0), (1790, 0), (1800, 1), (1810, 1), (1820, 1), (1830, 1), (1840, 0), (1850, 1), (1860, 1), (1870, 1), (1880, 1), (1890, 1), (1900, 1), (1910, 1), (1920, 1), (1930, 1), (1940, 0), (1950, 1), (1960, 1), (1970, 0), (1980, 0), (1990, 0), (2000, 0), (2010, 0), (2020, 0), (2030, 0), (2040, 0), (2050, 0)]
Vdin0_22  din0_22  0 PWL (0n 0.0v 9.495n 0.0v 9.505n 1.8v 19.495n 1.8v 19.505n 0.0v 29.495n 0.0v 29.505n 1.8v 39.495n 1.8v 39.505n 1.8v 49.495n 1.8v 49.505n 1.8v 59.495n 1.8v 59.505n 1.8v 69.495n 1.8v 69.505n 1.8v 79.495n 1.8v 79.505n 1.8v 89.495n 1.8v 89.505n 1.8v 99.495n 1.8v 99.505n 1.8v 109.495n 1.8v 109.505n 1.8v 119.495n 1.8v 119.505n 1.8v 129.495n 1.8v 129.505n 1.8v 139.495n 1.8v 139.505n 1.8v 149.495n 1.8v 149.505n 1.8v 159.495n 1.8v 159.505n 1.8v 169.495n 1.8v 169.505n 1.8v 179.495n 1.8v 179.505n 1.8v 189.495n 1.8v 189.505n 1.8v 199.495n 1.8v 199.505n 1.8v 209.495n 1.8v 209.505n 1.8v 219.495n 1.8v 219.505n 1.8v 229.495n 1.8v 229.505n 1.8v 239.495n 1.8v 239.505n 0.0v 249.495n 0.0v 249.505n 0.0v 259.495n 0.0v 259.505n 0.0v 269.495n 0.0v 269.505n 0.0v 279.495n 0.0v 279.505n 0.0v 289.495n 0.0v 289.505n 0.0v 299.495n 0.0v 299.505n 0.0v 309.495n 0.0v 309.505n 0.0v 319.495n 0.0v 319.505n 1.8v 329.495n 1.8v 329.505n 1.8v 339.495n 1.8v 339.505n 0.0v 349.495n 0.0v 349.505n 0.0v 359.495n 0.0v 359.505n 0.0v 369.495n 0.0v 369.505n 0.0v 379.495n 0.0v 379.505n 0.0v 389.495n 0.0v 389.505n 0.0v 399.495n 0.0v 399.505n 1.8v 409.495n 1.8v 409.505n 1.8v 419.495n 1.8v 419.505n 1.8v 429.495n 1.8v 429.505n 1.8v 439.495n 1.8v 439.505n 1.8v 449.495n 1.8v 449.505n 1.8v 459.495n 1.8v 459.505n 1.8v 469.495n 1.8v 469.505n 1.8v 479.495n 1.8v 479.505n 1.8v 489.495n 1.8v 489.505n 1.8v 499.495n 1.8v 499.505n 0.0v 509.495n 0.0v 509.505n 1.8v 519.495n 1.8v 519.505n 1.8v 529.495n 1.8v 529.505n 1.8v 539.495n 1.8v 539.505n 1.8v 549.495n 1.8v 549.505n 1.8v 559.495n 1.8v 559.505n 1.8v 569.495n 1.8v 569.505n 1.8v 579.495n 1.8v 579.505n 1.8v 589.495n 1.8v 589.505n 1.8v 599.495n 1.8v 599.505n 0.0v 609.495n 0.0v 609.505n 0.0v 619.495n 0.0v 619.505n 1.8v 629.495n 1.8v 629.505n 1.8v 639.495n 1.8v 639.505n 1.8v 649.495n 1.8v 649.505n 0.0v 659.495n 0.0v 659.505n 0.0v 669.495n 0.0v 669.505n 1.8v 679.495n 1.8v 679.505n 1.8v 689.495n 1.8v 689.505n 1.8v 699.495n 1.8v 699.505n 1.8v 709.495n 1.8v 709.505n 1.8v 719.495n 1.8v 719.505n 1.8v 729.495n 1.8v 729.505n 1.8v 739.495n 1.8v 739.505n 1.8v 749.495n 1.8v 749.505n 0.0v 759.495n 0.0v 759.505n 1.8v 769.495n 1.8v 769.505n 0.0v 779.495n 0.0v 779.505n 0.0v 789.495n 0.0v 789.505n 0.0v 799.495n 0.0v 799.505n 0.0v 809.495n 0.0v 809.505n 0.0v 819.495n 0.0v 819.505n 0.0v 829.495n 0.0v 829.505n 0.0v 839.495n 0.0v 839.505n 0.0v 849.495n 0.0v 849.505n 0.0v 859.495n 0.0v 859.505n 1.8v 869.495n 1.8v 869.505n 1.8v 879.495n 1.8v 879.505n 1.8v 889.495n 1.8v 889.505n 1.8v 899.495n 1.8v 899.505n 1.8v 909.495n 1.8v 909.505n 0.0v 919.495n 0.0v 919.505n 0.0v 929.495n 0.0v 929.505n 0.0v 939.495n 0.0v 939.505n 0.0v 949.495n 0.0v 949.505n 0.0v 959.495n 0.0v 959.505n 0.0v 969.495n 0.0v 969.505n 0.0v 979.495n 0.0v 979.505n 0.0v 989.495n 0.0v 989.505n 0.0v 999.495n 0.0v 999.505n 0.0v 1009.495n 0.0v 1009.505n 0.0v 1019.495n 0.0v 1019.505n 0.0v 1029.495n 0.0v 1029.505n 0.0v 1039.495n 0.0v 1039.505n 0.0v 1049.495n 0.0v 1049.505n 0.0v 1059.495n 0.0v 1059.505n 1.8v 1069.495n 1.8v 1069.505n 1.8v 1079.495n 1.8v 1079.505n 1.8v 1089.495n 1.8v 1089.505n 1.8v 1099.495n 1.8v 1099.505n 0.0v 1109.495n 0.0v 1109.505n 0.0v 1119.495n 0.0v 1119.505n 1.8v 1129.495n 1.8v 1129.505n 1.8v 1139.495n 1.8v 1139.505n 1.8v 1149.495n 1.8v 1149.505n 1.8v 1159.495n 1.8v 1159.505n 1.8v 1169.495n 1.8v 1169.505n 1.8v 1179.495n 1.8v 1179.505n 1.8v 1189.495n 1.8v 1189.505n 1.8v 1199.495n 1.8v 1199.505n 1.8v 1209.495n 1.8v 1209.505n 0.0v 1219.495n 0.0v 1219.505n 0.0v 1229.495n 0.0v 1229.505n 1.8v 1239.495n 1.8v 1239.505n 1.8v 1249.495n 1.8v 1249.505n 0.0v 1259.495n 0.0v 1259.505n 0.0v 1269.495n 0.0v 1269.505n 0.0v 1279.495n 0.0v 1279.505n 0.0v 1289.495n 0.0v 1289.505n 0.0v 1299.495n 0.0v 1299.505n 0.0v 1309.495n 0.0v 1309.505n 0.0v 1319.495n 0.0v 1319.505n 0.0v 1329.495n 0.0v 1329.505n 0.0v 1339.495n 0.0v 1339.505n 1.8v 1349.495n 1.8v 1349.505n 0.0v 1359.495n 0.0v 1359.505n 0.0v 1369.495n 0.0v 1369.505n 0.0v 1379.495n 0.0v 1379.505n 0.0v 1389.495n 0.0v 1389.505n 0.0v 1399.495n 0.0v 1399.505n 0.0v 1409.495n 0.0v 1409.505n 1.8v 1419.495n 1.8v 1419.505n 0.0v 1429.495n 0.0v 1429.505n 0.0v 1439.495n 0.0v 1439.505n 0.0v 1449.495n 0.0v 1449.505n 0.0v 1459.495n 0.0v 1459.505n 0.0v 1469.495n 0.0v 1469.505n 0.0v 1479.495n 0.0v 1479.505n 1.8v 1489.495n 1.8v 1489.505n 1.8v 1499.495n 1.8v 1499.505n 1.8v 1509.495n 1.8v 1509.505n 0.0v 1519.495n 0.0v 1519.505n 0.0v 1529.495n 0.0v 1529.505n 1.8v 1539.495n 1.8v 1539.505n 1.8v 1549.495n 1.8v 1549.505n 0.0v 1559.495n 0.0v 1559.505n 0.0v 1569.495n 0.0v 1569.505n 0.0v 1579.495n 0.0v 1579.505n 1.8v 1589.495n 1.8v 1589.505n 0.0v 1599.495n 0.0v 1599.505n 0.0v 1609.495n 0.0v 1609.505n 0.0v 1619.495n 0.0v 1619.505n 0.0v 1629.495n 0.0v 1629.505n 0.0v 1639.495n 0.0v 1639.505n 0.0v 1649.495n 0.0v 1649.505n 0.0v 1659.495n 0.0v 1659.505n 0.0v 1669.495n 0.0v 1669.505n 0.0v 1679.495n 0.0v 1679.505n 0.0v 1689.495n 0.0v 1689.505n 0.0v 1699.495n 0.0v 1699.505n 0.0v 1709.495n 0.0v 1709.505n 1.8v 1719.495n 1.8v 1719.505n 1.8v 1729.495n 1.8v 1729.505n 1.8v 1739.495n 1.8v 1739.505n 1.8v 1749.495n 1.8v 1749.505n 1.8v 1759.495n 1.8v 1759.505n 1.8v 1769.495n 1.8v 1769.505n 1.8v 1779.495n 1.8v 1779.505n 0.0v 1789.495n 0.0v 1789.505n 0.0v 1799.495n 0.0v 1799.505n 1.8v 1809.495n 1.8v 1809.505n 1.8v 1819.495n 1.8v 1819.505n 1.8v 1829.495n 1.8v 1829.505n 1.8v 1839.495n 1.8v 1839.505n 0.0v 1849.495n 0.0v 1849.505n 1.8v 1859.495n 1.8v 1859.505n 1.8v 1869.495n 1.8v 1869.505n 1.8v 1879.495n 1.8v 1879.505n 1.8v 1889.495n 1.8v 1889.505n 1.8v 1899.495n 1.8v 1899.505n 1.8v 1909.495n 1.8v 1909.505n 1.8v 1919.495n 1.8v 1919.505n 1.8v 1929.495n 1.8v 1929.505n 1.8v 1939.495n 1.8v 1939.505n 0.0v 1949.495n 0.0v 1949.505n 1.8v 1959.495n 1.8v 1959.505n 1.8v 1969.495n 1.8v 1969.505n 0.0v 1979.495n 0.0v 1979.505n 0.0v 1989.495n 0.0v 1989.505n 0.0v 1999.495n 0.0v 1999.505n 0.0v 2009.495n 0.0v 2009.505n 0.0v 2019.495n 0.0v 2019.505n 0.0v 2029.495n 0.0v 2029.505n 0.0v 2039.495n 0.0v 2039.505n 0.0v 2049.495n 0.0v 2049.505n 0.0v )
* (time, data): [(0, 0), (10, 1), (20, 1), (30, 1), (40, 1), (50, 1), (60, 1), (70, 1), (80, 1), (90, 1), (100, 1), (110, 0), (120, 0), (130, 0), (140, 0), (150, 0), (160, 0), (170, 0), (180, 0), (190, 0), (200, 1), (210, 1), (220, 1), (230, 1), (240, 1), (250, 1), (260, 1), (270, 0), (280, 0), (290, 0), (300, 0), (310, 1), (320, 1), (330, 1), (340, 0), (350, 0), (360, 0), (370, 0), (380, 0), (390, 0), (400, 1), (410, 1), (420, 1), (430, 1), (440, 1), (450, 1), (460, 1), (470, 1), (480, 1), (490, 1), (500, 0), (510, 1), (520, 1), (530, 0), (540, 1), (550, 1), (560, 1), (570, 1), (580, 1), (590, 1), (600, 0), (610, 0), (620, 0), (630, 0), (640, 0), (650, 0), (660, 0), (670, 1), (680, 1), (690, 1), (700, 1), (710, 1), (720, 1), (730, 1), (740, 1), (750, 0), (760, 0), (770, 0), (780, 0), (790, 0), (800, 0), (810, 0), (820, 0), (830, 0), (840, 0), (850, 0), (860, 0), (870, 0), (880, 0), (890, 0), (900, 0), (910, 1), (920, 0), (930, 0), (940, 0), (950, 0), (960, 0), (970, 0), (980, 0), (990, 1), (1000, 0), (1010, 0), (1020, 0), (1030, 0), (1040, 0), (1050, 0), (1060, 0), (1070, 0), (1080, 0), (1090, 0), (1100, 0), (1110, 0), (1120, 0), (1130, 0), (1140, 0), (1150, 1), (1160, 1), (1170, 1), (1180, 1), (1190, 1), (1200, 1), (1210, 0), (1220, 0), (1230, 1), (1240, 0), (1250, 1), (1260, 1), (1270, 1), (1280, 1), (1290, 1), (1300, 1), (1310, 1), (1320, 1), (1330, 1), (1340, 0), (1350, 0), (1360, 0), (1370, 0), (1380, 0), (1390, 0), (1400, 0), (1410, 0), (1420, 1), (1430, 1), (1440, 1), (1450, 1), (1460, 1), (1470, 1), (1480, 1), (1490, 1), (1500, 1), (1510, 1), (1520, 1), (1530, 0), (1540, 0), (1550, 0), (1560, 0), (1570, 0), (1580, 0), (1590, 0), (1600, 0), (1610, 1), (1620, 1), (1630, 1), (1640, 1), (1650, 1), (1660, 1), (1670, 1), (1680, 1), (1690, 1), (1700, 1), (1710, 0), (1720, 0), (1730, 1), (1740, 1), (1750, 1), (1760, 1), (1770, 1), (1780, 0), (1790, 0), (1800, 1), (1810, 1), (1820, 1), (1830, 1), (1840, 0), (1850, 0), (1860, 0), (1870, 0), (1880, 0), (1890, 0), (1900, 0), (1910, 0), (1920, 0), (1930, 0), (1940, 1), (1950, 1), (1960, 1), (1970, 0), (1980, 0), (1990, 0), (2000, 0), (2010, 0), (2020, 0), (2030, 0), (2040, 0), (2050, 0)]
Vdin0_23  din0_23  0 PWL (0n 0.0v 9.495n 0.0v 9.505n 1.8v 19.495n 1.8v 19.505n 1.8v 29.495n 1.8v 29.505n 1.8v 39.495n 1.8v 39.505n 1.8v 49.495n 1.8v 49.505n 1.8v 59.495n 1.8v 59.505n 1.8v 69.495n 1.8v 69.505n 1.8v 79.495n 1.8v 79.505n 1.8v 89.495n 1.8v 89.505n 1.8v 99.495n 1.8v 99.505n 1.8v 109.495n 1.8v 109.505n 0.0v 119.495n 0.0v 119.505n 0.0v 129.495n 0.0v 129.505n 0.0v 139.495n 0.0v 139.505n 0.0v 149.495n 0.0v 149.505n 0.0v 159.495n 0.0v 159.505n 0.0v 169.495n 0.0v 169.505n 0.0v 179.495n 0.0v 179.505n 0.0v 189.495n 0.0v 189.505n 0.0v 199.495n 0.0v 199.505n 1.8v 209.495n 1.8v 209.505n 1.8v 219.495n 1.8v 219.505n 1.8v 229.495n 1.8v 229.505n 1.8v 239.495n 1.8v 239.505n 1.8v 249.495n 1.8v 249.505n 1.8v 259.495n 1.8v 259.505n 1.8v 269.495n 1.8v 269.505n 0.0v 279.495n 0.0v 279.505n 0.0v 289.495n 0.0v 289.505n 0.0v 299.495n 0.0v 299.505n 0.0v 309.495n 0.0v 309.505n 1.8v 319.495n 1.8v 319.505n 1.8v 329.495n 1.8v 329.505n 1.8v 339.495n 1.8v 339.505n 0.0v 349.495n 0.0v 349.505n 0.0v 359.495n 0.0v 359.505n 0.0v 369.495n 0.0v 369.505n 0.0v 379.495n 0.0v 379.505n 0.0v 389.495n 0.0v 389.505n 0.0v 399.495n 0.0v 399.505n 1.8v 409.495n 1.8v 409.505n 1.8v 419.495n 1.8v 419.505n 1.8v 429.495n 1.8v 429.505n 1.8v 439.495n 1.8v 439.505n 1.8v 449.495n 1.8v 449.505n 1.8v 459.495n 1.8v 459.505n 1.8v 469.495n 1.8v 469.505n 1.8v 479.495n 1.8v 479.505n 1.8v 489.495n 1.8v 489.505n 1.8v 499.495n 1.8v 499.505n 0.0v 509.495n 0.0v 509.505n 1.8v 519.495n 1.8v 519.505n 1.8v 529.495n 1.8v 529.505n 0.0v 539.495n 0.0v 539.505n 1.8v 549.495n 1.8v 549.505n 1.8v 559.495n 1.8v 559.505n 1.8v 569.495n 1.8v 569.505n 1.8v 579.495n 1.8v 579.505n 1.8v 589.495n 1.8v 589.505n 1.8v 599.495n 1.8v 599.505n 0.0v 609.495n 0.0v 609.505n 0.0v 619.495n 0.0v 619.505n 0.0v 629.495n 0.0v 629.505n 0.0v 639.495n 0.0v 639.505n 0.0v 649.495n 0.0v 649.505n 0.0v 659.495n 0.0v 659.505n 0.0v 669.495n 0.0v 669.505n 1.8v 679.495n 1.8v 679.505n 1.8v 689.495n 1.8v 689.505n 1.8v 699.495n 1.8v 699.505n 1.8v 709.495n 1.8v 709.505n 1.8v 719.495n 1.8v 719.505n 1.8v 729.495n 1.8v 729.505n 1.8v 739.495n 1.8v 739.505n 1.8v 749.495n 1.8v 749.505n 0.0v 759.495n 0.0v 759.505n 0.0v 769.495n 0.0v 769.505n 0.0v 779.495n 0.0v 779.505n 0.0v 789.495n 0.0v 789.505n 0.0v 799.495n 0.0v 799.505n 0.0v 809.495n 0.0v 809.505n 0.0v 819.495n 0.0v 819.505n 0.0v 829.495n 0.0v 829.505n 0.0v 839.495n 0.0v 839.505n 0.0v 849.495n 0.0v 849.505n 0.0v 859.495n 0.0v 859.505n 0.0v 869.495n 0.0v 869.505n 0.0v 879.495n 0.0v 879.505n 0.0v 889.495n 0.0v 889.505n 0.0v 899.495n 0.0v 899.505n 0.0v 909.495n 0.0v 909.505n 1.8v 919.495n 1.8v 919.505n 0.0v 929.495n 0.0v 929.505n 0.0v 939.495n 0.0v 939.505n 0.0v 949.495n 0.0v 949.505n 0.0v 959.495n 0.0v 959.505n 0.0v 969.495n 0.0v 969.505n 0.0v 979.495n 0.0v 979.505n 0.0v 989.495n 0.0v 989.505n 1.8v 999.495n 1.8v 999.505n 0.0v 1009.495n 0.0v 1009.505n 0.0v 1019.495n 0.0v 1019.505n 0.0v 1029.495n 0.0v 1029.505n 0.0v 1039.495n 0.0v 1039.505n 0.0v 1049.495n 0.0v 1049.505n 0.0v 1059.495n 0.0v 1059.505n 0.0v 1069.495n 0.0v 1069.505n 0.0v 1079.495n 0.0v 1079.505n 0.0v 1089.495n 0.0v 1089.505n 0.0v 1099.495n 0.0v 1099.505n 0.0v 1109.495n 0.0v 1109.505n 0.0v 1119.495n 0.0v 1119.505n 0.0v 1129.495n 0.0v 1129.505n 0.0v 1139.495n 0.0v 1139.505n 0.0v 1149.495n 0.0v 1149.505n 1.8v 1159.495n 1.8v 1159.505n 1.8v 1169.495n 1.8v 1169.505n 1.8v 1179.495n 1.8v 1179.505n 1.8v 1189.495n 1.8v 1189.505n 1.8v 1199.495n 1.8v 1199.505n 1.8v 1209.495n 1.8v 1209.505n 0.0v 1219.495n 0.0v 1219.505n 0.0v 1229.495n 0.0v 1229.505n 1.8v 1239.495n 1.8v 1239.505n 0.0v 1249.495n 0.0v 1249.505n 1.8v 1259.495n 1.8v 1259.505n 1.8v 1269.495n 1.8v 1269.505n 1.8v 1279.495n 1.8v 1279.505n 1.8v 1289.495n 1.8v 1289.505n 1.8v 1299.495n 1.8v 1299.505n 1.8v 1309.495n 1.8v 1309.505n 1.8v 1319.495n 1.8v 1319.505n 1.8v 1329.495n 1.8v 1329.505n 1.8v 1339.495n 1.8v 1339.505n 0.0v 1349.495n 0.0v 1349.505n 0.0v 1359.495n 0.0v 1359.505n 0.0v 1369.495n 0.0v 1369.505n 0.0v 1379.495n 0.0v 1379.505n 0.0v 1389.495n 0.0v 1389.505n 0.0v 1399.495n 0.0v 1399.505n 0.0v 1409.495n 0.0v 1409.505n 0.0v 1419.495n 0.0v 1419.505n 1.8v 1429.495n 1.8v 1429.505n 1.8v 1439.495n 1.8v 1439.505n 1.8v 1449.495n 1.8v 1449.505n 1.8v 1459.495n 1.8v 1459.505n 1.8v 1469.495n 1.8v 1469.505n 1.8v 1479.495n 1.8v 1479.505n 1.8v 1489.495n 1.8v 1489.505n 1.8v 1499.495n 1.8v 1499.505n 1.8v 1509.495n 1.8v 1509.505n 1.8v 1519.495n 1.8v 1519.505n 1.8v 1529.495n 1.8v 1529.505n 0.0v 1539.495n 0.0v 1539.505n 0.0v 1549.495n 0.0v 1549.505n 0.0v 1559.495n 0.0v 1559.505n 0.0v 1569.495n 0.0v 1569.505n 0.0v 1579.495n 0.0v 1579.505n 0.0v 1589.495n 0.0v 1589.505n 0.0v 1599.495n 0.0v 1599.505n 0.0v 1609.495n 0.0v 1609.505n 1.8v 1619.495n 1.8v 1619.505n 1.8v 1629.495n 1.8v 1629.505n 1.8v 1639.495n 1.8v 1639.505n 1.8v 1649.495n 1.8v 1649.505n 1.8v 1659.495n 1.8v 1659.505n 1.8v 1669.495n 1.8v 1669.505n 1.8v 1679.495n 1.8v 1679.505n 1.8v 1689.495n 1.8v 1689.505n 1.8v 1699.495n 1.8v 1699.505n 1.8v 1709.495n 1.8v 1709.505n 0.0v 1719.495n 0.0v 1719.505n 0.0v 1729.495n 0.0v 1729.505n 1.8v 1739.495n 1.8v 1739.505n 1.8v 1749.495n 1.8v 1749.505n 1.8v 1759.495n 1.8v 1759.505n 1.8v 1769.495n 1.8v 1769.505n 1.8v 1779.495n 1.8v 1779.505n 0.0v 1789.495n 0.0v 1789.505n 0.0v 1799.495n 0.0v 1799.505n 1.8v 1809.495n 1.8v 1809.505n 1.8v 1819.495n 1.8v 1819.505n 1.8v 1829.495n 1.8v 1829.505n 1.8v 1839.495n 1.8v 1839.505n 0.0v 1849.495n 0.0v 1849.505n 0.0v 1859.495n 0.0v 1859.505n 0.0v 1869.495n 0.0v 1869.505n 0.0v 1879.495n 0.0v 1879.505n 0.0v 1889.495n 0.0v 1889.505n 0.0v 1899.495n 0.0v 1899.505n 0.0v 1909.495n 0.0v 1909.505n 0.0v 1919.495n 0.0v 1919.505n 0.0v 1929.495n 0.0v 1929.505n 0.0v 1939.495n 0.0v 1939.505n 1.8v 1949.495n 1.8v 1949.505n 1.8v 1959.495n 1.8v 1959.505n 1.8v 1969.495n 1.8v 1969.505n 0.0v 1979.495n 0.0v 1979.505n 0.0v 1989.495n 0.0v 1989.505n 0.0v 1999.495n 0.0v 1999.505n 0.0v 2009.495n 0.0v 2009.505n 0.0v 2019.495n 0.0v 2019.505n 0.0v 2029.495n 0.0v 2029.505n 0.0v 2039.495n 0.0v 2039.505n 0.0v 2049.495n 0.0v 2049.505n 0.0v )
* (time, data): [(0, 0), (10, 0), (20, 0), (30, 1), (40, 1), (50, 1), (60, 1), (70, 1), (80, 0), (90, 0), (100, 0), (110, 1), (120, 1), (130, 1), (140, 1), (150, 1), (160, 1), (170, 1), (180, 1), (190, 1), (200, 0), (210, 0), (220, 0), (230, 0), (240, 0), (250, 0), (260, 0), (270, 0), (280, 0), (290, 0), (300, 0), (310, 1), (320, 0), (330, 0), (340, 0), (350, 0), (360, 0), (370, 0), (380, 0), (390, 1), (400, 0), (410, 1), (420, 1), (430, 1), (440, 1), (450, 1), (460, 1), (470, 1), (480, 1), (490, 1), (500, 0), (510, 1), (520, 1), (530, 1), (540, 0), (550, 0), (560, 0), (570, 0), (580, 0), (590, 0), (600, 1), (610, 1), (620, 0), (630, 0), (640, 0), (650, 0), (660, 0), (670, 1), (680, 1), (690, 1), (700, 1), (710, 1), (720, 1), (730, 1), (740, 1), (750, 0), (760, 0), (770, 0), (780, 0), (790, 0), (800, 0), (810, 0), (820, 0), (830, 0), (840, 0), (850, 0), (860, 0), (870, 0), (880, 0), (890, 0), (900, 0), (910, 1), (920, 1), (930, 1), (940, 1), (950, 1), (960, 1), (970, 1), (980, 1), (990, 0), (1000, 0), (1010, 0), (1020, 0), (1030, 0), (1040, 1), (1050, 1), (1060, 0), (1070, 0), (1080, 0), (1090, 0), (1100, 0), (1110, 0), (1120, 0), (1130, 0), (1140, 0), (1150, 1), (1160, 1), (1170, 1), (1180, 1), (1190, 1), (1200, 1), (1210, 0), (1220, 0), (1230, 0), (1240, 0), (1250, 1), (1260, 1), (1270, 1), (1280, 1), (1290, 1), (1300, 1), (1310, 1), (1320, 1), (1330, 1), (1340, 1), (1350, 1), (1360, 1), (1370, 1), (1380, 1), (1390, 0), (1400, 0), (1410, 0), (1420, 1), (1430, 1), (1440, 1), (1450, 1), (1460, 1), (1470, 1), (1480, 0), (1490, 0), (1500, 0), (1510, 0), (1520, 0), (1530, 0), (1540, 0), (1550, 0), (1560, 0), (1570, 1), (1580, 1), (1590, 1), (1600, 1), (1610, 0), (1620, 0), (1630, 0), (1640, 0), (1650, 0), (1660, 1), (1670, 1), (1680, 1), (1690, 1), (1700, 1), (1710, 0), (1720, 0), (1730, 0), (1740, 0), (1750, 0), (1760, 0), (1770, 0), (1780, 0), (1790, 0), (1800, 1), (1810, 1), (1820, 1), (1830, 1), (1840, 1), (1850, 1), (1860, 1), (1870, 1), (1880, 1), (1890, 1), (1900, 0), (1910, 0), (1920, 0), (1930, 0), (1940, 0), (1950, 1), (1960, 1), (1970, 0), (1980, 0), (1990, 1), (2000, 1), (2010, 1), (2020, 1), (2030, 1), (2040, 0), (2050, 0)]
Vdin0_24  din0_24  0 PWL (0n 0.0v 9.495n 0.0v 9.505n 0.0v 19.495n 0.0v 19.505n 0.0v 29.495n 0.0v 29.505n 1.8v 39.495n 1.8v 39.505n 1.8v 49.495n 1.8v 49.505n 1.8v 59.495n 1.8v 59.505n 1.8v 69.495n 1.8v 69.505n 1.8v 79.495n 1.8v 79.505n 0.0v 89.495n 0.0v 89.505n 0.0v 99.495n 0.0v 99.505n 0.0v 109.495n 0.0v 109.505n 1.8v 119.495n 1.8v 119.505n 1.8v 129.495n 1.8v 129.505n 1.8v 139.495n 1.8v 139.505n 1.8v 149.495n 1.8v 149.505n 1.8v 159.495n 1.8v 159.505n 1.8v 169.495n 1.8v 169.505n 1.8v 179.495n 1.8v 179.505n 1.8v 189.495n 1.8v 189.505n 1.8v 199.495n 1.8v 199.505n 0.0v 209.495n 0.0v 209.505n 0.0v 219.495n 0.0v 219.505n 0.0v 229.495n 0.0v 229.505n 0.0v 239.495n 0.0v 239.505n 0.0v 249.495n 0.0v 249.505n 0.0v 259.495n 0.0v 259.505n 0.0v 269.495n 0.0v 269.505n 0.0v 279.495n 0.0v 279.505n 0.0v 289.495n 0.0v 289.505n 0.0v 299.495n 0.0v 299.505n 0.0v 309.495n 0.0v 309.505n 1.8v 319.495n 1.8v 319.505n 0.0v 329.495n 0.0v 329.505n 0.0v 339.495n 0.0v 339.505n 0.0v 349.495n 0.0v 349.505n 0.0v 359.495n 0.0v 359.505n 0.0v 369.495n 0.0v 369.505n 0.0v 379.495n 0.0v 379.505n 0.0v 389.495n 0.0v 389.505n 1.8v 399.495n 1.8v 399.505n 0.0v 409.495n 0.0v 409.505n 1.8v 419.495n 1.8v 419.505n 1.8v 429.495n 1.8v 429.505n 1.8v 439.495n 1.8v 439.505n 1.8v 449.495n 1.8v 449.505n 1.8v 459.495n 1.8v 459.505n 1.8v 469.495n 1.8v 469.505n 1.8v 479.495n 1.8v 479.505n 1.8v 489.495n 1.8v 489.505n 1.8v 499.495n 1.8v 499.505n 0.0v 509.495n 0.0v 509.505n 1.8v 519.495n 1.8v 519.505n 1.8v 529.495n 1.8v 529.505n 1.8v 539.495n 1.8v 539.505n 0.0v 549.495n 0.0v 549.505n 0.0v 559.495n 0.0v 559.505n 0.0v 569.495n 0.0v 569.505n 0.0v 579.495n 0.0v 579.505n 0.0v 589.495n 0.0v 589.505n 0.0v 599.495n 0.0v 599.505n 1.8v 609.495n 1.8v 609.505n 1.8v 619.495n 1.8v 619.505n 0.0v 629.495n 0.0v 629.505n 0.0v 639.495n 0.0v 639.505n 0.0v 649.495n 0.0v 649.505n 0.0v 659.495n 0.0v 659.505n 0.0v 669.495n 0.0v 669.505n 1.8v 679.495n 1.8v 679.505n 1.8v 689.495n 1.8v 689.505n 1.8v 699.495n 1.8v 699.505n 1.8v 709.495n 1.8v 709.505n 1.8v 719.495n 1.8v 719.505n 1.8v 729.495n 1.8v 729.505n 1.8v 739.495n 1.8v 739.505n 1.8v 749.495n 1.8v 749.505n 0.0v 759.495n 0.0v 759.505n 0.0v 769.495n 0.0v 769.505n 0.0v 779.495n 0.0v 779.505n 0.0v 789.495n 0.0v 789.505n 0.0v 799.495n 0.0v 799.505n 0.0v 809.495n 0.0v 809.505n 0.0v 819.495n 0.0v 819.505n 0.0v 829.495n 0.0v 829.505n 0.0v 839.495n 0.0v 839.505n 0.0v 849.495n 0.0v 849.505n 0.0v 859.495n 0.0v 859.505n 0.0v 869.495n 0.0v 869.505n 0.0v 879.495n 0.0v 879.505n 0.0v 889.495n 0.0v 889.505n 0.0v 899.495n 0.0v 899.505n 0.0v 909.495n 0.0v 909.505n 1.8v 919.495n 1.8v 919.505n 1.8v 929.495n 1.8v 929.505n 1.8v 939.495n 1.8v 939.505n 1.8v 949.495n 1.8v 949.505n 1.8v 959.495n 1.8v 959.505n 1.8v 969.495n 1.8v 969.505n 1.8v 979.495n 1.8v 979.505n 1.8v 989.495n 1.8v 989.505n 0.0v 999.495n 0.0v 999.505n 0.0v 1009.495n 0.0v 1009.505n 0.0v 1019.495n 0.0v 1019.505n 0.0v 1029.495n 0.0v 1029.505n 0.0v 1039.495n 0.0v 1039.505n 1.8v 1049.495n 1.8v 1049.505n 1.8v 1059.495n 1.8v 1059.505n 0.0v 1069.495n 0.0v 1069.505n 0.0v 1079.495n 0.0v 1079.505n 0.0v 1089.495n 0.0v 1089.505n 0.0v 1099.495n 0.0v 1099.505n 0.0v 1109.495n 0.0v 1109.505n 0.0v 1119.495n 0.0v 1119.505n 0.0v 1129.495n 0.0v 1129.505n 0.0v 1139.495n 0.0v 1139.505n 0.0v 1149.495n 0.0v 1149.505n 1.8v 1159.495n 1.8v 1159.505n 1.8v 1169.495n 1.8v 1169.505n 1.8v 1179.495n 1.8v 1179.505n 1.8v 1189.495n 1.8v 1189.505n 1.8v 1199.495n 1.8v 1199.505n 1.8v 1209.495n 1.8v 1209.505n 0.0v 1219.495n 0.0v 1219.505n 0.0v 1229.495n 0.0v 1229.505n 0.0v 1239.495n 0.0v 1239.505n 0.0v 1249.495n 0.0v 1249.505n 1.8v 1259.495n 1.8v 1259.505n 1.8v 1269.495n 1.8v 1269.505n 1.8v 1279.495n 1.8v 1279.505n 1.8v 1289.495n 1.8v 1289.505n 1.8v 1299.495n 1.8v 1299.505n 1.8v 1309.495n 1.8v 1309.505n 1.8v 1319.495n 1.8v 1319.505n 1.8v 1329.495n 1.8v 1329.505n 1.8v 1339.495n 1.8v 1339.505n 1.8v 1349.495n 1.8v 1349.505n 1.8v 1359.495n 1.8v 1359.505n 1.8v 1369.495n 1.8v 1369.505n 1.8v 1379.495n 1.8v 1379.505n 1.8v 1389.495n 1.8v 1389.505n 0.0v 1399.495n 0.0v 1399.505n 0.0v 1409.495n 0.0v 1409.505n 0.0v 1419.495n 0.0v 1419.505n 1.8v 1429.495n 1.8v 1429.505n 1.8v 1439.495n 1.8v 1439.505n 1.8v 1449.495n 1.8v 1449.505n 1.8v 1459.495n 1.8v 1459.505n 1.8v 1469.495n 1.8v 1469.505n 1.8v 1479.495n 1.8v 1479.505n 0.0v 1489.495n 0.0v 1489.505n 0.0v 1499.495n 0.0v 1499.505n 0.0v 1509.495n 0.0v 1509.505n 0.0v 1519.495n 0.0v 1519.505n 0.0v 1529.495n 0.0v 1529.505n 0.0v 1539.495n 0.0v 1539.505n 0.0v 1549.495n 0.0v 1549.505n 0.0v 1559.495n 0.0v 1559.505n 0.0v 1569.495n 0.0v 1569.505n 1.8v 1579.495n 1.8v 1579.505n 1.8v 1589.495n 1.8v 1589.505n 1.8v 1599.495n 1.8v 1599.505n 1.8v 1609.495n 1.8v 1609.505n 0.0v 1619.495n 0.0v 1619.505n 0.0v 1629.495n 0.0v 1629.505n 0.0v 1639.495n 0.0v 1639.505n 0.0v 1649.495n 0.0v 1649.505n 0.0v 1659.495n 0.0v 1659.505n 1.8v 1669.495n 1.8v 1669.505n 1.8v 1679.495n 1.8v 1679.505n 1.8v 1689.495n 1.8v 1689.505n 1.8v 1699.495n 1.8v 1699.505n 1.8v 1709.495n 1.8v 1709.505n 0.0v 1719.495n 0.0v 1719.505n 0.0v 1729.495n 0.0v 1729.505n 0.0v 1739.495n 0.0v 1739.505n 0.0v 1749.495n 0.0v 1749.505n 0.0v 1759.495n 0.0v 1759.505n 0.0v 1769.495n 0.0v 1769.505n 0.0v 1779.495n 0.0v 1779.505n 0.0v 1789.495n 0.0v 1789.505n 0.0v 1799.495n 0.0v 1799.505n 1.8v 1809.495n 1.8v 1809.505n 1.8v 1819.495n 1.8v 1819.505n 1.8v 1829.495n 1.8v 1829.505n 1.8v 1839.495n 1.8v 1839.505n 1.8v 1849.495n 1.8v 1849.505n 1.8v 1859.495n 1.8v 1859.505n 1.8v 1869.495n 1.8v 1869.505n 1.8v 1879.495n 1.8v 1879.505n 1.8v 1889.495n 1.8v 1889.505n 1.8v 1899.495n 1.8v 1899.505n 0.0v 1909.495n 0.0v 1909.505n 0.0v 1919.495n 0.0v 1919.505n 0.0v 1929.495n 0.0v 1929.505n 0.0v 1939.495n 0.0v 1939.505n 0.0v 1949.495n 0.0v 1949.505n 1.8v 1959.495n 1.8v 1959.505n 1.8v 1969.495n 1.8v 1969.505n 0.0v 1979.495n 0.0v 1979.505n 0.0v 1989.495n 0.0v 1989.505n 1.8v 1999.495n 1.8v 1999.505n 1.8v 2009.495n 1.8v 2009.505n 1.8v 2019.495n 1.8v 2019.505n 1.8v 2029.495n 1.8v 2029.505n 1.8v 2039.495n 1.8v 2039.505n 0.0v 2049.495n 0.0v 2049.505n 0.0v )
* (time, data): [(0, 0), (10, 1), (20, 1), (30, 0), (40, 0), (50, 0), (60, 0), (70, 0), (80, 0), (90, 0), (100, 0), (110, 0), (120, 0), (130, 0), (140, 0), (150, 0), (160, 0), (170, 1), (180, 1), (190, 1), (200, 0), (210, 0), (220, 0), (230, 0), (240, 1), (250, 1), (260, 1), (270, 1), (280, 1), (290, 1), (300, 1), (310, 1), (320, 1), (330, 1), (340, 0), (350, 0), (360, 0), (370, 0), (380, 0), (390, 0), (400, 0), (410, 0), (420, 0), (430, 0), (440, 0), (450, 0), (460, 0), (470, 0), (480, 0), (490, 0), (500, 0), (510, 1), (520, 1), (530, 1), (540, 0), (550, 0), (560, 0), (570, 0), (580, 0), (590, 0), (600, 0), (610, 0), (620, 0), (630, 0), (640, 0), (650, 0), (660, 0), (670, 1), (680, 1), (690, 1), (700, 1), (710, 1), (720, 1), (730, 1), (740, 1), (750, 1), (760, 1), (770, 1), (780, 1), (790, 1), (800, 1), (810, 1), (820, 1), (830, 1), (840, 1), (850, 1), (860, 0), (870, 0), (880, 0), (890, 0), (900, 1), (910, 1), (920, 1), (930, 1), (940, 1), (950, 1), (960, 1), (970, 1), (980, 1), (990, 0), (1000, 0), (1010, 0), (1020, 0), (1030, 0), (1040, 0), (1050, 0), (1060, 0), (1070, 0), (1080, 0), (1090, 0), (1100, 0), (1110, 0), (1120, 0), (1130, 1), (1140, 1), (1150, 1), (1160, 1), (1170, 1), (1180, 1), (1190, 1), (1200, 1), (1210, 1), (1220, 0), (1230, 0), (1240, 0), (1250, 0), (1260, 1), (1270, 1), (1280, 1), (1290, 1), (1300, 1), (1310, 1), (1320, 1), (1330, 1), (1340, 0), (1350, 0), (1360, 0), (1370, 0), (1380, 0), (1390, 0), (1400, 0), (1410, 1), (1420, 0), (1430, 0), (1440, 0), (1450, 0), (1460, 0), (1470, 0), (1480, 1), (1490, 1), (1500, 1), (1510, 0), (1520, 0), (1530, 0), (1540, 0), (1550, 1), (1560, 1), (1570, 1), (1580, 0), (1590, 1), (1600, 1), (1610, 0), (1620, 0), (1630, 0), (1640, 0), (1650, 0), (1660, 1), (1670, 1), (1680, 0), (1690, 1), (1700, 1), (1710, 0), (1720, 0), (1730, 1), (1740, 1), (1750, 1), (1760, 1), (1770, 1), (1780, 1), (1790, 1), (1800, 1), (1810, 1), (1820, 1), (1830, 1), (1840, 0), (1850, 0), (1860, 0), (1870, 0), (1880, 0), (1890, 0), (1900, 0), (1910, 0), (1920, 0), (1930, 0), (1940, 0), (1950, 1), (1960, 1), (1970, 1), (1980, 1), (1990, 0), (2000, 0), (2010, 0), (2020, 0), (2030, 0), (2040, 0), (2050, 0)]
Vdin0_25  din0_25  0 PWL (0n 0.0v 9.495n 0.0v 9.505n 1.8v 19.495n 1.8v 19.505n 1.8v 29.495n 1.8v 29.505n 0.0v 39.495n 0.0v 39.505n 0.0v 49.495n 0.0v 49.505n 0.0v 59.495n 0.0v 59.505n 0.0v 69.495n 0.0v 69.505n 0.0v 79.495n 0.0v 79.505n 0.0v 89.495n 0.0v 89.505n 0.0v 99.495n 0.0v 99.505n 0.0v 109.495n 0.0v 109.505n 0.0v 119.495n 0.0v 119.505n 0.0v 129.495n 0.0v 129.505n 0.0v 139.495n 0.0v 139.505n 0.0v 149.495n 0.0v 149.505n 0.0v 159.495n 0.0v 159.505n 0.0v 169.495n 0.0v 169.505n 1.8v 179.495n 1.8v 179.505n 1.8v 189.495n 1.8v 189.505n 1.8v 199.495n 1.8v 199.505n 0.0v 209.495n 0.0v 209.505n 0.0v 219.495n 0.0v 219.505n 0.0v 229.495n 0.0v 229.505n 0.0v 239.495n 0.0v 239.505n 1.8v 249.495n 1.8v 249.505n 1.8v 259.495n 1.8v 259.505n 1.8v 269.495n 1.8v 269.505n 1.8v 279.495n 1.8v 279.505n 1.8v 289.495n 1.8v 289.505n 1.8v 299.495n 1.8v 299.505n 1.8v 309.495n 1.8v 309.505n 1.8v 319.495n 1.8v 319.505n 1.8v 329.495n 1.8v 329.505n 1.8v 339.495n 1.8v 339.505n 0.0v 349.495n 0.0v 349.505n 0.0v 359.495n 0.0v 359.505n 0.0v 369.495n 0.0v 369.505n 0.0v 379.495n 0.0v 379.505n 0.0v 389.495n 0.0v 389.505n 0.0v 399.495n 0.0v 399.505n 0.0v 409.495n 0.0v 409.505n 0.0v 419.495n 0.0v 419.505n 0.0v 429.495n 0.0v 429.505n 0.0v 439.495n 0.0v 439.505n 0.0v 449.495n 0.0v 449.505n 0.0v 459.495n 0.0v 459.505n 0.0v 469.495n 0.0v 469.505n 0.0v 479.495n 0.0v 479.505n 0.0v 489.495n 0.0v 489.505n 0.0v 499.495n 0.0v 499.505n 0.0v 509.495n 0.0v 509.505n 1.8v 519.495n 1.8v 519.505n 1.8v 529.495n 1.8v 529.505n 1.8v 539.495n 1.8v 539.505n 0.0v 549.495n 0.0v 549.505n 0.0v 559.495n 0.0v 559.505n 0.0v 569.495n 0.0v 569.505n 0.0v 579.495n 0.0v 579.505n 0.0v 589.495n 0.0v 589.505n 0.0v 599.495n 0.0v 599.505n 0.0v 609.495n 0.0v 609.505n 0.0v 619.495n 0.0v 619.505n 0.0v 629.495n 0.0v 629.505n 0.0v 639.495n 0.0v 639.505n 0.0v 649.495n 0.0v 649.505n 0.0v 659.495n 0.0v 659.505n 0.0v 669.495n 0.0v 669.505n 1.8v 679.495n 1.8v 679.505n 1.8v 689.495n 1.8v 689.505n 1.8v 699.495n 1.8v 699.505n 1.8v 709.495n 1.8v 709.505n 1.8v 719.495n 1.8v 719.505n 1.8v 729.495n 1.8v 729.505n 1.8v 739.495n 1.8v 739.505n 1.8v 749.495n 1.8v 749.505n 1.8v 759.495n 1.8v 759.505n 1.8v 769.495n 1.8v 769.505n 1.8v 779.495n 1.8v 779.505n 1.8v 789.495n 1.8v 789.505n 1.8v 799.495n 1.8v 799.505n 1.8v 809.495n 1.8v 809.505n 1.8v 819.495n 1.8v 819.505n 1.8v 829.495n 1.8v 829.505n 1.8v 839.495n 1.8v 839.505n 1.8v 849.495n 1.8v 849.505n 1.8v 859.495n 1.8v 859.505n 0.0v 869.495n 0.0v 869.505n 0.0v 879.495n 0.0v 879.505n 0.0v 889.495n 0.0v 889.505n 0.0v 899.495n 0.0v 899.505n 1.8v 909.495n 1.8v 909.505n 1.8v 919.495n 1.8v 919.505n 1.8v 929.495n 1.8v 929.505n 1.8v 939.495n 1.8v 939.505n 1.8v 949.495n 1.8v 949.505n 1.8v 959.495n 1.8v 959.505n 1.8v 969.495n 1.8v 969.505n 1.8v 979.495n 1.8v 979.505n 1.8v 989.495n 1.8v 989.505n 0.0v 999.495n 0.0v 999.505n 0.0v 1009.495n 0.0v 1009.505n 0.0v 1019.495n 0.0v 1019.505n 0.0v 1029.495n 0.0v 1029.505n 0.0v 1039.495n 0.0v 1039.505n 0.0v 1049.495n 0.0v 1049.505n 0.0v 1059.495n 0.0v 1059.505n 0.0v 1069.495n 0.0v 1069.505n 0.0v 1079.495n 0.0v 1079.505n 0.0v 1089.495n 0.0v 1089.505n 0.0v 1099.495n 0.0v 1099.505n 0.0v 1109.495n 0.0v 1109.505n 0.0v 1119.495n 0.0v 1119.505n 0.0v 1129.495n 0.0v 1129.505n 1.8v 1139.495n 1.8v 1139.505n 1.8v 1149.495n 1.8v 1149.505n 1.8v 1159.495n 1.8v 1159.505n 1.8v 1169.495n 1.8v 1169.505n 1.8v 1179.495n 1.8v 1179.505n 1.8v 1189.495n 1.8v 1189.505n 1.8v 1199.495n 1.8v 1199.505n 1.8v 1209.495n 1.8v 1209.505n 1.8v 1219.495n 1.8v 1219.505n 0.0v 1229.495n 0.0v 1229.505n 0.0v 1239.495n 0.0v 1239.505n 0.0v 1249.495n 0.0v 1249.505n 0.0v 1259.495n 0.0v 1259.505n 1.8v 1269.495n 1.8v 1269.505n 1.8v 1279.495n 1.8v 1279.505n 1.8v 1289.495n 1.8v 1289.505n 1.8v 1299.495n 1.8v 1299.505n 1.8v 1309.495n 1.8v 1309.505n 1.8v 1319.495n 1.8v 1319.505n 1.8v 1329.495n 1.8v 1329.505n 1.8v 1339.495n 1.8v 1339.505n 0.0v 1349.495n 0.0v 1349.505n 0.0v 1359.495n 0.0v 1359.505n 0.0v 1369.495n 0.0v 1369.505n 0.0v 1379.495n 0.0v 1379.505n 0.0v 1389.495n 0.0v 1389.505n 0.0v 1399.495n 0.0v 1399.505n 0.0v 1409.495n 0.0v 1409.505n 1.8v 1419.495n 1.8v 1419.505n 0.0v 1429.495n 0.0v 1429.505n 0.0v 1439.495n 0.0v 1439.505n 0.0v 1449.495n 0.0v 1449.505n 0.0v 1459.495n 0.0v 1459.505n 0.0v 1469.495n 0.0v 1469.505n 0.0v 1479.495n 0.0v 1479.505n 1.8v 1489.495n 1.8v 1489.505n 1.8v 1499.495n 1.8v 1499.505n 1.8v 1509.495n 1.8v 1509.505n 0.0v 1519.495n 0.0v 1519.505n 0.0v 1529.495n 0.0v 1529.505n 0.0v 1539.495n 0.0v 1539.505n 0.0v 1549.495n 0.0v 1549.505n 1.8v 1559.495n 1.8v 1559.505n 1.8v 1569.495n 1.8v 1569.505n 1.8v 1579.495n 1.8v 1579.505n 0.0v 1589.495n 0.0v 1589.505n 1.8v 1599.495n 1.8v 1599.505n 1.8v 1609.495n 1.8v 1609.505n 0.0v 1619.495n 0.0v 1619.505n 0.0v 1629.495n 0.0v 1629.505n 0.0v 1639.495n 0.0v 1639.505n 0.0v 1649.495n 0.0v 1649.505n 0.0v 1659.495n 0.0v 1659.505n 1.8v 1669.495n 1.8v 1669.505n 1.8v 1679.495n 1.8v 1679.505n 0.0v 1689.495n 0.0v 1689.505n 1.8v 1699.495n 1.8v 1699.505n 1.8v 1709.495n 1.8v 1709.505n 0.0v 1719.495n 0.0v 1719.505n 0.0v 1729.495n 0.0v 1729.505n 1.8v 1739.495n 1.8v 1739.505n 1.8v 1749.495n 1.8v 1749.505n 1.8v 1759.495n 1.8v 1759.505n 1.8v 1769.495n 1.8v 1769.505n 1.8v 1779.495n 1.8v 1779.505n 1.8v 1789.495n 1.8v 1789.505n 1.8v 1799.495n 1.8v 1799.505n 1.8v 1809.495n 1.8v 1809.505n 1.8v 1819.495n 1.8v 1819.505n 1.8v 1829.495n 1.8v 1829.505n 1.8v 1839.495n 1.8v 1839.505n 0.0v 1849.495n 0.0v 1849.505n 0.0v 1859.495n 0.0v 1859.505n 0.0v 1869.495n 0.0v 1869.505n 0.0v 1879.495n 0.0v 1879.505n 0.0v 1889.495n 0.0v 1889.505n 0.0v 1899.495n 0.0v 1899.505n 0.0v 1909.495n 0.0v 1909.505n 0.0v 1919.495n 0.0v 1919.505n 0.0v 1929.495n 0.0v 1929.505n 0.0v 1939.495n 0.0v 1939.505n 0.0v 1949.495n 0.0v 1949.505n 1.8v 1959.495n 1.8v 1959.505n 1.8v 1969.495n 1.8v 1969.505n 1.8v 1979.495n 1.8v 1979.505n 1.8v 1989.495n 1.8v 1989.505n 0.0v 1999.495n 0.0v 1999.505n 0.0v 2009.495n 0.0v 2009.505n 0.0v 2019.495n 0.0v 2019.505n 0.0v 2029.495n 0.0v 2029.505n 0.0v 2039.495n 0.0v 2039.505n 0.0v 2049.495n 0.0v 2049.505n 0.0v )
* (time, data): [(0, 0), (10, 1), (20, 0), (30, 1), (40, 1), (50, 1), (60, 1), (70, 1), (80, 0), (90, 0), (100, 0), (110, 0), (120, 0), (130, 0), (140, 0), (150, 0), (160, 0), (170, 1), (180, 1), (190, 1), (200, 1), (210, 1), (220, 1), (230, 1), (240, 0), (250, 0), (260, 0), (270, 0), (280, 1), (290, 1), (300, 1), (310, 0), (320, 1), (330, 1), (340, 0), (350, 0), (360, 0), (370, 0), (380, 0), (390, 1), (400, 1), (410, 0), (420, 0), (430, 0), (440, 0), (450, 0), (460, 0), (470, 0), (480, 0), (490, 0), (500, 1), (510, 0), (520, 0), (530, 0), (540, 0), (550, 0), (560, 0), (570, 0), (580, 0), (590, 0), (600, 0), (610, 0), (620, 0), (630, 0), (640, 0), (650, 1), (660, 1), (670, 0), (680, 0), (690, 0), (700, 0), (710, 0), (720, 0), (730, 0), (740, 1), (750, 1), (760, 1), (770, 0), (780, 0), (790, 0), (800, 0), (810, 0), (820, 0), (830, 0), (840, 0), (850, 0), (860, 0), (870, 0), (880, 0), (890, 0), (900, 1), (910, 1), (920, 1), (930, 1), (940, 1), (950, 1), (960, 1), (970, 1), (980, 1), (990, 0), (1000, 1), (1010, 1), (1020, 1), (1030, 1), (1040, 1), (1050, 1), (1060, 0), (1070, 0), (1080, 0), (1090, 0), (1100, 1), (1110, 1), (1120, 0), (1130, 1), (1140, 1), (1150, 1), (1160, 1), (1170, 1), (1180, 1), (1190, 1), (1200, 1), (1210, 0), (1220, 1), (1230, 1), (1240, 0), (1250, 0), (1260, 1), (1270, 1), (1280, 1), (1290, 1), (1300, 1), (1310, 1), (1320, 1), (1330, 1), (1340, 1), (1350, 1), (1360, 1), (1370, 1), (1380, 1), (1390, 0), (1400, 0), (1410, 1), (1420, 1), (1430, 1), (1440, 1), (1450, 1), (1460, 1), (1470, 1), (1480, 1), (1490, 1), (1500, 1), (1510, 1), (1520, 1), (1530, 1), (1540, 1), (1550, 1), (1560, 1), (1570, 0), (1580, 0), (1590, 1), (1600, 1), (1610, 0), (1620, 0), (1630, 0), (1640, 0), (1650, 0), (1660, 1), (1670, 1), (1680, 1), (1690, 0), (1700, 0), (1710, 0), (1720, 0), (1730, 0), (1740, 0), (1750, 0), (1760, 0), (1770, 0), (1780, 1), (1790, 1), (1800, 1), (1810, 1), (1820, 1), (1830, 1), (1840, 0), (1850, 0), (1860, 0), (1870, 0), (1880, 0), (1890, 0), (1900, 1), (1910, 1), (1920, 1), (1930, 1), (1940, 0), (1950, 1), (1960, 1), (1970, 1), (1980, 1), (1990, 0), (2000, 0), (2010, 0), (2020, 0), (2030, 0), (2040, 1), (2050, 1)]
Vdin0_26  din0_26  0 PWL (0n 0.0v 9.495n 0.0v 9.505n 1.8v 19.495n 1.8v 19.505n 0.0v 29.495n 0.0v 29.505n 1.8v 39.495n 1.8v 39.505n 1.8v 49.495n 1.8v 49.505n 1.8v 59.495n 1.8v 59.505n 1.8v 69.495n 1.8v 69.505n 1.8v 79.495n 1.8v 79.505n 0.0v 89.495n 0.0v 89.505n 0.0v 99.495n 0.0v 99.505n 0.0v 109.495n 0.0v 109.505n 0.0v 119.495n 0.0v 119.505n 0.0v 129.495n 0.0v 129.505n 0.0v 139.495n 0.0v 139.505n 0.0v 149.495n 0.0v 149.505n 0.0v 159.495n 0.0v 159.505n 0.0v 169.495n 0.0v 169.505n 1.8v 179.495n 1.8v 179.505n 1.8v 189.495n 1.8v 189.505n 1.8v 199.495n 1.8v 199.505n 1.8v 209.495n 1.8v 209.505n 1.8v 219.495n 1.8v 219.505n 1.8v 229.495n 1.8v 229.505n 1.8v 239.495n 1.8v 239.505n 0.0v 249.495n 0.0v 249.505n 0.0v 259.495n 0.0v 259.505n 0.0v 269.495n 0.0v 269.505n 0.0v 279.495n 0.0v 279.505n 1.8v 289.495n 1.8v 289.505n 1.8v 299.495n 1.8v 299.505n 1.8v 309.495n 1.8v 309.505n 0.0v 319.495n 0.0v 319.505n 1.8v 329.495n 1.8v 329.505n 1.8v 339.495n 1.8v 339.505n 0.0v 349.495n 0.0v 349.505n 0.0v 359.495n 0.0v 359.505n 0.0v 369.495n 0.0v 369.505n 0.0v 379.495n 0.0v 379.505n 0.0v 389.495n 0.0v 389.505n 1.8v 399.495n 1.8v 399.505n 1.8v 409.495n 1.8v 409.505n 0.0v 419.495n 0.0v 419.505n 0.0v 429.495n 0.0v 429.505n 0.0v 439.495n 0.0v 439.505n 0.0v 449.495n 0.0v 449.505n 0.0v 459.495n 0.0v 459.505n 0.0v 469.495n 0.0v 469.505n 0.0v 479.495n 0.0v 479.505n 0.0v 489.495n 0.0v 489.505n 0.0v 499.495n 0.0v 499.505n 1.8v 509.495n 1.8v 509.505n 0.0v 519.495n 0.0v 519.505n 0.0v 529.495n 0.0v 529.505n 0.0v 539.495n 0.0v 539.505n 0.0v 549.495n 0.0v 549.505n 0.0v 559.495n 0.0v 559.505n 0.0v 569.495n 0.0v 569.505n 0.0v 579.495n 0.0v 579.505n 0.0v 589.495n 0.0v 589.505n 0.0v 599.495n 0.0v 599.505n 0.0v 609.495n 0.0v 609.505n 0.0v 619.495n 0.0v 619.505n 0.0v 629.495n 0.0v 629.505n 0.0v 639.495n 0.0v 639.505n 0.0v 649.495n 0.0v 649.505n 1.8v 659.495n 1.8v 659.505n 1.8v 669.495n 1.8v 669.505n 0.0v 679.495n 0.0v 679.505n 0.0v 689.495n 0.0v 689.505n 0.0v 699.495n 0.0v 699.505n 0.0v 709.495n 0.0v 709.505n 0.0v 719.495n 0.0v 719.505n 0.0v 729.495n 0.0v 729.505n 0.0v 739.495n 0.0v 739.505n 1.8v 749.495n 1.8v 749.505n 1.8v 759.495n 1.8v 759.505n 1.8v 769.495n 1.8v 769.505n 0.0v 779.495n 0.0v 779.505n 0.0v 789.495n 0.0v 789.505n 0.0v 799.495n 0.0v 799.505n 0.0v 809.495n 0.0v 809.505n 0.0v 819.495n 0.0v 819.505n 0.0v 829.495n 0.0v 829.505n 0.0v 839.495n 0.0v 839.505n 0.0v 849.495n 0.0v 849.505n 0.0v 859.495n 0.0v 859.505n 0.0v 869.495n 0.0v 869.505n 0.0v 879.495n 0.0v 879.505n 0.0v 889.495n 0.0v 889.505n 0.0v 899.495n 0.0v 899.505n 1.8v 909.495n 1.8v 909.505n 1.8v 919.495n 1.8v 919.505n 1.8v 929.495n 1.8v 929.505n 1.8v 939.495n 1.8v 939.505n 1.8v 949.495n 1.8v 949.505n 1.8v 959.495n 1.8v 959.505n 1.8v 969.495n 1.8v 969.505n 1.8v 979.495n 1.8v 979.505n 1.8v 989.495n 1.8v 989.505n 0.0v 999.495n 0.0v 999.505n 1.8v 1009.495n 1.8v 1009.505n 1.8v 1019.495n 1.8v 1019.505n 1.8v 1029.495n 1.8v 1029.505n 1.8v 1039.495n 1.8v 1039.505n 1.8v 1049.495n 1.8v 1049.505n 1.8v 1059.495n 1.8v 1059.505n 0.0v 1069.495n 0.0v 1069.505n 0.0v 1079.495n 0.0v 1079.505n 0.0v 1089.495n 0.0v 1089.505n 0.0v 1099.495n 0.0v 1099.505n 1.8v 1109.495n 1.8v 1109.505n 1.8v 1119.495n 1.8v 1119.505n 0.0v 1129.495n 0.0v 1129.505n 1.8v 1139.495n 1.8v 1139.505n 1.8v 1149.495n 1.8v 1149.505n 1.8v 1159.495n 1.8v 1159.505n 1.8v 1169.495n 1.8v 1169.505n 1.8v 1179.495n 1.8v 1179.505n 1.8v 1189.495n 1.8v 1189.505n 1.8v 1199.495n 1.8v 1199.505n 1.8v 1209.495n 1.8v 1209.505n 0.0v 1219.495n 0.0v 1219.505n 1.8v 1229.495n 1.8v 1229.505n 1.8v 1239.495n 1.8v 1239.505n 0.0v 1249.495n 0.0v 1249.505n 0.0v 1259.495n 0.0v 1259.505n 1.8v 1269.495n 1.8v 1269.505n 1.8v 1279.495n 1.8v 1279.505n 1.8v 1289.495n 1.8v 1289.505n 1.8v 1299.495n 1.8v 1299.505n 1.8v 1309.495n 1.8v 1309.505n 1.8v 1319.495n 1.8v 1319.505n 1.8v 1329.495n 1.8v 1329.505n 1.8v 1339.495n 1.8v 1339.505n 1.8v 1349.495n 1.8v 1349.505n 1.8v 1359.495n 1.8v 1359.505n 1.8v 1369.495n 1.8v 1369.505n 1.8v 1379.495n 1.8v 1379.505n 1.8v 1389.495n 1.8v 1389.505n 0.0v 1399.495n 0.0v 1399.505n 0.0v 1409.495n 0.0v 1409.505n 1.8v 1419.495n 1.8v 1419.505n 1.8v 1429.495n 1.8v 1429.505n 1.8v 1439.495n 1.8v 1439.505n 1.8v 1449.495n 1.8v 1449.505n 1.8v 1459.495n 1.8v 1459.505n 1.8v 1469.495n 1.8v 1469.505n 1.8v 1479.495n 1.8v 1479.505n 1.8v 1489.495n 1.8v 1489.505n 1.8v 1499.495n 1.8v 1499.505n 1.8v 1509.495n 1.8v 1509.505n 1.8v 1519.495n 1.8v 1519.505n 1.8v 1529.495n 1.8v 1529.505n 1.8v 1539.495n 1.8v 1539.505n 1.8v 1549.495n 1.8v 1549.505n 1.8v 1559.495n 1.8v 1559.505n 1.8v 1569.495n 1.8v 1569.505n 0.0v 1579.495n 0.0v 1579.505n 0.0v 1589.495n 0.0v 1589.505n 1.8v 1599.495n 1.8v 1599.505n 1.8v 1609.495n 1.8v 1609.505n 0.0v 1619.495n 0.0v 1619.505n 0.0v 1629.495n 0.0v 1629.505n 0.0v 1639.495n 0.0v 1639.505n 0.0v 1649.495n 0.0v 1649.505n 0.0v 1659.495n 0.0v 1659.505n 1.8v 1669.495n 1.8v 1669.505n 1.8v 1679.495n 1.8v 1679.505n 1.8v 1689.495n 1.8v 1689.505n 0.0v 1699.495n 0.0v 1699.505n 0.0v 1709.495n 0.0v 1709.505n 0.0v 1719.495n 0.0v 1719.505n 0.0v 1729.495n 0.0v 1729.505n 0.0v 1739.495n 0.0v 1739.505n 0.0v 1749.495n 0.0v 1749.505n 0.0v 1759.495n 0.0v 1759.505n 0.0v 1769.495n 0.0v 1769.505n 0.0v 1779.495n 0.0v 1779.505n 1.8v 1789.495n 1.8v 1789.505n 1.8v 1799.495n 1.8v 1799.505n 1.8v 1809.495n 1.8v 1809.505n 1.8v 1819.495n 1.8v 1819.505n 1.8v 1829.495n 1.8v 1829.505n 1.8v 1839.495n 1.8v 1839.505n 0.0v 1849.495n 0.0v 1849.505n 0.0v 1859.495n 0.0v 1859.505n 0.0v 1869.495n 0.0v 1869.505n 0.0v 1879.495n 0.0v 1879.505n 0.0v 1889.495n 0.0v 1889.505n 0.0v 1899.495n 0.0v 1899.505n 1.8v 1909.495n 1.8v 1909.505n 1.8v 1919.495n 1.8v 1919.505n 1.8v 1929.495n 1.8v 1929.505n 1.8v 1939.495n 1.8v 1939.505n 0.0v 1949.495n 0.0v 1949.505n 1.8v 1959.495n 1.8v 1959.505n 1.8v 1969.495n 1.8v 1969.505n 1.8v 1979.495n 1.8v 1979.505n 1.8v 1989.495n 1.8v 1989.505n 0.0v 1999.495n 0.0v 1999.505n 0.0v 2009.495n 0.0v 2009.505n 0.0v 2019.495n 0.0v 2019.505n 0.0v 2029.495n 0.0v 2029.505n 0.0v 2039.495n 0.0v 2039.505n 1.8v 2049.495n 1.8v 2049.505n 1.8v )
* (time, data): [(0, 0), (10, 0), (20, 1), (30, 0), (40, 0), (50, 0), (60, 0), (70, 0), (80, 0), (90, 0), (100, 0), (110, 0), (120, 0), (130, 0), (140, 0), (150, 0), (160, 0), (170, 1), (180, 1), (190, 1), (200, 1), (210, 1), (220, 1), (230, 1), (240, 1), (250, 1), (260, 1), (270, 1), (280, 0), (290, 0), (300, 0), (310, 0), (320, 1), (330, 1), (340, 0), (350, 0), (360, 0), (370, 0), (380, 0), (390, 0), (400, 0), (410, 1), (420, 1), (430, 1), (440, 1), (450, 1), (460, 1), (470, 1), (480, 1), (490, 1), (500, 0), (510, 0), (520, 0), (530, 1), (540, 1), (550, 1), (560, 1), (570, 1), (580, 1), (590, 1), (600, 1), (610, 1), (620, 1), (630, 1), (640, 1), (650, 1), (660, 1), (670, 0), (680, 0), (690, 0), (700, 0), (710, 0), (720, 0), (730, 0), (740, 1), (750, 1), (760, 1), (770, 1), (780, 1), (790, 1), (800, 1), (810, 1), (820, 1), (830, 1), (840, 1), (850, 1), (860, 1), (870, 1), (880, 1), (890, 1), (900, 0), (910, 1), (920, 1), (930, 1), (940, 1), (950, 1), (960, 1), (970, 1), (980, 1), (990, 1), (1000, 0), (1010, 0), (1020, 0), (1030, 0), (1040, 1), (1050, 1), (1060, 0), (1070, 0), (1080, 0), (1090, 0), (1100, 0), (1110, 0), (1120, 1), (1130, 1), (1140, 1), (1150, 0), (1160, 0), (1170, 0), (1180, 0), (1190, 0), (1200, 0), (1210, 1), (1220, 1), (1230, 0), (1240, 1), (1250, 0), (1260, 0), (1270, 0), (1280, 0), (1290, 0), (1300, 0), (1310, 0), (1320, 0), (1330, 0), (1340, 1), (1350, 0), (1360, 0), (1370, 0), (1380, 0), (1390, 0), (1400, 0), (1410, 0), (1420, 0), (1430, 0), (1440, 0), (1450, 0), (1460, 0), (1470, 0), (1480, 1), (1490, 1), (1500, 1), (1510, 1), (1520, 1), (1530, 1), (1540, 1), (1550, 0), (1560, 0), (1570, 0), (1580, 1), (1590, 1), (1600, 1), (1610, 0), (1620, 0), (1630, 0), (1640, 0), (1650, 0), (1660, 1), (1670, 1), (1680, 0), (1690, 1), (1700, 1), (1710, 0), (1720, 0), (1730, 1), (1740, 1), (1750, 1), (1760, 1), (1770, 1), (1780, 1), (1790, 1), (1800, 0), (1810, 0), (1820, 0), (1830, 0), (1840, 1), (1850, 0), (1860, 0), (1870, 0), (1880, 0), (1890, 0), (1900, 1), (1910, 1), (1920, 1), (1930, 1), (1940, 1), (1950, 0), (1960, 0), (1970, 0), (1980, 0), (1990, 1), (2000, 1), (2010, 1), (2020, 1), (2030, 1), (2040, 0), (2050, 0)]
Vdin0_27  din0_27  0 PWL (0n 0.0v 9.495n 0.0v 9.505n 0.0v 19.495n 0.0v 19.505n 1.8v 29.495n 1.8v 29.505n 0.0v 39.495n 0.0v 39.505n 0.0v 49.495n 0.0v 49.505n 0.0v 59.495n 0.0v 59.505n 0.0v 69.495n 0.0v 69.505n 0.0v 79.495n 0.0v 79.505n 0.0v 89.495n 0.0v 89.505n 0.0v 99.495n 0.0v 99.505n 0.0v 109.495n 0.0v 109.505n 0.0v 119.495n 0.0v 119.505n 0.0v 129.495n 0.0v 129.505n 0.0v 139.495n 0.0v 139.505n 0.0v 149.495n 0.0v 149.505n 0.0v 159.495n 0.0v 159.505n 0.0v 169.495n 0.0v 169.505n 1.8v 179.495n 1.8v 179.505n 1.8v 189.495n 1.8v 189.505n 1.8v 199.495n 1.8v 199.505n 1.8v 209.495n 1.8v 209.505n 1.8v 219.495n 1.8v 219.505n 1.8v 229.495n 1.8v 229.505n 1.8v 239.495n 1.8v 239.505n 1.8v 249.495n 1.8v 249.505n 1.8v 259.495n 1.8v 259.505n 1.8v 269.495n 1.8v 269.505n 1.8v 279.495n 1.8v 279.505n 0.0v 289.495n 0.0v 289.505n 0.0v 299.495n 0.0v 299.505n 0.0v 309.495n 0.0v 309.505n 0.0v 319.495n 0.0v 319.505n 1.8v 329.495n 1.8v 329.505n 1.8v 339.495n 1.8v 339.505n 0.0v 349.495n 0.0v 349.505n 0.0v 359.495n 0.0v 359.505n 0.0v 369.495n 0.0v 369.505n 0.0v 379.495n 0.0v 379.505n 0.0v 389.495n 0.0v 389.505n 0.0v 399.495n 0.0v 399.505n 0.0v 409.495n 0.0v 409.505n 1.8v 419.495n 1.8v 419.505n 1.8v 429.495n 1.8v 429.505n 1.8v 439.495n 1.8v 439.505n 1.8v 449.495n 1.8v 449.505n 1.8v 459.495n 1.8v 459.505n 1.8v 469.495n 1.8v 469.505n 1.8v 479.495n 1.8v 479.505n 1.8v 489.495n 1.8v 489.505n 1.8v 499.495n 1.8v 499.505n 0.0v 509.495n 0.0v 509.505n 0.0v 519.495n 0.0v 519.505n 0.0v 529.495n 0.0v 529.505n 1.8v 539.495n 1.8v 539.505n 1.8v 549.495n 1.8v 549.505n 1.8v 559.495n 1.8v 559.505n 1.8v 569.495n 1.8v 569.505n 1.8v 579.495n 1.8v 579.505n 1.8v 589.495n 1.8v 589.505n 1.8v 599.495n 1.8v 599.505n 1.8v 609.495n 1.8v 609.505n 1.8v 619.495n 1.8v 619.505n 1.8v 629.495n 1.8v 629.505n 1.8v 639.495n 1.8v 639.505n 1.8v 649.495n 1.8v 649.505n 1.8v 659.495n 1.8v 659.505n 1.8v 669.495n 1.8v 669.505n 0.0v 679.495n 0.0v 679.505n 0.0v 689.495n 0.0v 689.505n 0.0v 699.495n 0.0v 699.505n 0.0v 709.495n 0.0v 709.505n 0.0v 719.495n 0.0v 719.505n 0.0v 729.495n 0.0v 729.505n 0.0v 739.495n 0.0v 739.505n 1.8v 749.495n 1.8v 749.505n 1.8v 759.495n 1.8v 759.505n 1.8v 769.495n 1.8v 769.505n 1.8v 779.495n 1.8v 779.505n 1.8v 789.495n 1.8v 789.505n 1.8v 799.495n 1.8v 799.505n 1.8v 809.495n 1.8v 809.505n 1.8v 819.495n 1.8v 819.505n 1.8v 829.495n 1.8v 829.505n 1.8v 839.495n 1.8v 839.505n 1.8v 849.495n 1.8v 849.505n 1.8v 859.495n 1.8v 859.505n 1.8v 869.495n 1.8v 869.505n 1.8v 879.495n 1.8v 879.505n 1.8v 889.495n 1.8v 889.505n 1.8v 899.495n 1.8v 899.505n 0.0v 909.495n 0.0v 909.505n 1.8v 919.495n 1.8v 919.505n 1.8v 929.495n 1.8v 929.505n 1.8v 939.495n 1.8v 939.505n 1.8v 949.495n 1.8v 949.505n 1.8v 959.495n 1.8v 959.505n 1.8v 969.495n 1.8v 969.505n 1.8v 979.495n 1.8v 979.505n 1.8v 989.495n 1.8v 989.505n 1.8v 999.495n 1.8v 999.505n 0.0v 1009.495n 0.0v 1009.505n 0.0v 1019.495n 0.0v 1019.505n 0.0v 1029.495n 0.0v 1029.505n 0.0v 1039.495n 0.0v 1039.505n 1.8v 1049.495n 1.8v 1049.505n 1.8v 1059.495n 1.8v 1059.505n 0.0v 1069.495n 0.0v 1069.505n 0.0v 1079.495n 0.0v 1079.505n 0.0v 1089.495n 0.0v 1089.505n 0.0v 1099.495n 0.0v 1099.505n 0.0v 1109.495n 0.0v 1109.505n 0.0v 1119.495n 0.0v 1119.505n 1.8v 1129.495n 1.8v 1129.505n 1.8v 1139.495n 1.8v 1139.505n 1.8v 1149.495n 1.8v 1149.505n 0.0v 1159.495n 0.0v 1159.505n 0.0v 1169.495n 0.0v 1169.505n 0.0v 1179.495n 0.0v 1179.505n 0.0v 1189.495n 0.0v 1189.505n 0.0v 1199.495n 0.0v 1199.505n 0.0v 1209.495n 0.0v 1209.505n 1.8v 1219.495n 1.8v 1219.505n 1.8v 1229.495n 1.8v 1229.505n 0.0v 1239.495n 0.0v 1239.505n 1.8v 1249.495n 1.8v 1249.505n 0.0v 1259.495n 0.0v 1259.505n 0.0v 1269.495n 0.0v 1269.505n 0.0v 1279.495n 0.0v 1279.505n 0.0v 1289.495n 0.0v 1289.505n 0.0v 1299.495n 0.0v 1299.505n 0.0v 1309.495n 0.0v 1309.505n 0.0v 1319.495n 0.0v 1319.505n 0.0v 1329.495n 0.0v 1329.505n 0.0v 1339.495n 0.0v 1339.505n 1.8v 1349.495n 1.8v 1349.505n 0.0v 1359.495n 0.0v 1359.505n 0.0v 1369.495n 0.0v 1369.505n 0.0v 1379.495n 0.0v 1379.505n 0.0v 1389.495n 0.0v 1389.505n 0.0v 1399.495n 0.0v 1399.505n 0.0v 1409.495n 0.0v 1409.505n 0.0v 1419.495n 0.0v 1419.505n 0.0v 1429.495n 0.0v 1429.505n 0.0v 1439.495n 0.0v 1439.505n 0.0v 1449.495n 0.0v 1449.505n 0.0v 1459.495n 0.0v 1459.505n 0.0v 1469.495n 0.0v 1469.505n 0.0v 1479.495n 0.0v 1479.505n 1.8v 1489.495n 1.8v 1489.505n 1.8v 1499.495n 1.8v 1499.505n 1.8v 1509.495n 1.8v 1509.505n 1.8v 1519.495n 1.8v 1519.505n 1.8v 1529.495n 1.8v 1529.505n 1.8v 1539.495n 1.8v 1539.505n 1.8v 1549.495n 1.8v 1549.505n 0.0v 1559.495n 0.0v 1559.505n 0.0v 1569.495n 0.0v 1569.505n 0.0v 1579.495n 0.0v 1579.505n 1.8v 1589.495n 1.8v 1589.505n 1.8v 1599.495n 1.8v 1599.505n 1.8v 1609.495n 1.8v 1609.505n 0.0v 1619.495n 0.0v 1619.505n 0.0v 1629.495n 0.0v 1629.505n 0.0v 1639.495n 0.0v 1639.505n 0.0v 1649.495n 0.0v 1649.505n 0.0v 1659.495n 0.0v 1659.505n 1.8v 1669.495n 1.8v 1669.505n 1.8v 1679.495n 1.8v 1679.505n 0.0v 1689.495n 0.0v 1689.505n 1.8v 1699.495n 1.8v 1699.505n 1.8v 1709.495n 1.8v 1709.505n 0.0v 1719.495n 0.0v 1719.505n 0.0v 1729.495n 0.0v 1729.505n 1.8v 1739.495n 1.8v 1739.505n 1.8v 1749.495n 1.8v 1749.505n 1.8v 1759.495n 1.8v 1759.505n 1.8v 1769.495n 1.8v 1769.505n 1.8v 1779.495n 1.8v 1779.505n 1.8v 1789.495n 1.8v 1789.505n 1.8v 1799.495n 1.8v 1799.505n 0.0v 1809.495n 0.0v 1809.505n 0.0v 1819.495n 0.0v 1819.505n 0.0v 1829.495n 0.0v 1829.505n 0.0v 1839.495n 0.0v 1839.505n 1.8v 1849.495n 1.8v 1849.505n 0.0v 1859.495n 0.0v 1859.505n 0.0v 1869.495n 0.0v 1869.505n 0.0v 1879.495n 0.0v 1879.505n 0.0v 1889.495n 0.0v 1889.505n 0.0v 1899.495n 0.0v 1899.505n 1.8v 1909.495n 1.8v 1909.505n 1.8v 1919.495n 1.8v 1919.505n 1.8v 1929.495n 1.8v 1929.505n 1.8v 1939.495n 1.8v 1939.505n 1.8v 1949.495n 1.8v 1949.505n 0.0v 1959.495n 0.0v 1959.505n 0.0v 1969.495n 0.0v 1969.505n 0.0v 1979.495n 0.0v 1979.505n 0.0v 1989.495n 0.0v 1989.505n 1.8v 1999.495n 1.8v 1999.505n 1.8v 2009.495n 1.8v 2009.505n 1.8v 2019.495n 1.8v 2019.505n 1.8v 2029.495n 1.8v 2029.505n 1.8v 2039.495n 1.8v 2039.505n 0.0v 2049.495n 0.0v 2049.505n 0.0v )
* (time, data): [(0, 0), (10, 0), (20, 1), (30, 0), (40, 0), (50, 0), (60, 0), (70, 0), (80, 0), (90, 0), (100, 0), (110, 0), (120, 0), (130, 0), (140, 0), (150, 0), (160, 0), (170, 0), (180, 0), (190, 0), (200, 1), (210, 1), (220, 1), (230, 1), (240, 0), (250, 0), (260, 0), (270, 1), (280, 0), (290, 0), (300, 0), (310, 1), (320, 0), (330, 0), (340, 0), (350, 0), (360, 0), (370, 0), (380, 0), (390, 1), (400, 1), (410, 1), (420, 1), (430, 1), (440, 1), (450, 1), (460, 1), (470, 1), (480, 1), (490, 1), (500, 0), (510, 1), (520, 1), (530, 0), (540, 0), (550, 0), (560, 0), (570, 0), (580, 0), (590, 0), (600, 0), (610, 0), (620, 1), (630, 1), (640, 1), (650, 1), (660, 1), (670, 0), (680, 0), (690, 0), (700, 0), (710, 0), (720, 0), (730, 0), (740, 0), (750, 0), (760, 0), (770, 0), (780, 0), (790, 0), (800, 0), (810, 0), (820, 0), (830, 0), (840, 0), (850, 0), (860, 1), (870, 1), (880, 1), (890, 1), (900, 0), (910, 0), (920, 1), (930, 1), (940, 1), (950, 1), (960, 1), (970, 1), (980, 1), (990, 1), (1000, 0), (1010, 0), (1020, 0), (1030, 0), (1040, 0), (1050, 0), (1060, 0), (1070, 0), (1080, 0), (1090, 0), (1100, 0), (1110, 0), (1120, 1), (1130, 1), (1140, 1), (1150, 0), (1160, 0), (1170, 0), (1180, 0), (1190, 0), (1200, 0), (1210, 1), (1220, 1), (1230, 1), (1240, 0), (1250, 0), (1260, 1), (1270, 1), (1280, 1), (1290, 1), (1300, 1), (1310, 1), (1320, 1), (1330, 1), (1340, 0), (1350, 1), (1360, 1), (1370, 1), (1380, 1), (1390, 0), (1400, 0), (1410, 1), (1420, 0), (1430, 0), (1440, 0), (1450, 0), (1460, 0), (1470, 0), (1480, 0), (1490, 0), (1500, 0), (1510, 1), (1520, 1), (1530, 1), (1540, 1), (1550, 1), (1560, 1), (1570, 1), (1580, 1), (1590, 0), (1600, 0), (1610, 0), (1620, 0), (1630, 0), (1640, 0), (1650, 0), (1660, 0), (1670, 0), (1680, 0), (1690, 0), (1700, 0), (1710, 0), (1720, 0), (1730, 1), (1740, 1), (1750, 1), (1760, 1), (1770, 1), (1780, 0), (1790, 0), (1800, 1), (1810, 1), (1820, 1), (1830, 1), (1840, 0), (1850, 1), (1860, 1), (1870, 1), (1880, 1), (1890, 1), (1900, 0), (1910, 0), (1920, 0), (1930, 0), (1940, 1), (1950, 0), (1960, 0), (1970, 0), (1980, 0), (1990, 1), (2000, 1), (2010, 1), (2020, 1), (2030, 1), (2040, 0), (2050, 0)]
Vdin0_28  din0_28  0 PWL (0n 0.0v 9.495n 0.0v 9.505n 0.0v 19.495n 0.0v 19.505n 1.8v 29.495n 1.8v 29.505n 0.0v 39.495n 0.0v 39.505n 0.0v 49.495n 0.0v 49.505n 0.0v 59.495n 0.0v 59.505n 0.0v 69.495n 0.0v 69.505n 0.0v 79.495n 0.0v 79.505n 0.0v 89.495n 0.0v 89.505n 0.0v 99.495n 0.0v 99.505n 0.0v 109.495n 0.0v 109.505n 0.0v 119.495n 0.0v 119.505n 0.0v 129.495n 0.0v 129.505n 0.0v 139.495n 0.0v 139.505n 0.0v 149.495n 0.0v 149.505n 0.0v 159.495n 0.0v 159.505n 0.0v 169.495n 0.0v 169.505n 0.0v 179.495n 0.0v 179.505n 0.0v 189.495n 0.0v 189.505n 0.0v 199.495n 0.0v 199.505n 1.8v 209.495n 1.8v 209.505n 1.8v 219.495n 1.8v 219.505n 1.8v 229.495n 1.8v 229.505n 1.8v 239.495n 1.8v 239.505n 0.0v 249.495n 0.0v 249.505n 0.0v 259.495n 0.0v 259.505n 0.0v 269.495n 0.0v 269.505n 1.8v 279.495n 1.8v 279.505n 0.0v 289.495n 0.0v 289.505n 0.0v 299.495n 0.0v 299.505n 0.0v 309.495n 0.0v 309.505n 1.8v 319.495n 1.8v 319.505n 0.0v 329.495n 0.0v 329.505n 0.0v 339.495n 0.0v 339.505n 0.0v 349.495n 0.0v 349.505n 0.0v 359.495n 0.0v 359.505n 0.0v 369.495n 0.0v 369.505n 0.0v 379.495n 0.0v 379.505n 0.0v 389.495n 0.0v 389.505n 1.8v 399.495n 1.8v 399.505n 1.8v 409.495n 1.8v 409.505n 1.8v 419.495n 1.8v 419.505n 1.8v 429.495n 1.8v 429.505n 1.8v 439.495n 1.8v 439.505n 1.8v 449.495n 1.8v 449.505n 1.8v 459.495n 1.8v 459.505n 1.8v 469.495n 1.8v 469.505n 1.8v 479.495n 1.8v 479.505n 1.8v 489.495n 1.8v 489.505n 1.8v 499.495n 1.8v 499.505n 0.0v 509.495n 0.0v 509.505n 1.8v 519.495n 1.8v 519.505n 1.8v 529.495n 1.8v 529.505n 0.0v 539.495n 0.0v 539.505n 0.0v 549.495n 0.0v 549.505n 0.0v 559.495n 0.0v 559.505n 0.0v 569.495n 0.0v 569.505n 0.0v 579.495n 0.0v 579.505n 0.0v 589.495n 0.0v 589.505n 0.0v 599.495n 0.0v 599.505n 0.0v 609.495n 0.0v 609.505n 0.0v 619.495n 0.0v 619.505n 1.8v 629.495n 1.8v 629.505n 1.8v 639.495n 1.8v 639.505n 1.8v 649.495n 1.8v 649.505n 1.8v 659.495n 1.8v 659.505n 1.8v 669.495n 1.8v 669.505n 0.0v 679.495n 0.0v 679.505n 0.0v 689.495n 0.0v 689.505n 0.0v 699.495n 0.0v 699.505n 0.0v 709.495n 0.0v 709.505n 0.0v 719.495n 0.0v 719.505n 0.0v 729.495n 0.0v 729.505n 0.0v 739.495n 0.0v 739.505n 0.0v 749.495n 0.0v 749.505n 0.0v 759.495n 0.0v 759.505n 0.0v 769.495n 0.0v 769.505n 0.0v 779.495n 0.0v 779.505n 0.0v 789.495n 0.0v 789.505n 0.0v 799.495n 0.0v 799.505n 0.0v 809.495n 0.0v 809.505n 0.0v 819.495n 0.0v 819.505n 0.0v 829.495n 0.0v 829.505n 0.0v 839.495n 0.0v 839.505n 0.0v 849.495n 0.0v 849.505n 0.0v 859.495n 0.0v 859.505n 1.8v 869.495n 1.8v 869.505n 1.8v 879.495n 1.8v 879.505n 1.8v 889.495n 1.8v 889.505n 1.8v 899.495n 1.8v 899.505n 0.0v 909.495n 0.0v 909.505n 0.0v 919.495n 0.0v 919.505n 1.8v 929.495n 1.8v 929.505n 1.8v 939.495n 1.8v 939.505n 1.8v 949.495n 1.8v 949.505n 1.8v 959.495n 1.8v 959.505n 1.8v 969.495n 1.8v 969.505n 1.8v 979.495n 1.8v 979.505n 1.8v 989.495n 1.8v 989.505n 1.8v 999.495n 1.8v 999.505n 0.0v 1009.495n 0.0v 1009.505n 0.0v 1019.495n 0.0v 1019.505n 0.0v 1029.495n 0.0v 1029.505n 0.0v 1039.495n 0.0v 1039.505n 0.0v 1049.495n 0.0v 1049.505n 0.0v 1059.495n 0.0v 1059.505n 0.0v 1069.495n 0.0v 1069.505n 0.0v 1079.495n 0.0v 1079.505n 0.0v 1089.495n 0.0v 1089.505n 0.0v 1099.495n 0.0v 1099.505n 0.0v 1109.495n 0.0v 1109.505n 0.0v 1119.495n 0.0v 1119.505n 1.8v 1129.495n 1.8v 1129.505n 1.8v 1139.495n 1.8v 1139.505n 1.8v 1149.495n 1.8v 1149.505n 0.0v 1159.495n 0.0v 1159.505n 0.0v 1169.495n 0.0v 1169.505n 0.0v 1179.495n 0.0v 1179.505n 0.0v 1189.495n 0.0v 1189.505n 0.0v 1199.495n 0.0v 1199.505n 0.0v 1209.495n 0.0v 1209.505n 1.8v 1219.495n 1.8v 1219.505n 1.8v 1229.495n 1.8v 1229.505n 1.8v 1239.495n 1.8v 1239.505n 0.0v 1249.495n 0.0v 1249.505n 0.0v 1259.495n 0.0v 1259.505n 1.8v 1269.495n 1.8v 1269.505n 1.8v 1279.495n 1.8v 1279.505n 1.8v 1289.495n 1.8v 1289.505n 1.8v 1299.495n 1.8v 1299.505n 1.8v 1309.495n 1.8v 1309.505n 1.8v 1319.495n 1.8v 1319.505n 1.8v 1329.495n 1.8v 1329.505n 1.8v 1339.495n 1.8v 1339.505n 0.0v 1349.495n 0.0v 1349.505n 1.8v 1359.495n 1.8v 1359.505n 1.8v 1369.495n 1.8v 1369.505n 1.8v 1379.495n 1.8v 1379.505n 1.8v 1389.495n 1.8v 1389.505n 0.0v 1399.495n 0.0v 1399.505n 0.0v 1409.495n 0.0v 1409.505n 1.8v 1419.495n 1.8v 1419.505n 0.0v 1429.495n 0.0v 1429.505n 0.0v 1439.495n 0.0v 1439.505n 0.0v 1449.495n 0.0v 1449.505n 0.0v 1459.495n 0.0v 1459.505n 0.0v 1469.495n 0.0v 1469.505n 0.0v 1479.495n 0.0v 1479.505n 0.0v 1489.495n 0.0v 1489.505n 0.0v 1499.495n 0.0v 1499.505n 0.0v 1509.495n 0.0v 1509.505n 1.8v 1519.495n 1.8v 1519.505n 1.8v 1529.495n 1.8v 1529.505n 1.8v 1539.495n 1.8v 1539.505n 1.8v 1549.495n 1.8v 1549.505n 1.8v 1559.495n 1.8v 1559.505n 1.8v 1569.495n 1.8v 1569.505n 1.8v 1579.495n 1.8v 1579.505n 1.8v 1589.495n 1.8v 1589.505n 0.0v 1599.495n 0.0v 1599.505n 0.0v 1609.495n 0.0v 1609.505n 0.0v 1619.495n 0.0v 1619.505n 0.0v 1629.495n 0.0v 1629.505n 0.0v 1639.495n 0.0v 1639.505n 0.0v 1649.495n 0.0v 1649.505n 0.0v 1659.495n 0.0v 1659.505n 0.0v 1669.495n 0.0v 1669.505n 0.0v 1679.495n 0.0v 1679.505n 0.0v 1689.495n 0.0v 1689.505n 0.0v 1699.495n 0.0v 1699.505n 0.0v 1709.495n 0.0v 1709.505n 0.0v 1719.495n 0.0v 1719.505n 0.0v 1729.495n 0.0v 1729.505n 1.8v 1739.495n 1.8v 1739.505n 1.8v 1749.495n 1.8v 1749.505n 1.8v 1759.495n 1.8v 1759.505n 1.8v 1769.495n 1.8v 1769.505n 1.8v 1779.495n 1.8v 1779.505n 0.0v 1789.495n 0.0v 1789.505n 0.0v 1799.495n 0.0v 1799.505n 1.8v 1809.495n 1.8v 1809.505n 1.8v 1819.495n 1.8v 1819.505n 1.8v 1829.495n 1.8v 1829.505n 1.8v 1839.495n 1.8v 1839.505n 0.0v 1849.495n 0.0v 1849.505n 1.8v 1859.495n 1.8v 1859.505n 1.8v 1869.495n 1.8v 1869.505n 1.8v 1879.495n 1.8v 1879.505n 1.8v 1889.495n 1.8v 1889.505n 1.8v 1899.495n 1.8v 1899.505n 0.0v 1909.495n 0.0v 1909.505n 0.0v 1919.495n 0.0v 1919.505n 0.0v 1929.495n 0.0v 1929.505n 0.0v 1939.495n 0.0v 1939.505n 1.8v 1949.495n 1.8v 1949.505n 0.0v 1959.495n 0.0v 1959.505n 0.0v 1969.495n 0.0v 1969.505n 0.0v 1979.495n 0.0v 1979.505n 0.0v 1989.495n 0.0v 1989.505n 1.8v 1999.495n 1.8v 1999.505n 1.8v 2009.495n 1.8v 2009.505n 1.8v 2019.495n 1.8v 2019.505n 1.8v 2029.495n 1.8v 2029.505n 1.8v 2039.495n 1.8v 2039.505n 0.0v 2049.495n 0.0v 2049.505n 0.0v )
* (time, data): [(0, 0), (10, 1), (20, 0), (30, 0), (40, 0), (50, 0), (60, 0), (70, 0), (80, 1), (90, 1), (100, 1), (110, 1), (120, 1), (130, 1), (140, 1), (150, 1), (160, 1), (170, 0), (180, 0), (190, 0), (200, 0), (210, 0), (220, 0), (230, 0), (240, 0), (250, 0), (260, 0), (270, 0), (280, 0), (290, 0), (300, 0), (310, 0), (320, 1), (330, 1), (340, 0), (350, 0), (360, 0), (370, 0), (380, 0), (390, 1), (400, 0), (410, 1), (420, 1), (430, 1), (440, 1), (450, 1), (460, 1), (470, 1), (480, 1), (490, 1), (500, 1), (510, 0), (520, 0), (530, 0), (540, 1), (550, 1), (560, 1), (570, 1), (580, 1), (590, 1), (600, 0), (610, 0), (620, 1), (630, 1), (640, 1), (650, 0), (660, 0), (670, 1), (680, 1), (690, 1), (700, 1), (710, 1), (720, 1), (730, 1), (740, 1), (750, 0), (760, 1), (770, 0), (780, 0), (790, 0), (800, 0), (810, 0), (820, 0), (830, 0), (840, 0), (850, 0), (860, 0), (870, 0), (880, 0), (890, 0), (900, 1), (910, 0), (920, 1), (930, 1), (940, 1), (950, 1), (960, 1), (970, 1), (980, 1), (990, 1), (1000, 0), (1010, 0), (1020, 0), (1030, 0), (1040, 1), (1050, 1), (1060, 1), (1070, 1), (1080, 1), (1090, 1), (1100, 0), (1110, 0), (1120, 1), (1130, 0), (1140, 0), (1150, 0), (1160, 0), (1170, 0), (1180, 0), (1190, 0), (1200, 0), (1210, 0), (1220, 1), (1230, 1), (1240, 1), (1250, 0), (1260, 1), (1270, 1), (1280, 1), (1290, 1), (1300, 1), (1310, 1), (1320, 1), (1330, 1), (1340, 0), (1350, 1), (1360, 1), (1370, 1), (1380, 1), (1390, 0), (1400, 0), (1410, 1), (1420, 1), (1430, 1), (1440, 1), (1450, 1), (1460, 1), (1470, 1), (1480, 0), (1490, 0), (1500, 0), (1510, 0), (1520, 0), (1530, 0), (1540, 0), (1550, 1), (1560, 1), (1570, 1), (1580, 1), (1590, 1), (1600, 1), (1610, 0), (1620, 0), (1630, 0), (1640, 0), (1650, 0), (1660, 0), (1670, 0), (1680, 1), (1690, 0), (1700, 0), (1710, 0), (1720, 0), (1730, 1), (1740, 1), (1750, 1), (1760, 1), (1770, 1), (1780, 0), (1790, 0), (1800, 1), (1810, 1), (1820, 1), (1830, 1), (1840, 0), (1850, 0), (1860, 0), (1870, 0), (1880, 0), (1890, 0), (1900, 1), (1910, 1), (1920, 1), (1930, 1), (1940, 0), (1950, 0), (1960, 0), (1970, 0), (1980, 0), (1990, 1), (2000, 1), (2010, 1), (2020, 1), (2030, 1), (2040, 1), (2050, 1)]
Vdin0_29  din0_29  0 PWL (0n 0.0v 9.495n 0.0v 9.505n 1.8v 19.495n 1.8v 19.505n 0.0v 29.495n 0.0v 29.505n 0.0v 39.495n 0.0v 39.505n 0.0v 49.495n 0.0v 49.505n 0.0v 59.495n 0.0v 59.505n 0.0v 69.495n 0.0v 69.505n 0.0v 79.495n 0.0v 79.505n 1.8v 89.495n 1.8v 89.505n 1.8v 99.495n 1.8v 99.505n 1.8v 109.495n 1.8v 109.505n 1.8v 119.495n 1.8v 119.505n 1.8v 129.495n 1.8v 129.505n 1.8v 139.495n 1.8v 139.505n 1.8v 149.495n 1.8v 149.505n 1.8v 159.495n 1.8v 159.505n 1.8v 169.495n 1.8v 169.505n 0.0v 179.495n 0.0v 179.505n 0.0v 189.495n 0.0v 189.505n 0.0v 199.495n 0.0v 199.505n 0.0v 209.495n 0.0v 209.505n 0.0v 219.495n 0.0v 219.505n 0.0v 229.495n 0.0v 229.505n 0.0v 239.495n 0.0v 239.505n 0.0v 249.495n 0.0v 249.505n 0.0v 259.495n 0.0v 259.505n 0.0v 269.495n 0.0v 269.505n 0.0v 279.495n 0.0v 279.505n 0.0v 289.495n 0.0v 289.505n 0.0v 299.495n 0.0v 299.505n 0.0v 309.495n 0.0v 309.505n 0.0v 319.495n 0.0v 319.505n 1.8v 329.495n 1.8v 329.505n 1.8v 339.495n 1.8v 339.505n 0.0v 349.495n 0.0v 349.505n 0.0v 359.495n 0.0v 359.505n 0.0v 369.495n 0.0v 369.505n 0.0v 379.495n 0.0v 379.505n 0.0v 389.495n 0.0v 389.505n 1.8v 399.495n 1.8v 399.505n 0.0v 409.495n 0.0v 409.505n 1.8v 419.495n 1.8v 419.505n 1.8v 429.495n 1.8v 429.505n 1.8v 439.495n 1.8v 439.505n 1.8v 449.495n 1.8v 449.505n 1.8v 459.495n 1.8v 459.505n 1.8v 469.495n 1.8v 469.505n 1.8v 479.495n 1.8v 479.505n 1.8v 489.495n 1.8v 489.505n 1.8v 499.495n 1.8v 499.505n 1.8v 509.495n 1.8v 509.505n 0.0v 519.495n 0.0v 519.505n 0.0v 529.495n 0.0v 529.505n 0.0v 539.495n 0.0v 539.505n 1.8v 549.495n 1.8v 549.505n 1.8v 559.495n 1.8v 559.505n 1.8v 569.495n 1.8v 569.505n 1.8v 579.495n 1.8v 579.505n 1.8v 589.495n 1.8v 589.505n 1.8v 599.495n 1.8v 599.505n 0.0v 609.495n 0.0v 609.505n 0.0v 619.495n 0.0v 619.505n 1.8v 629.495n 1.8v 629.505n 1.8v 639.495n 1.8v 639.505n 1.8v 649.495n 1.8v 649.505n 0.0v 659.495n 0.0v 659.505n 0.0v 669.495n 0.0v 669.505n 1.8v 679.495n 1.8v 679.505n 1.8v 689.495n 1.8v 689.505n 1.8v 699.495n 1.8v 699.505n 1.8v 709.495n 1.8v 709.505n 1.8v 719.495n 1.8v 719.505n 1.8v 729.495n 1.8v 729.505n 1.8v 739.495n 1.8v 739.505n 1.8v 749.495n 1.8v 749.505n 0.0v 759.495n 0.0v 759.505n 1.8v 769.495n 1.8v 769.505n 0.0v 779.495n 0.0v 779.505n 0.0v 789.495n 0.0v 789.505n 0.0v 799.495n 0.0v 799.505n 0.0v 809.495n 0.0v 809.505n 0.0v 819.495n 0.0v 819.505n 0.0v 829.495n 0.0v 829.505n 0.0v 839.495n 0.0v 839.505n 0.0v 849.495n 0.0v 849.505n 0.0v 859.495n 0.0v 859.505n 0.0v 869.495n 0.0v 869.505n 0.0v 879.495n 0.0v 879.505n 0.0v 889.495n 0.0v 889.505n 0.0v 899.495n 0.0v 899.505n 1.8v 909.495n 1.8v 909.505n 0.0v 919.495n 0.0v 919.505n 1.8v 929.495n 1.8v 929.505n 1.8v 939.495n 1.8v 939.505n 1.8v 949.495n 1.8v 949.505n 1.8v 959.495n 1.8v 959.505n 1.8v 969.495n 1.8v 969.505n 1.8v 979.495n 1.8v 979.505n 1.8v 989.495n 1.8v 989.505n 1.8v 999.495n 1.8v 999.505n 0.0v 1009.495n 0.0v 1009.505n 0.0v 1019.495n 0.0v 1019.505n 0.0v 1029.495n 0.0v 1029.505n 0.0v 1039.495n 0.0v 1039.505n 1.8v 1049.495n 1.8v 1049.505n 1.8v 1059.495n 1.8v 1059.505n 1.8v 1069.495n 1.8v 1069.505n 1.8v 1079.495n 1.8v 1079.505n 1.8v 1089.495n 1.8v 1089.505n 1.8v 1099.495n 1.8v 1099.505n 0.0v 1109.495n 0.0v 1109.505n 0.0v 1119.495n 0.0v 1119.505n 1.8v 1129.495n 1.8v 1129.505n 0.0v 1139.495n 0.0v 1139.505n 0.0v 1149.495n 0.0v 1149.505n 0.0v 1159.495n 0.0v 1159.505n 0.0v 1169.495n 0.0v 1169.505n 0.0v 1179.495n 0.0v 1179.505n 0.0v 1189.495n 0.0v 1189.505n 0.0v 1199.495n 0.0v 1199.505n 0.0v 1209.495n 0.0v 1209.505n 0.0v 1219.495n 0.0v 1219.505n 1.8v 1229.495n 1.8v 1229.505n 1.8v 1239.495n 1.8v 1239.505n 1.8v 1249.495n 1.8v 1249.505n 0.0v 1259.495n 0.0v 1259.505n 1.8v 1269.495n 1.8v 1269.505n 1.8v 1279.495n 1.8v 1279.505n 1.8v 1289.495n 1.8v 1289.505n 1.8v 1299.495n 1.8v 1299.505n 1.8v 1309.495n 1.8v 1309.505n 1.8v 1319.495n 1.8v 1319.505n 1.8v 1329.495n 1.8v 1329.505n 1.8v 1339.495n 1.8v 1339.505n 0.0v 1349.495n 0.0v 1349.505n 1.8v 1359.495n 1.8v 1359.505n 1.8v 1369.495n 1.8v 1369.505n 1.8v 1379.495n 1.8v 1379.505n 1.8v 1389.495n 1.8v 1389.505n 0.0v 1399.495n 0.0v 1399.505n 0.0v 1409.495n 0.0v 1409.505n 1.8v 1419.495n 1.8v 1419.505n 1.8v 1429.495n 1.8v 1429.505n 1.8v 1439.495n 1.8v 1439.505n 1.8v 1449.495n 1.8v 1449.505n 1.8v 1459.495n 1.8v 1459.505n 1.8v 1469.495n 1.8v 1469.505n 1.8v 1479.495n 1.8v 1479.505n 0.0v 1489.495n 0.0v 1489.505n 0.0v 1499.495n 0.0v 1499.505n 0.0v 1509.495n 0.0v 1509.505n 0.0v 1519.495n 0.0v 1519.505n 0.0v 1529.495n 0.0v 1529.505n 0.0v 1539.495n 0.0v 1539.505n 0.0v 1549.495n 0.0v 1549.505n 1.8v 1559.495n 1.8v 1559.505n 1.8v 1569.495n 1.8v 1569.505n 1.8v 1579.495n 1.8v 1579.505n 1.8v 1589.495n 1.8v 1589.505n 1.8v 1599.495n 1.8v 1599.505n 1.8v 1609.495n 1.8v 1609.505n 0.0v 1619.495n 0.0v 1619.505n 0.0v 1629.495n 0.0v 1629.505n 0.0v 1639.495n 0.0v 1639.505n 0.0v 1649.495n 0.0v 1649.505n 0.0v 1659.495n 0.0v 1659.505n 0.0v 1669.495n 0.0v 1669.505n 0.0v 1679.495n 0.0v 1679.505n 1.8v 1689.495n 1.8v 1689.505n 0.0v 1699.495n 0.0v 1699.505n 0.0v 1709.495n 0.0v 1709.505n 0.0v 1719.495n 0.0v 1719.505n 0.0v 1729.495n 0.0v 1729.505n 1.8v 1739.495n 1.8v 1739.505n 1.8v 1749.495n 1.8v 1749.505n 1.8v 1759.495n 1.8v 1759.505n 1.8v 1769.495n 1.8v 1769.505n 1.8v 1779.495n 1.8v 1779.505n 0.0v 1789.495n 0.0v 1789.505n 0.0v 1799.495n 0.0v 1799.505n 1.8v 1809.495n 1.8v 1809.505n 1.8v 1819.495n 1.8v 1819.505n 1.8v 1829.495n 1.8v 1829.505n 1.8v 1839.495n 1.8v 1839.505n 0.0v 1849.495n 0.0v 1849.505n 0.0v 1859.495n 0.0v 1859.505n 0.0v 1869.495n 0.0v 1869.505n 0.0v 1879.495n 0.0v 1879.505n 0.0v 1889.495n 0.0v 1889.505n 0.0v 1899.495n 0.0v 1899.505n 1.8v 1909.495n 1.8v 1909.505n 1.8v 1919.495n 1.8v 1919.505n 1.8v 1929.495n 1.8v 1929.505n 1.8v 1939.495n 1.8v 1939.505n 0.0v 1949.495n 0.0v 1949.505n 0.0v 1959.495n 0.0v 1959.505n 0.0v 1969.495n 0.0v 1969.505n 0.0v 1979.495n 0.0v 1979.505n 0.0v 1989.495n 0.0v 1989.505n 1.8v 1999.495n 1.8v 1999.505n 1.8v 2009.495n 1.8v 2009.505n 1.8v 2019.495n 1.8v 2019.505n 1.8v 2029.495n 1.8v 2029.505n 1.8v 2039.495n 1.8v 2039.505n 1.8v 2049.495n 1.8v 2049.505n 1.8v )
* (time, data): [(0, 0), (10, 0), (20, 1), (30, 1), (40, 1), (50, 1), (60, 1), (70, 1), (80, 1), (90, 1), (100, 1), (110, 0), (120, 0), (130, 0), (140, 0), (150, 0), (160, 0), (170, 0), (180, 0), (190, 0), (200, 1), (210, 1), (220, 1), (230, 1), (240, 0), (250, 0), (260, 0), (270, 1), (280, 1), (290, 1), (300, 1), (310, 1), (320, 0), (330, 0), (340, 0), (350, 0), (360, 0), (370, 0), (380, 0), (390, 1), (400, 1), (410, 1), (420, 1), (430, 1), (440, 1), (450, 1), (460, 1), (470, 1), (480, 1), (490, 1), (500, 1), (510, 0), (520, 0), (530, 1), (540, 1), (550, 1), (560, 1), (570, 1), (580, 1), (590, 1), (600, 1), (610, 1), (620, 0), (630, 0), (640, 0), (650, 0), (660, 0), (670, 1), (680, 1), (690, 1), (700, 1), (710, 1), (720, 1), (730, 1), (740, 0), (750, 1), (760, 0), (770, 0), (780, 0), (790, 0), (800, 0), (810, 0), (820, 0), (830, 0), (840, 0), (850, 0), (860, 1), (870, 1), (880, 1), (890, 1), (900, 0), (910, 1), (920, 0), (930, 0), (940, 0), (950, 0), (960, 0), (970, 0), (980, 0), (990, 1), (1000, 1), (1010, 1), (1020, 1), (1030, 1), (1040, 1), (1050, 1), (1060, 1), (1070, 1), (1080, 1), (1090, 1), (1100, 0), (1110, 0), (1120, 0), (1130, 0), (1140, 0), (1150, 0), (1160, 0), (1170, 0), (1180, 0), (1190, 0), (1200, 0), (1210, 0), (1220, 0), (1230, 1), (1240, 1), (1250, 1), (1260, 1), (1270, 1), (1280, 1), (1290, 1), (1300, 1), (1310, 1), (1320, 1), (1330, 1), (1340, 1), (1350, 0), (1360, 0), (1370, 0), (1380, 0), (1390, 1), (1400, 1), (1410, 0), (1420, 0), (1430, 0), (1440, 0), (1450, 0), (1460, 0), (1470, 0), (1480, 0), (1490, 0), (1500, 0), (1510, 1), (1520, 1), (1530, 1), (1540, 1), (1550, 0), (1560, 0), (1570, 1), (1580, 1), (1590, 1), (1600, 1), (1610, 0), (1620, 0), (1630, 0), (1640, 0), (1650, 0), (1660, 1), (1670, 1), (1680, 1), (1690, 1), (1700, 1), (1710, 0), (1720, 0), (1730, 0), (1740, 0), (1750, 0), (1760, 0), (1770, 0), (1780, 0), (1790, 0), (1800, 1), (1810, 1), (1820, 1), (1830, 1), (1840, 0), (1850, 1), (1860, 1), (1870, 1), (1880, 1), (1890, 1), (1900, 1), (1910, 1), (1920, 1), (1930, 1), (1940, 0), (1950, 0), (1960, 0), (1970, 0), (1980, 0), (1990, 0), (2000, 0), (2010, 0), (2020, 0), (2030, 0), (2040, 1), (2050, 1)]
Vdin0_30  din0_30  0 PWL (0n 0.0v 9.495n 0.0v 9.505n 0.0v 19.495n 0.0v 19.505n 1.8v 29.495n 1.8v 29.505n 1.8v 39.495n 1.8v 39.505n 1.8v 49.495n 1.8v 49.505n 1.8v 59.495n 1.8v 59.505n 1.8v 69.495n 1.8v 69.505n 1.8v 79.495n 1.8v 79.505n 1.8v 89.495n 1.8v 89.505n 1.8v 99.495n 1.8v 99.505n 1.8v 109.495n 1.8v 109.505n 0.0v 119.495n 0.0v 119.505n 0.0v 129.495n 0.0v 129.505n 0.0v 139.495n 0.0v 139.505n 0.0v 149.495n 0.0v 149.505n 0.0v 159.495n 0.0v 159.505n 0.0v 169.495n 0.0v 169.505n 0.0v 179.495n 0.0v 179.505n 0.0v 189.495n 0.0v 189.505n 0.0v 199.495n 0.0v 199.505n 1.8v 209.495n 1.8v 209.505n 1.8v 219.495n 1.8v 219.505n 1.8v 229.495n 1.8v 229.505n 1.8v 239.495n 1.8v 239.505n 0.0v 249.495n 0.0v 249.505n 0.0v 259.495n 0.0v 259.505n 0.0v 269.495n 0.0v 269.505n 1.8v 279.495n 1.8v 279.505n 1.8v 289.495n 1.8v 289.505n 1.8v 299.495n 1.8v 299.505n 1.8v 309.495n 1.8v 309.505n 1.8v 319.495n 1.8v 319.505n 0.0v 329.495n 0.0v 329.505n 0.0v 339.495n 0.0v 339.505n 0.0v 349.495n 0.0v 349.505n 0.0v 359.495n 0.0v 359.505n 0.0v 369.495n 0.0v 369.505n 0.0v 379.495n 0.0v 379.505n 0.0v 389.495n 0.0v 389.505n 1.8v 399.495n 1.8v 399.505n 1.8v 409.495n 1.8v 409.505n 1.8v 419.495n 1.8v 419.505n 1.8v 429.495n 1.8v 429.505n 1.8v 439.495n 1.8v 439.505n 1.8v 449.495n 1.8v 449.505n 1.8v 459.495n 1.8v 459.505n 1.8v 469.495n 1.8v 469.505n 1.8v 479.495n 1.8v 479.505n 1.8v 489.495n 1.8v 489.505n 1.8v 499.495n 1.8v 499.505n 1.8v 509.495n 1.8v 509.505n 0.0v 519.495n 0.0v 519.505n 0.0v 529.495n 0.0v 529.505n 1.8v 539.495n 1.8v 539.505n 1.8v 549.495n 1.8v 549.505n 1.8v 559.495n 1.8v 559.505n 1.8v 569.495n 1.8v 569.505n 1.8v 579.495n 1.8v 579.505n 1.8v 589.495n 1.8v 589.505n 1.8v 599.495n 1.8v 599.505n 1.8v 609.495n 1.8v 609.505n 1.8v 619.495n 1.8v 619.505n 0.0v 629.495n 0.0v 629.505n 0.0v 639.495n 0.0v 639.505n 0.0v 649.495n 0.0v 649.505n 0.0v 659.495n 0.0v 659.505n 0.0v 669.495n 0.0v 669.505n 1.8v 679.495n 1.8v 679.505n 1.8v 689.495n 1.8v 689.505n 1.8v 699.495n 1.8v 699.505n 1.8v 709.495n 1.8v 709.505n 1.8v 719.495n 1.8v 719.505n 1.8v 729.495n 1.8v 729.505n 1.8v 739.495n 1.8v 739.505n 0.0v 749.495n 0.0v 749.505n 1.8v 759.495n 1.8v 759.505n 0.0v 769.495n 0.0v 769.505n 0.0v 779.495n 0.0v 779.505n 0.0v 789.495n 0.0v 789.505n 0.0v 799.495n 0.0v 799.505n 0.0v 809.495n 0.0v 809.505n 0.0v 819.495n 0.0v 819.505n 0.0v 829.495n 0.0v 829.505n 0.0v 839.495n 0.0v 839.505n 0.0v 849.495n 0.0v 849.505n 0.0v 859.495n 0.0v 859.505n 1.8v 869.495n 1.8v 869.505n 1.8v 879.495n 1.8v 879.505n 1.8v 889.495n 1.8v 889.505n 1.8v 899.495n 1.8v 899.505n 0.0v 909.495n 0.0v 909.505n 1.8v 919.495n 1.8v 919.505n 0.0v 929.495n 0.0v 929.505n 0.0v 939.495n 0.0v 939.505n 0.0v 949.495n 0.0v 949.505n 0.0v 959.495n 0.0v 959.505n 0.0v 969.495n 0.0v 969.505n 0.0v 979.495n 0.0v 979.505n 0.0v 989.495n 0.0v 989.505n 1.8v 999.495n 1.8v 999.505n 1.8v 1009.495n 1.8v 1009.505n 1.8v 1019.495n 1.8v 1019.505n 1.8v 1029.495n 1.8v 1029.505n 1.8v 1039.495n 1.8v 1039.505n 1.8v 1049.495n 1.8v 1049.505n 1.8v 1059.495n 1.8v 1059.505n 1.8v 1069.495n 1.8v 1069.505n 1.8v 1079.495n 1.8v 1079.505n 1.8v 1089.495n 1.8v 1089.505n 1.8v 1099.495n 1.8v 1099.505n 0.0v 1109.495n 0.0v 1109.505n 0.0v 1119.495n 0.0v 1119.505n 0.0v 1129.495n 0.0v 1129.505n 0.0v 1139.495n 0.0v 1139.505n 0.0v 1149.495n 0.0v 1149.505n 0.0v 1159.495n 0.0v 1159.505n 0.0v 1169.495n 0.0v 1169.505n 0.0v 1179.495n 0.0v 1179.505n 0.0v 1189.495n 0.0v 1189.505n 0.0v 1199.495n 0.0v 1199.505n 0.0v 1209.495n 0.0v 1209.505n 0.0v 1219.495n 0.0v 1219.505n 0.0v 1229.495n 0.0v 1229.505n 1.8v 1239.495n 1.8v 1239.505n 1.8v 1249.495n 1.8v 1249.505n 1.8v 1259.495n 1.8v 1259.505n 1.8v 1269.495n 1.8v 1269.505n 1.8v 1279.495n 1.8v 1279.505n 1.8v 1289.495n 1.8v 1289.505n 1.8v 1299.495n 1.8v 1299.505n 1.8v 1309.495n 1.8v 1309.505n 1.8v 1319.495n 1.8v 1319.505n 1.8v 1329.495n 1.8v 1329.505n 1.8v 1339.495n 1.8v 1339.505n 1.8v 1349.495n 1.8v 1349.505n 0.0v 1359.495n 0.0v 1359.505n 0.0v 1369.495n 0.0v 1369.505n 0.0v 1379.495n 0.0v 1379.505n 0.0v 1389.495n 0.0v 1389.505n 1.8v 1399.495n 1.8v 1399.505n 1.8v 1409.495n 1.8v 1409.505n 0.0v 1419.495n 0.0v 1419.505n 0.0v 1429.495n 0.0v 1429.505n 0.0v 1439.495n 0.0v 1439.505n 0.0v 1449.495n 0.0v 1449.505n 0.0v 1459.495n 0.0v 1459.505n 0.0v 1469.495n 0.0v 1469.505n 0.0v 1479.495n 0.0v 1479.505n 0.0v 1489.495n 0.0v 1489.505n 0.0v 1499.495n 0.0v 1499.505n 0.0v 1509.495n 0.0v 1509.505n 1.8v 1519.495n 1.8v 1519.505n 1.8v 1529.495n 1.8v 1529.505n 1.8v 1539.495n 1.8v 1539.505n 1.8v 1549.495n 1.8v 1549.505n 0.0v 1559.495n 0.0v 1559.505n 0.0v 1569.495n 0.0v 1569.505n 1.8v 1579.495n 1.8v 1579.505n 1.8v 1589.495n 1.8v 1589.505n 1.8v 1599.495n 1.8v 1599.505n 1.8v 1609.495n 1.8v 1609.505n 0.0v 1619.495n 0.0v 1619.505n 0.0v 1629.495n 0.0v 1629.505n 0.0v 1639.495n 0.0v 1639.505n 0.0v 1649.495n 0.0v 1649.505n 0.0v 1659.495n 0.0v 1659.505n 1.8v 1669.495n 1.8v 1669.505n 1.8v 1679.495n 1.8v 1679.505n 1.8v 1689.495n 1.8v 1689.505n 1.8v 1699.495n 1.8v 1699.505n 1.8v 1709.495n 1.8v 1709.505n 0.0v 1719.495n 0.0v 1719.505n 0.0v 1729.495n 0.0v 1729.505n 0.0v 1739.495n 0.0v 1739.505n 0.0v 1749.495n 0.0v 1749.505n 0.0v 1759.495n 0.0v 1759.505n 0.0v 1769.495n 0.0v 1769.505n 0.0v 1779.495n 0.0v 1779.505n 0.0v 1789.495n 0.0v 1789.505n 0.0v 1799.495n 0.0v 1799.505n 1.8v 1809.495n 1.8v 1809.505n 1.8v 1819.495n 1.8v 1819.505n 1.8v 1829.495n 1.8v 1829.505n 1.8v 1839.495n 1.8v 1839.505n 0.0v 1849.495n 0.0v 1849.505n 1.8v 1859.495n 1.8v 1859.505n 1.8v 1869.495n 1.8v 1869.505n 1.8v 1879.495n 1.8v 1879.505n 1.8v 1889.495n 1.8v 1889.505n 1.8v 1899.495n 1.8v 1899.505n 1.8v 1909.495n 1.8v 1909.505n 1.8v 1919.495n 1.8v 1919.505n 1.8v 1929.495n 1.8v 1929.505n 1.8v 1939.495n 1.8v 1939.505n 0.0v 1949.495n 0.0v 1949.505n 0.0v 1959.495n 0.0v 1959.505n 0.0v 1969.495n 0.0v 1969.505n 0.0v 1979.495n 0.0v 1979.505n 0.0v 1989.495n 0.0v 1989.505n 0.0v 1999.495n 0.0v 1999.505n 0.0v 2009.495n 0.0v 2009.505n 0.0v 2019.495n 0.0v 2019.505n 0.0v 2029.495n 0.0v 2029.505n 0.0v 2039.495n 0.0v 2039.505n 1.8v 2049.495n 1.8v 2049.505n 1.8v )
* (time, data): [(0, 0), (10, 0), (20, 0), (30, 1), (40, 1), (50, 1), (60, 1), (70, 1), (80, 1), (90, 1), (100, 1), (110, 1), (120, 1), (130, 1), (140, 1), (150, 1), (160, 1), (170, 0), (180, 0), (190, 0), (200, 1), (210, 1), (220, 1), (230, 1), (240, 0), (250, 0), (260, 0), (270, 1), (280, 0), (290, 0), (300, 0), (310, 0), (320, 1), (330, 1), (340, 0), (350, 0), (360, 0), (370, 0), (380, 0), (390, 1), (400, 1), (410, 1), (420, 1), (430, 1), (440, 1), (450, 1), (460, 1), (470, 1), (480, 1), (490, 1), (500, 0), (510, 1), (520, 1), (530, 1), (540, 1), (550, 1), (560, 1), (570, 1), (580, 1), (590, 1), (600, 0), (610, 0), (620, 1), (630, 1), (640, 1), (650, 0), (660, 0), (670, 1), (680, 1), (690, 1), (700, 1), (710, 1), (720, 1), (730, 1), (740, 1), (750, 0), (760, 1), (770, 0), (780, 0), (790, 0), (800, 0), (810, 0), (820, 0), (830, 0), (840, 0), (850, 0), (860, 0), (870, 0), (880, 0), (890, 0), (900, 0), (910, 1), (920, 0), (930, 0), (940, 0), (950, 0), (960, 0), (970, 0), (980, 0), (990, 0), (1000, 0), (1010, 0), (1020, 0), (1030, 0), (1040, 0), (1050, 0), (1060, 0), (1070, 0), (1080, 0), (1090, 0), (1100, 0), (1110, 0), (1120, 0), (1130, 0), (1140, 0), (1150, 0), (1160, 0), (1170, 0), (1180, 0), (1190, 0), (1200, 0), (1210, 0), (1220, 0), (1230, 1), (1240, 1), (1250, 0), (1260, 1), (1270, 1), (1280, 1), (1290, 1), (1300, 1), (1310, 1), (1320, 1), (1330, 1), (1340, 0), (1350, 0), (1360, 0), (1370, 0), (1380, 0), (1390, 1), (1400, 1), (1410, 0), (1420, 1), (1430, 1), (1440, 1), (1450, 1), (1460, 1), (1470, 1), (1480, 0), (1490, 0), (1500, 0), (1510, 1), (1520, 1), (1530, 0), (1540, 0), (1550, 0), (1560, 0), (1570, 0), (1580, 1), (1590, 0), (1600, 0), (1610, 1), (1620, 1), (1630, 1), (1640, 1), (1650, 1), (1660, 0), (1670, 0), (1680, 1), (1690, 0), (1700, 0), (1710, 0), (1720, 0), (1730, 0), (1740, 0), (1750, 0), (1760, 0), (1770, 0), (1780, 1), (1790, 1), (1800, 0), (1810, 0), (1820, 0), (1830, 0), (1840, 0), (1850, 0), (1860, 0), (1870, 0), (1880, 0), (1890, 0), (1900, 0), (1910, 0), (1920, 0), (1930, 0), (1940, 0), (1950, 0), (1960, 0), (1970, 1), (1980, 1), (1990, 1), (2000, 1), (2010, 1), (2020, 1), (2030, 1), (2040, 1), (2050, 1)]
Vdin0_31  din0_31  0 PWL (0n 0.0v 9.495n 0.0v 9.505n 0.0v 19.495n 0.0v 19.505n 0.0v 29.495n 0.0v 29.505n 1.8v 39.495n 1.8v 39.505n 1.8v 49.495n 1.8v 49.505n 1.8v 59.495n 1.8v 59.505n 1.8v 69.495n 1.8v 69.505n 1.8v 79.495n 1.8v 79.505n 1.8v 89.495n 1.8v 89.505n 1.8v 99.495n 1.8v 99.505n 1.8v 109.495n 1.8v 109.505n 1.8v 119.495n 1.8v 119.505n 1.8v 129.495n 1.8v 129.505n 1.8v 139.495n 1.8v 139.505n 1.8v 149.495n 1.8v 149.505n 1.8v 159.495n 1.8v 159.505n 1.8v 169.495n 1.8v 169.505n 0.0v 179.495n 0.0v 179.505n 0.0v 189.495n 0.0v 189.505n 0.0v 199.495n 0.0v 199.505n 1.8v 209.495n 1.8v 209.505n 1.8v 219.495n 1.8v 219.505n 1.8v 229.495n 1.8v 229.505n 1.8v 239.495n 1.8v 239.505n 0.0v 249.495n 0.0v 249.505n 0.0v 259.495n 0.0v 259.505n 0.0v 269.495n 0.0v 269.505n 1.8v 279.495n 1.8v 279.505n 0.0v 289.495n 0.0v 289.505n 0.0v 299.495n 0.0v 299.505n 0.0v 309.495n 0.0v 309.505n 0.0v 319.495n 0.0v 319.505n 1.8v 329.495n 1.8v 329.505n 1.8v 339.495n 1.8v 339.505n 0.0v 349.495n 0.0v 349.505n 0.0v 359.495n 0.0v 359.505n 0.0v 369.495n 0.0v 369.505n 0.0v 379.495n 0.0v 379.505n 0.0v 389.495n 0.0v 389.505n 1.8v 399.495n 1.8v 399.505n 1.8v 409.495n 1.8v 409.505n 1.8v 419.495n 1.8v 419.505n 1.8v 429.495n 1.8v 429.505n 1.8v 439.495n 1.8v 439.505n 1.8v 449.495n 1.8v 449.505n 1.8v 459.495n 1.8v 459.505n 1.8v 469.495n 1.8v 469.505n 1.8v 479.495n 1.8v 479.505n 1.8v 489.495n 1.8v 489.505n 1.8v 499.495n 1.8v 499.505n 0.0v 509.495n 0.0v 509.505n 1.8v 519.495n 1.8v 519.505n 1.8v 529.495n 1.8v 529.505n 1.8v 539.495n 1.8v 539.505n 1.8v 549.495n 1.8v 549.505n 1.8v 559.495n 1.8v 559.505n 1.8v 569.495n 1.8v 569.505n 1.8v 579.495n 1.8v 579.505n 1.8v 589.495n 1.8v 589.505n 1.8v 599.495n 1.8v 599.505n 0.0v 609.495n 0.0v 609.505n 0.0v 619.495n 0.0v 619.505n 1.8v 629.495n 1.8v 629.505n 1.8v 639.495n 1.8v 639.505n 1.8v 649.495n 1.8v 649.505n 0.0v 659.495n 0.0v 659.505n 0.0v 669.495n 0.0v 669.505n 1.8v 679.495n 1.8v 679.505n 1.8v 689.495n 1.8v 689.505n 1.8v 699.495n 1.8v 699.505n 1.8v 709.495n 1.8v 709.505n 1.8v 719.495n 1.8v 719.505n 1.8v 729.495n 1.8v 729.505n 1.8v 739.495n 1.8v 739.505n 1.8v 749.495n 1.8v 749.505n 0.0v 759.495n 0.0v 759.505n 1.8v 769.495n 1.8v 769.505n 0.0v 779.495n 0.0v 779.505n 0.0v 789.495n 0.0v 789.505n 0.0v 799.495n 0.0v 799.505n 0.0v 809.495n 0.0v 809.505n 0.0v 819.495n 0.0v 819.505n 0.0v 829.495n 0.0v 829.505n 0.0v 839.495n 0.0v 839.505n 0.0v 849.495n 0.0v 849.505n 0.0v 859.495n 0.0v 859.505n 0.0v 869.495n 0.0v 869.505n 0.0v 879.495n 0.0v 879.505n 0.0v 889.495n 0.0v 889.505n 0.0v 899.495n 0.0v 899.505n 0.0v 909.495n 0.0v 909.505n 1.8v 919.495n 1.8v 919.505n 0.0v 929.495n 0.0v 929.505n 0.0v 939.495n 0.0v 939.505n 0.0v 949.495n 0.0v 949.505n 0.0v 959.495n 0.0v 959.505n 0.0v 969.495n 0.0v 969.505n 0.0v 979.495n 0.0v 979.505n 0.0v 989.495n 0.0v 989.505n 0.0v 999.495n 0.0v 999.505n 0.0v 1009.495n 0.0v 1009.505n 0.0v 1019.495n 0.0v 1019.505n 0.0v 1029.495n 0.0v 1029.505n 0.0v 1039.495n 0.0v 1039.505n 0.0v 1049.495n 0.0v 1049.505n 0.0v 1059.495n 0.0v 1059.505n 0.0v 1069.495n 0.0v 1069.505n 0.0v 1079.495n 0.0v 1079.505n 0.0v 1089.495n 0.0v 1089.505n 0.0v 1099.495n 0.0v 1099.505n 0.0v 1109.495n 0.0v 1109.505n 0.0v 1119.495n 0.0v 1119.505n 0.0v 1129.495n 0.0v 1129.505n 0.0v 1139.495n 0.0v 1139.505n 0.0v 1149.495n 0.0v 1149.505n 0.0v 1159.495n 0.0v 1159.505n 0.0v 1169.495n 0.0v 1169.505n 0.0v 1179.495n 0.0v 1179.505n 0.0v 1189.495n 0.0v 1189.505n 0.0v 1199.495n 0.0v 1199.505n 0.0v 1209.495n 0.0v 1209.505n 0.0v 1219.495n 0.0v 1219.505n 0.0v 1229.495n 0.0v 1229.505n 1.8v 1239.495n 1.8v 1239.505n 1.8v 1249.495n 1.8v 1249.505n 0.0v 1259.495n 0.0v 1259.505n 1.8v 1269.495n 1.8v 1269.505n 1.8v 1279.495n 1.8v 1279.505n 1.8v 1289.495n 1.8v 1289.505n 1.8v 1299.495n 1.8v 1299.505n 1.8v 1309.495n 1.8v 1309.505n 1.8v 1319.495n 1.8v 1319.505n 1.8v 1329.495n 1.8v 1329.505n 1.8v 1339.495n 1.8v 1339.505n 0.0v 1349.495n 0.0v 1349.505n 0.0v 1359.495n 0.0v 1359.505n 0.0v 1369.495n 0.0v 1369.505n 0.0v 1379.495n 0.0v 1379.505n 0.0v 1389.495n 0.0v 1389.505n 1.8v 1399.495n 1.8v 1399.505n 1.8v 1409.495n 1.8v 1409.505n 0.0v 1419.495n 0.0v 1419.505n 1.8v 1429.495n 1.8v 1429.505n 1.8v 1439.495n 1.8v 1439.505n 1.8v 1449.495n 1.8v 1449.505n 1.8v 1459.495n 1.8v 1459.505n 1.8v 1469.495n 1.8v 1469.505n 1.8v 1479.495n 1.8v 1479.505n 0.0v 1489.495n 0.0v 1489.505n 0.0v 1499.495n 0.0v 1499.505n 0.0v 1509.495n 0.0v 1509.505n 1.8v 1519.495n 1.8v 1519.505n 1.8v 1529.495n 1.8v 1529.505n 0.0v 1539.495n 0.0v 1539.505n 0.0v 1549.495n 0.0v 1549.505n 0.0v 1559.495n 0.0v 1559.505n 0.0v 1569.495n 0.0v 1569.505n 0.0v 1579.495n 0.0v 1579.505n 1.8v 1589.495n 1.8v 1589.505n 0.0v 1599.495n 0.0v 1599.505n 0.0v 1609.495n 0.0v 1609.505n 1.8v 1619.495n 1.8v 1619.505n 1.8v 1629.495n 1.8v 1629.505n 1.8v 1639.495n 1.8v 1639.505n 1.8v 1649.495n 1.8v 1649.505n 1.8v 1659.495n 1.8v 1659.505n 0.0v 1669.495n 0.0v 1669.505n 0.0v 1679.495n 0.0v 1679.505n 1.8v 1689.495n 1.8v 1689.505n 0.0v 1699.495n 0.0v 1699.505n 0.0v 1709.495n 0.0v 1709.505n 0.0v 1719.495n 0.0v 1719.505n 0.0v 1729.495n 0.0v 1729.505n 0.0v 1739.495n 0.0v 1739.505n 0.0v 1749.495n 0.0v 1749.505n 0.0v 1759.495n 0.0v 1759.505n 0.0v 1769.495n 0.0v 1769.505n 0.0v 1779.495n 0.0v 1779.505n 1.8v 1789.495n 1.8v 1789.505n 1.8v 1799.495n 1.8v 1799.505n 0.0v 1809.495n 0.0v 1809.505n 0.0v 1819.495n 0.0v 1819.505n 0.0v 1829.495n 0.0v 1829.505n 0.0v 1839.495n 0.0v 1839.505n 0.0v 1849.495n 0.0v 1849.505n 0.0v 1859.495n 0.0v 1859.505n 0.0v 1869.495n 0.0v 1869.505n 0.0v 1879.495n 0.0v 1879.505n 0.0v 1889.495n 0.0v 1889.505n 0.0v 1899.495n 0.0v 1899.505n 0.0v 1909.495n 0.0v 1909.505n 0.0v 1919.495n 0.0v 1919.505n 0.0v 1929.495n 0.0v 1929.505n 0.0v 1939.495n 0.0v 1939.505n 0.0v 1949.495n 0.0v 1949.505n 0.0v 1959.495n 0.0v 1959.505n 0.0v 1969.495n 0.0v 1969.505n 1.8v 1979.495n 1.8v 1979.505n 1.8v 1989.495n 1.8v 1989.505n 1.8v 1999.495n 1.8v 1999.505n 1.8v 2009.495n 1.8v 2009.505n 1.8v 2019.495n 1.8v 2019.505n 1.8v 2029.495n 1.8v 2029.505n 1.8v 2039.495n 1.8v 2039.505n 1.8v 2049.495n 1.8v 2049.505n 1.8v )
* (time, data): [(0, 0), (10, 0), (20, 1), (30, 1), (40, 0), (50, 0), (60, 1), (70, 1), (80, 1), (90, 0), (100, 1), (110, 1), (120, 1), (130, 1), (140, 1), (150, 0), (160, 1), (170, 1), (180, 0), (190, 0), (200, 1), (210, 1), (220, 1), (230, 1), (240, 1), (250, 1), (260, 1), (270, 0), (280, 1), (290, 0), (300, 1), (310, 0), (320, 1), (330, 0), (340, 1), (350, 0), (360, 1), (370, 1), (380, 1), (390, 1), (400, 1), (410, 0), (420, 0), (430, 1), (440, 1), (450, 0), (460, 0), (470, 1), (480, 0), (490, 0), (500, 1), (510, 1), (520, 1), (530, 0), (540, 1), (550, 0), (560, 1), (570, 0), (580, 1), (590, 0), (600, 1), (610, 1), (620, 1), (630, 0), (640, 0), (650, 0), (660, 0), (670, 0), (680, 0), (690, 0), (700, 1), (710, 0), (720, 1), (730, 1), (740, 0), (750, 1), (760, 1), (770, 1), (780, 0), (790, 1), (800, 1), (810, 1), (820, 1), (830, 1), (840, 1), (850, 0), (860, 0), (870, 0), (880, 0), (890, 0), (900, 1), (910, 0), (920, 1), (930, 1), (940, 0), (950, 0), (960, 1), (970, 1), (980, 1), (990, 0), (1000, 0), (1010, 1), (1020, 1), (1030, 0), (1040, 1), (1050, 0), (1060, 0), (1070, 0), (1080, 1), (1090, 0), (1100, 0), (1110, 1), (1120, 0), (1130, 0), (1140, 1), (1150, 1), (1160, 0), (1170, 0), (1180, 0), (1190, 1), (1200, 0), (1210, 0), (1220, 0), (1230, 0), (1240, 0), (1250, 0), (1260, 1), (1270, 1), (1280, 1), (1290, 1), (1300, 1), (1310, 1), (1320, 0), (1330, 1), (1340, 1), (1350, 1), (1360, 0), (1370, 1), (1380, 1), (1390, 1), (1400, 1), (1410, 0), (1420, 0), (1430, 0), (1440, 0), (1450, 1), (1460, 1), (1470, 0), (1480, 0), (1490, 0), (1500, 0), (1510, 1), (1520, 1), (1530, 1), (1540, 1), (1550, 1), (1560, 1), (1570, 0), (1580, 1), (1590, 1), (1600, 1), (1610, 1), (1620, 1), (1630, 1), (1640, 1), (1650, 1), (1660, 0), (1670, 1), (1680, 0), (1690, 1), (1700, 0), (1710, 0), (1720, 0), (1730, 0), (1740, 1), (1750, 0), (1760, 1), (1770, 1), (1780, 1), (1790, 0), (1800, 1), (1810, 0), (1820, 1), (1830, 1), (1840, 1), (1850, 1), (1860, 0), (1870, 0), (1880, 1), (1890, 1), (1900, 0), (1910, 1), (1920, 0), (1930, 1), (1940, 1), (1950, 1), (1960, 1), (1970, 1), (1980, 1), (1990, 1), (2000, 1), (2010, 0), (2020, 0), (2030, 0), (2040, 0), (2050, 0)]
Va0_0  a0_0  0 PWL (0n 0.0v 9.495n 0.0v 9.505n 0.0v 19.495n 0.0v 19.505n 1.8v 29.495n 1.8v 29.505n 1.8v 39.495n 1.8v 39.505n 0.0v 49.495n 0.0v 49.505n 0.0v 59.495n 0.0v 59.505n 1.8v 69.495n 1.8v 69.505n 1.8v 79.495n 1.8v 79.505n 1.8v 89.495n 1.8v 89.505n 0.0v 99.495n 0.0v 99.505n 1.8v 109.495n 1.8v 109.505n 1.8v 119.495n 1.8v 119.505n 1.8v 129.495n 1.8v 129.505n 1.8v 139.495n 1.8v 139.505n 1.8v 149.495n 1.8v 149.505n 0.0v 159.495n 0.0v 159.505n 1.8v 169.495n 1.8v 169.505n 1.8v 179.495n 1.8v 179.505n 0.0v 189.495n 0.0v 189.505n 0.0v 199.495n 0.0v 199.505n 1.8v 209.495n 1.8v 209.505n 1.8v 219.495n 1.8v 219.505n 1.8v 229.495n 1.8v 229.505n 1.8v 239.495n 1.8v 239.505n 1.8v 249.495n 1.8v 249.505n 1.8v 259.495n 1.8v 259.505n 1.8v 269.495n 1.8v 269.505n 0.0v 279.495n 0.0v 279.505n 1.8v 289.495n 1.8v 289.505n 0.0v 299.495n 0.0v 299.505n 1.8v 309.495n 1.8v 309.505n 0.0v 319.495n 0.0v 319.505n 1.8v 329.495n 1.8v 329.505n 0.0v 339.495n 0.0v 339.505n 1.8v 349.495n 1.8v 349.505n 0.0v 359.495n 0.0v 359.505n 1.8v 369.495n 1.8v 369.505n 1.8v 379.495n 1.8v 379.505n 1.8v 389.495n 1.8v 389.505n 1.8v 399.495n 1.8v 399.505n 1.8v 409.495n 1.8v 409.505n 0.0v 419.495n 0.0v 419.505n 0.0v 429.495n 0.0v 429.505n 1.8v 439.495n 1.8v 439.505n 1.8v 449.495n 1.8v 449.505n 0.0v 459.495n 0.0v 459.505n 0.0v 469.495n 0.0v 469.505n 1.8v 479.495n 1.8v 479.505n 0.0v 489.495n 0.0v 489.505n 0.0v 499.495n 0.0v 499.505n 1.8v 509.495n 1.8v 509.505n 1.8v 519.495n 1.8v 519.505n 1.8v 529.495n 1.8v 529.505n 0.0v 539.495n 0.0v 539.505n 1.8v 549.495n 1.8v 549.505n 0.0v 559.495n 0.0v 559.505n 1.8v 569.495n 1.8v 569.505n 0.0v 579.495n 0.0v 579.505n 1.8v 589.495n 1.8v 589.505n 0.0v 599.495n 0.0v 599.505n 1.8v 609.495n 1.8v 609.505n 1.8v 619.495n 1.8v 619.505n 1.8v 629.495n 1.8v 629.505n 0.0v 639.495n 0.0v 639.505n 0.0v 649.495n 0.0v 649.505n 0.0v 659.495n 0.0v 659.505n 0.0v 669.495n 0.0v 669.505n 0.0v 679.495n 0.0v 679.505n 0.0v 689.495n 0.0v 689.505n 0.0v 699.495n 0.0v 699.505n 1.8v 709.495n 1.8v 709.505n 0.0v 719.495n 0.0v 719.505n 1.8v 729.495n 1.8v 729.505n 1.8v 739.495n 1.8v 739.505n 0.0v 749.495n 0.0v 749.505n 1.8v 759.495n 1.8v 759.505n 1.8v 769.495n 1.8v 769.505n 1.8v 779.495n 1.8v 779.505n 0.0v 789.495n 0.0v 789.505n 1.8v 799.495n 1.8v 799.505n 1.8v 809.495n 1.8v 809.505n 1.8v 819.495n 1.8v 819.505n 1.8v 829.495n 1.8v 829.505n 1.8v 839.495n 1.8v 839.505n 1.8v 849.495n 1.8v 849.505n 0.0v 859.495n 0.0v 859.505n 0.0v 869.495n 0.0v 869.505n 0.0v 879.495n 0.0v 879.505n 0.0v 889.495n 0.0v 889.505n 0.0v 899.495n 0.0v 899.505n 1.8v 909.495n 1.8v 909.505n 0.0v 919.495n 0.0v 919.505n 1.8v 929.495n 1.8v 929.505n 1.8v 939.495n 1.8v 939.505n 0.0v 949.495n 0.0v 949.505n 0.0v 959.495n 0.0v 959.505n 1.8v 969.495n 1.8v 969.505n 1.8v 979.495n 1.8v 979.505n 1.8v 989.495n 1.8v 989.505n 0.0v 999.495n 0.0v 999.505n 0.0v 1009.495n 0.0v 1009.505n 1.8v 1019.495n 1.8v 1019.505n 1.8v 1029.495n 1.8v 1029.505n 0.0v 1039.495n 0.0v 1039.505n 1.8v 1049.495n 1.8v 1049.505n 0.0v 1059.495n 0.0v 1059.505n 0.0v 1069.495n 0.0v 1069.505n 0.0v 1079.495n 0.0v 1079.505n 1.8v 1089.495n 1.8v 1089.505n 0.0v 1099.495n 0.0v 1099.505n 0.0v 1109.495n 0.0v 1109.505n 1.8v 1119.495n 1.8v 1119.505n 0.0v 1129.495n 0.0v 1129.505n 0.0v 1139.495n 0.0v 1139.505n 1.8v 1149.495n 1.8v 1149.505n 1.8v 1159.495n 1.8v 1159.505n 0.0v 1169.495n 0.0v 1169.505n 0.0v 1179.495n 0.0v 1179.505n 0.0v 1189.495n 0.0v 1189.505n 1.8v 1199.495n 1.8v 1199.505n 0.0v 1209.495n 0.0v 1209.505n 0.0v 1219.495n 0.0v 1219.505n 0.0v 1229.495n 0.0v 1229.505n 0.0v 1239.495n 0.0v 1239.505n 0.0v 1249.495n 0.0v 1249.505n 0.0v 1259.495n 0.0v 1259.505n 1.8v 1269.495n 1.8v 1269.505n 1.8v 1279.495n 1.8v 1279.505n 1.8v 1289.495n 1.8v 1289.505n 1.8v 1299.495n 1.8v 1299.505n 1.8v 1309.495n 1.8v 1309.505n 1.8v 1319.495n 1.8v 1319.505n 0.0v 1329.495n 0.0v 1329.505n 1.8v 1339.495n 1.8v 1339.505n 1.8v 1349.495n 1.8v 1349.505n 1.8v 1359.495n 1.8v 1359.505n 0.0v 1369.495n 0.0v 1369.505n 1.8v 1379.495n 1.8v 1379.505n 1.8v 1389.495n 1.8v 1389.505n 1.8v 1399.495n 1.8v 1399.505n 1.8v 1409.495n 1.8v 1409.505n 0.0v 1419.495n 0.0v 1419.505n 0.0v 1429.495n 0.0v 1429.505n 0.0v 1439.495n 0.0v 1439.505n 0.0v 1449.495n 0.0v 1449.505n 1.8v 1459.495n 1.8v 1459.505n 1.8v 1469.495n 1.8v 1469.505n 0.0v 1479.495n 0.0v 1479.505n 0.0v 1489.495n 0.0v 1489.505n 0.0v 1499.495n 0.0v 1499.505n 0.0v 1509.495n 0.0v 1509.505n 1.8v 1519.495n 1.8v 1519.505n 1.8v 1529.495n 1.8v 1529.505n 1.8v 1539.495n 1.8v 1539.505n 1.8v 1549.495n 1.8v 1549.505n 1.8v 1559.495n 1.8v 1559.505n 1.8v 1569.495n 1.8v 1569.505n 0.0v 1579.495n 0.0v 1579.505n 1.8v 1589.495n 1.8v 1589.505n 1.8v 1599.495n 1.8v 1599.505n 1.8v 1609.495n 1.8v 1609.505n 1.8v 1619.495n 1.8v 1619.505n 1.8v 1629.495n 1.8v 1629.505n 1.8v 1639.495n 1.8v 1639.505n 1.8v 1649.495n 1.8v 1649.505n 1.8v 1659.495n 1.8v 1659.505n 0.0v 1669.495n 0.0v 1669.505n 1.8v 1679.495n 1.8v 1679.505n 0.0v 1689.495n 0.0v 1689.505n 1.8v 1699.495n 1.8v 1699.505n 0.0v 1709.495n 0.0v 1709.505n 0.0v 1719.495n 0.0v 1719.505n 0.0v 1729.495n 0.0v 1729.505n 0.0v 1739.495n 0.0v 1739.505n 1.8v 1749.495n 1.8v 1749.505n 0.0v 1759.495n 0.0v 1759.505n 1.8v 1769.495n 1.8v 1769.505n 1.8v 1779.495n 1.8v 1779.505n 1.8v 1789.495n 1.8v 1789.505n 0.0v 1799.495n 0.0v 1799.505n 1.8v 1809.495n 1.8v 1809.505n 0.0v 1819.495n 0.0v 1819.505n 1.8v 1829.495n 1.8v 1829.505n 1.8v 1839.495n 1.8v 1839.505n 1.8v 1849.495n 1.8v 1849.505n 1.8v 1859.495n 1.8v 1859.505n 0.0v 1869.495n 0.0v 1869.505n 0.0v 1879.495n 0.0v 1879.505n 1.8v 1889.495n 1.8v 1889.505n 1.8v 1899.495n 1.8v 1899.505n 0.0v 1909.495n 0.0v 1909.505n 1.8v 1919.495n 1.8v 1919.505n 0.0v 1929.495n 0.0v 1929.505n 1.8v 1939.495n 1.8v 1939.505n 1.8v 1949.495n 1.8v 1949.505n 1.8v 1959.495n 1.8v 1959.505n 1.8v 1969.495n 1.8v 1969.505n 1.8v 1979.495n 1.8v 1979.505n 1.8v 1989.495n 1.8v 1989.505n 1.8v 1999.495n 1.8v 1999.505n 1.8v 2009.495n 1.8v 2009.505n 0.0v 2019.495n 0.0v 2019.505n 0.0v 2029.495n 0.0v 2029.505n 0.0v 2039.495n 0.0v 2039.505n 0.0v 2049.495n 0.0v 2049.505n 0.0v )
* (time, data): [(0, 0), (10, 0), (20, 0), (30, 0), (40, 0), (50, 0), (60, 0), (70, 0), (80, 0), (90, 0), (100, 0), (110, 0), (120, 0), (130, 0), (140, 0), (150, 0), (160, 0), (170, 0), (180, 0), (190, 0), (200, 0), (210, 0), (220, 0), (230, 0), (240, 0), (250, 0), (260, 0), (270, 0), (280, 0), (290, 0), (300, 0), (310, 1), (320, 0), (330, 1), (340, 0), (350, 0), (360, 0), (370, 0), (380, 0), (390, 0), (400, 0), (410, 0), (420, 0), (430, 0), (440, 0), (450, 1), (460, 1), (470, 0), (480, 1), (490, 0), (500, 0), (510, 0), (520, 0), (530, 0), (540, 0), (550, 0), (560, 0), (570, 0), (580, 0), (590, 0), (600, 0), (610, 0), (620, 0), (630, 1), (640, 1), (650, 1), (660, 1), (670, 0), (680, 0), (690, 0), (700, 0), (710, 1), (720, 0), (730, 0), (740, 0), (750, 0), (760, 0), (770, 0), (780, 1), (790, 0), (800, 0), (810, 0), (820, 0), (830, 0), (840, 0), (850, 0), (860, 0), (870, 0), (880, 0), (890, 0), (900, 0), (910, 1), (920, 0), (930, 0), (940, 1), (950, 0), (960, 0), (970, 0), (980, 0), (990, 0), (1000, 1), (1010, 0), (1020, 0), (1030, 1), (1040, 0), (1050, 0), (1060, 1), (1070, 1), (1080, 0), (1090, 0), (1100, 1), (1110, 0), (1120, 0), (1130, 1), (1140, 0), (1150, 0), (1160, 1), (1170, 0), (1180, 1), (1190, 0), (1200, 1), (1210, 0), (1220, 1), (1230, 1), (1240, 1), (1250, 1), (1260, 0), (1270, 0), (1280, 0), (1290, 0), (1300, 0), (1310, 0), (1320, 1), (1330, 0), (1340, 0), (1350, 0), (1360, 1), (1370, 0), (1380, 0), (1390, 0), (1400, 0), (1410, 1), (1420, 1), (1430, 1), (1440, 0), (1450, 0), (1460, 0), (1470, 0), (1480, 1), (1490, 0), (1500, 1), (1510, 0), (1520, 0), (1530, 0), (1540, 0), (1550, 0), (1560, 0), (1570, 0), (1580, 0), (1590, 0), (1600, 0), (1610, 0), (1620, 0), (1630, 0), (1640, 0), (1650, 0), (1660, 1), (1670, 0), (1680, 1), (1690, 0), (1700, 0), (1710, 1), (1720, 0), (1730, 0), (1740, 0), (1750, 0), (1760, 0), (1770, 0), (1780, 0), (1790, 0), (1800, 0), (1810, 1), (1820, 0), (1830, 0), (1840, 0), (1850, 0), (1860, 1), (1870, 1), (1880, 0), (1890, 0), (1900, 0), (1910, 0), (1920, 1), (1930, 0), (1940, 0), (1950, 0), (1960, 0), (1970, 0), (1980, 0), (1990, 0), (2000, 0), (2010, 1), (2020, 0), (2030, 1), (2040, 0), (2050, 0)]
Va0_1  a0_1  0 PWL (0n 0.0v 9.495n 0.0v 9.505n 0.0v 19.495n 0.0v 19.505n 0.0v 29.495n 0.0v 29.505n 0.0v 39.495n 0.0v 39.505n 0.0v 49.495n 0.0v 49.505n 0.0v 59.495n 0.0v 59.505n 0.0v 69.495n 0.0v 69.505n 0.0v 79.495n 0.0v 79.505n 0.0v 89.495n 0.0v 89.505n 0.0v 99.495n 0.0v 99.505n 0.0v 109.495n 0.0v 109.505n 0.0v 119.495n 0.0v 119.505n 0.0v 129.495n 0.0v 129.505n 0.0v 139.495n 0.0v 139.505n 0.0v 149.495n 0.0v 149.505n 0.0v 159.495n 0.0v 159.505n 0.0v 169.495n 0.0v 169.505n 0.0v 179.495n 0.0v 179.505n 0.0v 189.495n 0.0v 189.505n 0.0v 199.495n 0.0v 199.505n 0.0v 209.495n 0.0v 209.505n 0.0v 219.495n 0.0v 219.505n 0.0v 229.495n 0.0v 229.505n 0.0v 239.495n 0.0v 239.505n 0.0v 249.495n 0.0v 249.505n 0.0v 259.495n 0.0v 259.505n 0.0v 269.495n 0.0v 269.505n 0.0v 279.495n 0.0v 279.505n 0.0v 289.495n 0.0v 289.505n 0.0v 299.495n 0.0v 299.505n 0.0v 309.495n 0.0v 309.505n 1.8v 319.495n 1.8v 319.505n 0.0v 329.495n 0.0v 329.505n 1.8v 339.495n 1.8v 339.505n 0.0v 349.495n 0.0v 349.505n 0.0v 359.495n 0.0v 359.505n 0.0v 369.495n 0.0v 369.505n 0.0v 379.495n 0.0v 379.505n 0.0v 389.495n 0.0v 389.505n 0.0v 399.495n 0.0v 399.505n 0.0v 409.495n 0.0v 409.505n 0.0v 419.495n 0.0v 419.505n 0.0v 429.495n 0.0v 429.505n 0.0v 439.495n 0.0v 439.505n 0.0v 449.495n 0.0v 449.505n 1.8v 459.495n 1.8v 459.505n 1.8v 469.495n 1.8v 469.505n 0.0v 479.495n 0.0v 479.505n 1.8v 489.495n 1.8v 489.505n 0.0v 499.495n 0.0v 499.505n 0.0v 509.495n 0.0v 509.505n 0.0v 519.495n 0.0v 519.505n 0.0v 529.495n 0.0v 529.505n 0.0v 539.495n 0.0v 539.505n 0.0v 549.495n 0.0v 549.505n 0.0v 559.495n 0.0v 559.505n 0.0v 569.495n 0.0v 569.505n 0.0v 579.495n 0.0v 579.505n 0.0v 589.495n 0.0v 589.505n 0.0v 599.495n 0.0v 599.505n 0.0v 609.495n 0.0v 609.505n 0.0v 619.495n 0.0v 619.505n 0.0v 629.495n 0.0v 629.505n 1.8v 639.495n 1.8v 639.505n 1.8v 649.495n 1.8v 649.505n 1.8v 659.495n 1.8v 659.505n 1.8v 669.495n 1.8v 669.505n 0.0v 679.495n 0.0v 679.505n 0.0v 689.495n 0.0v 689.505n 0.0v 699.495n 0.0v 699.505n 0.0v 709.495n 0.0v 709.505n 1.8v 719.495n 1.8v 719.505n 0.0v 729.495n 0.0v 729.505n 0.0v 739.495n 0.0v 739.505n 0.0v 749.495n 0.0v 749.505n 0.0v 759.495n 0.0v 759.505n 0.0v 769.495n 0.0v 769.505n 0.0v 779.495n 0.0v 779.505n 1.8v 789.495n 1.8v 789.505n 0.0v 799.495n 0.0v 799.505n 0.0v 809.495n 0.0v 809.505n 0.0v 819.495n 0.0v 819.505n 0.0v 829.495n 0.0v 829.505n 0.0v 839.495n 0.0v 839.505n 0.0v 849.495n 0.0v 849.505n 0.0v 859.495n 0.0v 859.505n 0.0v 869.495n 0.0v 869.505n 0.0v 879.495n 0.0v 879.505n 0.0v 889.495n 0.0v 889.505n 0.0v 899.495n 0.0v 899.505n 0.0v 909.495n 0.0v 909.505n 1.8v 919.495n 1.8v 919.505n 0.0v 929.495n 0.0v 929.505n 0.0v 939.495n 0.0v 939.505n 1.8v 949.495n 1.8v 949.505n 0.0v 959.495n 0.0v 959.505n 0.0v 969.495n 0.0v 969.505n 0.0v 979.495n 0.0v 979.505n 0.0v 989.495n 0.0v 989.505n 0.0v 999.495n 0.0v 999.505n 1.8v 1009.495n 1.8v 1009.505n 0.0v 1019.495n 0.0v 1019.505n 0.0v 1029.495n 0.0v 1029.505n 1.8v 1039.495n 1.8v 1039.505n 0.0v 1049.495n 0.0v 1049.505n 0.0v 1059.495n 0.0v 1059.505n 1.8v 1069.495n 1.8v 1069.505n 1.8v 1079.495n 1.8v 1079.505n 0.0v 1089.495n 0.0v 1089.505n 0.0v 1099.495n 0.0v 1099.505n 1.8v 1109.495n 1.8v 1109.505n 0.0v 1119.495n 0.0v 1119.505n 0.0v 1129.495n 0.0v 1129.505n 1.8v 1139.495n 1.8v 1139.505n 0.0v 1149.495n 0.0v 1149.505n 0.0v 1159.495n 0.0v 1159.505n 1.8v 1169.495n 1.8v 1169.505n 0.0v 1179.495n 0.0v 1179.505n 1.8v 1189.495n 1.8v 1189.505n 0.0v 1199.495n 0.0v 1199.505n 1.8v 1209.495n 1.8v 1209.505n 0.0v 1219.495n 0.0v 1219.505n 1.8v 1229.495n 1.8v 1229.505n 1.8v 1239.495n 1.8v 1239.505n 1.8v 1249.495n 1.8v 1249.505n 1.8v 1259.495n 1.8v 1259.505n 0.0v 1269.495n 0.0v 1269.505n 0.0v 1279.495n 0.0v 1279.505n 0.0v 1289.495n 0.0v 1289.505n 0.0v 1299.495n 0.0v 1299.505n 0.0v 1309.495n 0.0v 1309.505n 0.0v 1319.495n 0.0v 1319.505n 1.8v 1329.495n 1.8v 1329.505n 0.0v 1339.495n 0.0v 1339.505n 0.0v 1349.495n 0.0v 1349.505n 0.0v 1359.495n 0.0v 1359.505n 1.8v 1369.495n 1.8v 1369.505n 0.0v 1379.495n 0.0v 1379.505n 0.0v 1389.495n 0.0v 1389.505n 0.0v 1399.495n 0.0v 1399.505n 0.0v 1409.495n 0.0v 1409.505n 1.8v 1419.495n 1.8v 1419.505n 1.8v 1429.495n 1.8v 1429.505n 1.8v 1439.495n 1.8v 1439.505n 0.0v 1449.495n 0.0v 1449.505n 0.0v 1459.495n 0.0v 1459.505n 0.0v 1469.495n 0.0v 1469.505n 0.0v 1479.495n 0.0v 1479.505n 1.8v 1489.495n 1.8v 1489.505n 0.0v 1499.495n 0.0v 1499.505n 1.8v 1509.495n 1.8v 1509.505n 0.0v 1519.495n 0.0v 1519.505n 0.0v 1529.495n 0.0v 1529.505n 0.0v 1539.495n 0.0v 1539.505n 0.0v 1549.495n 0.0v 1549.505n 0.0v 1559.495n 0.0v 1559.505n 0.0v 1569.495n 0.0v 1569.505n 0.0v 1579.495n 0.0v 1579.505n 0.0v 1589.495n 0.0v 1589.505n 0.0v 1599.495n 0.0v 1599.505n 0.0v 1609.495n 0.0v 1609.505n 0.0v 1619.495n 0.0v 1619.505n 0.0v 1629.495n 0.0v 1629.505n 0.0v 1639.495n 0.0v 1639.505n 0.0v 1649.495n 0.0v 1649.505n 0.0v 1659.495n 0.0v 1659.505n 1.8v 1669.495n 1.8v 1669.505n 0.0v 1679.495n 0.0v 1679.505n 1.8v 1689.495n 1.8v 1689.505n 0.0v 1699.495n 0.0v 1699.505n 0.0v 1709.495n 0.0v 1709.505n 1.8v 1719.495n 1.8v 1719.505n 0.0v 1729.495n 0.0v 1729.505n 0.0v 1739.495n 0.0v 1739.505n 0.0v 1749.495n 0.0v 1749.505n 0.0v 1759.495n 0.0v 1759.505n 0.0v 1769.495n 0.0v 1769.505n 0.0v 1779.495n 0.0v 1779.505n 0.0v 1789.495n 0.0v 1789.505n 0.0v 1799.495n 0.0v 1799.505n 0.0v 1809.495n 0.0v 1809.505n 1.8v 1819.495n 1.8v 1819.505n 0.0v 1829.495n 0.0v 1829.505n 0.0v 1839.495n 0.0v 1839.505n 0.0v 1849.495n 0.0v 1849.505n 0.0v 1859.495n 0.0v 1859.505n 1.8v 1869.495n 1.8v 1869.505n 1.8v 1879.495n 1.8v 1879.505n 0.0v 1889.495n 0.0v 1889.505n 0.0v 1899.495n 0.0v 1899.505n 0.0v 1909.495n 0.0v 1909.505n 0.0v 1919.495n 0.0v 1919.505n 1.8v 1929.495n 1.8v 1929.505n 0.0v 1939.495n 0.0v 1939.505n 0.0v 1949.495n 0.0v 1949.505n 0.0v 1959.495n 0.0v 1959.505n 0.0v 1969.495n 0.0v 1969.505n 0.0v 1979.495n 0.0v 1979.505n 0.0v 1989.495n 0.0v 1989.505n 0.0v 1999.495n 0.0v 1999.505n 0.0v 2009.495n 0.0v 2009.505n 1.8v 2019.495n 1.8v 2019.505n 0.0v 2029.495n 0.0v 2029.505n 1.8v 2039.495n 1.8v 2039.505n 0.0v 2049.495n 0.0v 2049.505n 0.0v )
* (time, data): [(0, 0), (10, 0), (20, 0), (30, 1), (40, 0), (50, 0), (60, 1), (70, 1), (80, 1), (90, 0), (100, 1), (110, 0), (120, 0), (130, 0), (140, 1), (150, 0), (160, 1), (170, 1), (180, 0), (190, 0), (200, 0), (210, 0), (220, 1), (230, 1), (240, 0), (250, 0), (260, 0), (270, 0), (280, 1), (290, 0), (300, 0), (310, 1), (320, 0), (330, 1), (340, 0), (350, 0), (360, 0), (370, 1), (380, 1), (390, 1), (400, 0), (410, 0), (420, 0), (430, 0), (440, 0), (450, 1), (460, 1), (470, 1), (480, 1), (490, 0), (500, 1), (510, 0), (520, 0), (530, 0), (540, 1), (550, 0), (560, 0), (570, 0), (580, 0), (590, 0), (600, 0), (610, 1), (620, 0), (630, 1), (640, 1), (650, 1), (660, 1), (670, 0), (680, 0), (690, 0), (700, 0), (710, 1), (720, 1), (730, 1), (740, 0), (750, 1), (760, 0), (770, 0), (780, 1), (790, 1), (800, 1), (810, 1), (820, 0), (830, 0), (840, 0), (850, 0), (860, 0), (870, 0), (880, 0), (890, 0), (900, 0), (910, 1), (920, 1), (930, 0), (940, 1), (950, 0), (960, 1), (970, 1), (980, 1), (990, 0), (1000, 1), (1010, 0), (1020, 0), (1030, 1), (1040, 1), (1050, 0), (1060, 1), (1070, 1), (1080, 0), (1090, 0), (1100, 1), (1110, 0), (1120, 0), (1130, 1), (1140, 1), (1150, 0), (1160, 1), (1170, 0), (1180, 1), (1190, 0), (1200, 1), (1210, 0), (1220, 1), (1230, 1), (1240, 1), (1250, 1), (1260, 1), (1270, 1), (1280, 1), (1290, 0), (1300, 0), (1310, 0), (1320, 1), (1330, 1), (1340, 1), (1350, 0), (1360, 1), (1370, 0), (1380, 0), (1390, 1), (1400, 1), (1410, 1), (1420, 1), (1430, 1), (1440, 0), (1450, 0), (1460, 0), (1470, 0), (1480, 1), (1490, 0), (1500, 1), (1510, 0), (1520, 0), (1530, 1), (1540, 1), (1550, 1), (1560, 0), (1570, 0), (1580, 1), (1590, 0), (1600, 0), (1610, 1), (1620, 1), (1630, 1), (1640, 0), (1650, 0), (1660, 1), (1670, 0), (1680, 1), (1690, 1), (1700, 0), (1710, 1), (1720, 0), (1730, 0), (1740, 1), (1750, 0), (1760, 1), (1770, 1), (1780, 0), (1790, 0), (1800, 1), (1810, 1), (1820, 0), (1830, 0), (1840, 1), (1850, 0), (1860, 1), (1870, 1), (1880, 0), (1890, 0), (1900, 0), (1910, 0), (1920, 1), (1930, 0), (1940, 1), (1950, 1), (1960, 1), (1970, 1), (1980, 1), (1990, 1), (2000, 1), (2010, 1), (2020, 0), (2030, 1), (2040, 0), (2050, 0)]
Va0_2  a0_2  0 PWL (0n 0.0v 9.495n 0.0v 9.505n 0.0v 19.495n 0.0v 19.505n 0.0v 29.495n 0.0v 29.505n 1.8v 39.495n 1.8v 39.505n 0.0v 49.495n 0.0v 49.505n 0.0v 59.495n 0.0v 59.505n 1.8v 69.495n 1.8v 69.505n 1.8v 79.495n 1.8v 79.505n 1.8v 89.495n 1.8v 89.505n 0.0v 99.495n 0.0v 99.505n 1.8v 109.495n 1.8v 109.505n 0.0v 119.495n 0.0v 119.505n 0.0v 129.495n 0.0v 129.505n 0.0v 139.495n 0.0v 139.505n 1.8v 149.495n 1.8v 149.505n 0.0v 159.495n 0.0v 159.505n 1.8v 169.495n 1.8v 169.505n 1.8v 179.495n 1.8v 179.505n 0.0v 189.495n 0.0v 189.505n 0.0v 199.495n 0.0v 199.505n 0.0v 209.495n 0.0v 209.505n 0.0v 219.495n 0.0v 219.505n 1.8v 229.495n 1.8v 229.505n 1.8v 239.495n 1.8v 239.505n 0.0v 249.495n 0.0v 249.505n 0.0v 259.495n 0.0v 259.505n 0.0v 269.495n 0.0v 269.505n 0.0v 279.495n 0.0v 279.505n 1.8v 289.495n 1.8v 289.505n 0.0v 299.495n 0.0v 299.505n 0.0v 309.495n 0.0v 309.505n 1.8v 319.495n 1.8v 319.505n 0.0v 329.495n 0.0v 329.505n 1.8v 339.495n 1.8v 339.505n 0.0v 349.495n 0.0v 349.505n 0.0v 359.495n 0.0v 359.505n 0.0v 369.495n 0.0v 369.505n 1.8v 379.495n 1.8v 379.505n 1.8v 389.495n 1.8v 389.505n 1.8v 399.495n 1.8v 399.505n 0.0v 409.495n 0.0v 409.505n 0.0v 419.495n 0.0v 419.505n 0.0v 429.495n 0.0v 429.505n 0.0v 439.495n 0.0v 439.505n 0.0v 449.495n 0.0v 449.505n 1.8v 459.495n 1.8v 459.505n 1.8v 469.495n 1.8v 469.505n 1.8v 479.495n 1.8v 479.505n 1.8v 489.495n 1.8v 489.505n 0.0v 499.495n 0.0v 499.505n 1.8v 509.495n 1.8v 509.505n 0.0v 519.495n 0.0v 519.505n 0.0v 529.495n 0.0v 529.505n 0.0v 539.495n 0.0v 539.505n 1.8v 549.495n 1.8v 549.505n 0.0v 559.495n 0.0v 559.505n 0.0v 569.495n 0.0v 569.505n 0.0v 579.495n 0.0v 579.505n 0.0v 589.495n 0.0v 589.505n 0.0v 599.495n 0.0v 599.505n 0.0v 609.495n 0.0v 609.505n 1.8v 619.495n 1.8v 619.505n 0.0v 629.495n 0.0v 629.505n 1.8v 639.495n 1.8v 639.505n 1.8v 649.495n 1.8v 649.505n 1.8v 659.495n 1.8v 659.505n 1.8v 669.495n 1.8v 669.505n 0.0v 679.495n 0.0v 679.505n 0.0v 689.495n 0.0v 689.505n 0.0v 699.495n 0.0v 699.505n 0.0v 709.495n 0.0v 709.505n 1.8v 719.495n 1.8v 719.505n 1.8v 729.495n 1.8v 729.505n 1.8v 739.495n 1.8v 739.505n 0.0v 749.495n 0.0v 749.505n 1.8v 759.495n 1.8v 759.505n 0.0v 769.495n 0.0v 769.505n 0.0v 779.495n 0.0v 779.505n 1.8v 789.495n 1.8v 789.505n 1.8v 799.495n 1.8v 799.505n 1.8v 809.495n 1.8v 809.505n 1.8v 819.495n 1.8v 819.505n 0.0v 829.495n 0.0v 829.505n 0.0v 839.495n 0.0v 839.505n 0.0v 849.495n 0.0v 849.505n 0.0v 859.495n 0.0v 859.505n 0.0v 869.495n 0.0v 869.505n 0.0v 879.495n 0.0v 879.505n 0.0v 889.495n 0.0v 889.505n 0.0v 899.495n 0.0v 899.505n 0.0v 909.495n 0.0v 909.505n 1.8v 919.495n 1.8v 919.505n 1.8v 929.495n 1.8v 929.505n 0.0v 939.495n 0.0v 939.505n 1.8v 949.495n 1.8v 949.505n 0.0v 959.495n 0.0v 959.505n 1.8v 969.495n 1.8v 969.505n 1.8v 979.495n 1.8v 979.505n 1.8v 989.495n 1.8v 989.505n 0.0v 999.495n 0.0v 999.505n 1.8v 1009.495n 1.8v 1009.505n 0.0v 1019.495n 0.0v 1019.505n 0.0v 1029.495n 0.0v 1029.505n 1.8v 1039.495n 1.8v 1039.505n 1.8v 1049.495n 1.8v 1049.505n 0.0v 1059.495n 0.0v 1059.505n 1.8v 1069.495n 1.8v 1069.505n 1.8v 1079.495n 1.8v 1079.505n 0.0v 1089.495n 0.0v 1089.505n 0.0v 1099.495n 0.0v 1099.505n 1.8v 1109.495n 1.8v 1109.505n 0.0v 1119.495n 0.0v 1119.505n 0.0v 1129.495n 0.0v 1129.505n 1.8v 1139.495n 1.8v 1139.505n 1.8v 1149.495n 1.8v 1149.505n 0.0v 1159.495n 0.0v 1159.505n 1.8v 1169.495n 1.8v 1169.505n 0.0v 1179.495n 0.0v 1179.505n 1.8v 1189.495n 1.8v 1189.505n 0.0v 1199.495n 0.0v 1199.505n 1.8v 1209.495n 1.8v 1209.505n 0.0v 1219.495n 0.0v 1219.505n 1.8v 1229.495n 1.8v 1229.505n 1.8v 1239.495n 1.8v 1239.505n 1.8v 1249.495n 1.8v 1249.505n 1.8v 1259.495n 1.8v 1259.505n 1.8v 1269.495n 1.8v 1269.505n 1.8v 1279.495n 1.8v 1279.505n 1.8v 1289.495n 1.8v 1289.505n 0.0v 1299.495n 0.0v 1299.505n 0.0v 1309.495n 0.0v 1309.505n 0.0v 1319.495n 0.0v 1319.505n 1.8v 1329.495n 1.8v 1329.505n 1.8v 1339.495n 1.8v 1339.505n 1.8v 1349.495n 1.8v 1349.505n 0.0v 1359.495n 0.0v 1359.505n 1.8v 1369.495n 1.8v 1369.505n 0.0v 1379.495n 0.0v 1379.505n 0.0v 1389.495n 0.0v 1389.505n 1.8v 1399.495n 1.8v 1399.505n 1.8v 1409.495n 1.8v 1409.505n 1.8v 1419.495n 1.8v 1419.505n 1.8v 1429.495n 1.8v 1429.505n 1.8v 1439.495n 1.8v 1439.505n 0.0v 1449.495n 0.0v 1449.505n 0.0v 1459.495n 0.0v 1459.505n 0.0v 1469.495n 0.0v 1469.505n 0.0v 1479.495n 0.0v 1479.505n 1.8v 1489.495n 1.8v 1489.505n 0.0v 1499.495n 0.0v 1499.505n 1.8v 1509.495n 1.8v 1509.505n 0.0v 1519.495n 0.0v 1519.505n 0.0v 1529.495n 0.0v 1529.505n 1.8v 1539.495n 1.8v 1539.505n 1.8v 1549.495n 1.8v 1549.505n 1.8v 1559.495n 1.8v 1559.505n 0.0v 1569.495n 0.0v 1569.505n 0.0v 1579.495n 0.0v 1579.505n 1.8v 1589.495n 1.8v 1589.505n 0.0v 1599.495n 0.0v 1599.505n 0.0v 1609.495n 0.0v 1609.505n 1.8v 1619.495n 1.8v 1619.505n 1.8v 1629.495n 1.8v 1629.505n 1.8v 1639.495n 1.8v 1639.505n 0.0v 1649.495n 0.0v 1649.505n 0.0v 1659.495n 0.0v 1659.505n 1.8v 1669.495n 1.8v 1669.505n 0.0v 1679.495n 0.0v 1679.505n 1.8v 1689.495n 1.8v 1689.505n 1.8v 1699.495n 1.8v 1699.505n 0.0v 1709.495n 0.0v 1709.505n 1.8v 1719.495n 1.8v 1719.505n 0.0v 1729.495n 0.0v 1729.505n 0.0v 1739.495n 0.0v 1739.505n 1.8v 1749.495n 1.8v 1749.505n 0.0v 1759.495n 0.0v 1759.505n 1.8v 1769.495n 1.8v 1769.505n 1.8v 1779.495n 1.8v 1779.505n 0.0v 1789.495n 0.0v 1789.505n 0.0v 1799.495n 0.0v 1799.505n 1.8v 1809.495n 1.8v 1809.505n 1.8v 1819.495n 1.8v 1819.505n 0.0v 1829.495n 0.0v 1829.505n 0.0v 1839.495n 0.0v 1839.505n 1.8v 1849.495n 1.8v 1849.505n 0.0v 1859.495n 0.0v 1859.505n 1.8v 1869.495n 1.8v 1869.505n 1.8v 1879.495n 1.8v 1879.505n 0.0v 1889.495n 0.0v 1889.505n 0.0v 1899.495n 0.0v 1899.505n 0.0v 1909.495n 0.0v 1909.505n 0.0v 1919.495n 0.0v 1919.505n 1.8v 1929.495n 1.8v 1929.505n 0.0v 1939.495n 0.0v 1939.505n 1.8v 1949.495n 1.8v 1949.505n 1.8v 1959.495n 1.8v 1959.505n 1.8v 1969.495n 1.8v 1969.505n 1.8v 1979.495n 1.8v 1979.505n 1.8v 1989.495n 1.8v 1989.505n 1.8v 1999.495n 1.8v 1999.505n 1.8v 2009.495n 1.8v 2009.505n 1.8v 2019.495n 1.8v 2019.505n 0.0v 2029.495n 0.0v 2029.505n 1.8v 2039.495n 1.8v 2039.505n 0.0v 2049.495n 0.0v 2049.505n 0.0v )
* (time, data): [(0, 0), (10, 0), (20, 0), (30, 1), (40, 0), (50, 0), (60, 1), (70, 1), (80, 1), (90, 0), (100, 1), (110, 0), (120, 0), (130, 0), (140, 1), (150, 0), (160, 1), (170, 1), (180, 0), (190, 0), (200, 0), (210, 0), (220, 1), (230, 1), (240, 0), (250, 0), (260, 0), (270, 0), (280, 1), (290, 0), (300, 0), (310, 1), (320, 0), (330, 1), (340, 0), (350, 0), (360, 0), (370, 1), (380, 1), (390, 1), (400, 0), (410, 0), (420, 0), (430, 0), (440, 0), (450, 1), (460, 1), (470, 1), (480, 1), (490, 0), (500, 1), (510, 0), (520, 0), (530, 0), (540, 1), (550, 0), (560, 0), (570, 0), (580, 0), (590, 0), (600, 0), (610, 1), (620, 0), (630, 1), (640, 1), (650, 1), (660, 1), (670, 0), (680, 0), (690, 0), (700, 0), (710, 1), (720, 1), (730, 1), (740, 0), (750, 1), (760, 0), (770, 0), (780, 1), (790, 1), (800, 1), (810, 1), (820, 0), (830, 0), (840, 0), (850, 0), (860, 0), (870, 0), (880, 0), (890, 0), (900, 0), (910, 1), (920, 1), (930, 0), (940, 1), (950, 0), (960, 1), (970, 1), (980, 1), (990, 0), (1000, 1), (1010, 0), (1020, 0), (1030, 1), (1040, 1), (1050, 0), (1060, 1), (1070, 1), (1080, 0), (1090, 0), (1100, 1), (1110, 0), (1120, 0), (1130, 1), (1140, 1), (1150, 0), (1160, 1), (1170, 0), (1180, 1), (1190, 0), (1200, 1), (1210, 0), (1220, 1), (1230, 1), (1240, 1), (1250, 1), (1260, 1), (1270, 1), (1280, 1), (1290, 0), (1300, 0), (1310, 0), (1320, 1), (1330, 1), (1340, 1), (1350, 0), (1360, 1), (1370, 0), (1380, 0), (1390, 1), (1400, 1), (1410, 1), (1420, 1), (1430, 1), (1440, 0), (1450, 0), (1460, 0), (1470, 0), (1480, 1), (1490, 0), (1500, 1), (1510, 0), (1520, 0), (1530, 1), (1540, 1), (1550, 1), (1560, 0), (1570, 0), (1580, 1), (1590, 0), (1600, 0), (1610, 1), (1620, 1), (1630, 1), (1640, 0), (1650, 0), (1660, 1), (1670, 0), (1680, 1), (1690, 1), (1700, 0), (1710, 1), (1720, 0), (1730, 0), (1740, 1), (1750, 0), (1760, 1), (1770, 1), (1780, 0), (1790, 0), (1800, 1), (1810, 1), (1820, 0), (1830, 0), (1840, 1), (1850, 0), (1860, 1), (1870, 1), (1880, 0), (1890, 0), (1900, 0), (1910, 0), (1920, 1), (1930, 0), (1940, 1), (1950, 1), (1960, 1), (1970, 1), (1980, 1), (1990, 1), (2000, 1), (2010, 1), (2020, 0), (2030, 1), (2040, 0), (2050, 0)]
Va0_3  a0_3  0 PWL (0n 0.0v 9.495n 0.0v 9.505n 0.0v 19.495n 0.0v 19.505n 0.0v 29.495n 0.0v 29.505n 1.8v 39.495n 1.8v 39.505n 0.0v 49.495n 0.0v 49.505n 0.0v 59.495n 0.0v 59.505n 1.8v 69.495n 1.8v 69.505n 1.8v 79.495n 1.8v 79.505n 1.8v 89.495n 1.8v 89.505n 0.0v 99.495n 0.0v 99.505n 1.8v 109.495n 1.8v 109.505n 0.0v 119.495n 0.0v 119.505n 0.0v 129.495n 0.0v 129.505n 0.0v 139.495n 0.0v 139.505n 1.8v 149.495n 1.8v 149.505n 0.0v 159.495n 0.0v 159.505n 1.8v 169.495n 1.8v 169.505n 1.8v 179.495n 1.8v 179.505n 0.0v 189.495n 0.0v 189.505n 0.0v 199.495n 0.0v 199.505n 0.0v 209.495n 0.0v 209.505n 0.0v 219.495n 0.0v 219.505n 1.8v 229.495n 1.8v 229.505n 1.8v 239.495n 1.8v 239.505n 0.0v 249.495n 0.0v 249.505n 0.0v 259.495n 0.0v 259.505n 0.0v 269.495n 0.0v 269.505n 0.0v 279.495n 0.0v 279.505n 1.8v 289.495n 1.8v 289.505n 0.0v 299.495n 0.0v 299.505n 0.0v 309.495n 0.0v 309.505n 1.8v 319.495n 1.8v 319.505n 0.0v 329.495n 0.0v 329.505n 1.8v 339.495n 1.8v 339.505n 0.0v 349.495n 0.0v 349.505n 0.0v 359.495n 0.0v 359.505n 0.0v 369.495n 0.0v 369.505n 1.8v 379.495n 1.8v 379.505n 1.8v 389.495n 1.8v 389.505n 1.8v 399.495n 1.8v 399.505n 0.0v 409.495n 0.0v 409.505n 0.0v 419.495n 0.0v 419.505n 0.0v 429.495n 0.0v 429.505n 0.0v 439.495n 0.0v 439.505n 0.0v 449.495n 0.0v 449.505n 1.8v 459.495n 1.8v 459.505n 1.8v 469.495n 1.8v 469.505n 1.8v 479.495n 1.8v 479.505n 1.8v 489.495n 1.8v 489.505n 0.0v 499.495n 0.0v 499.505n 1.8v 509.495n 1.8v 509.505n 0.0v 519.495n 0.0v 519.505n 0.0v 529.495n 0.0v 529.505n 0.0v 539.495n 0.0v 539.505n 1.8v 549.495n 1.8v 549.505n 0.0v 559.495n 0.0v 559.505n 0.0v 569.495n 0.0v 569.505n 0.0v 579.495n 0.0v 579.505n 0.0v 589.495n 0.0v 589.505n 0.0v 599.495n 0.0v 599.505n 0.0v 609.495n 0.0v 609.505n 1.8v 619.495n 1.8v 619.505n 0.0v 629.495n 0.0v 629.505n 1.8v 639.495n 1.8v 639.505n 1.8v 649.495n 1.8v 649.505n 1.8v 659.495n 1.8v 659.505n 1.8v 669.495n 1.8v 669.505n 0.0v 679.495n 0.0v 679.505n 0.0v 689.495n 0.0v 689.505n 0.0v 699.495n 0.0v 699.505n 0.0v 709.495n 0.0v 709.505n 1.8v 719.495n 1.8v 719.505n 1.8v 729.495n 1.8v 729.505n 1.8v 739.495n 1.8v 739.505n 0.0v 749.495n 0.0v 749.505n 1.8v 759.495n 1.8v 759.505n 0.0v 769.495n 0.0v 769.505n 0.0v 779.495n 0.0v 779.505n 1.8v 789.495n 1.8v 789.505n 1.8v 799.495n 1.8v 799.505n 1.8v 809.495n 1.8v 809.505n 1.8v 819.495n 1.8v 819.505n 0.0v 829.495n 0.0v 829.505n 0.0v 839.495n 0.0v 839.505n 0.0v 849.495n 0.0v 849.505n 0.0v 859.495n 0.0v 859.505n 0.0v 869.495n 0.0v 869.505n 0.0v 879.495n 0.0v 879.505n 0.0v 889.495n 0.0v 889.505n 0.0v 899.495n 0.0v 899.505n 0.0v 909.495n 0.0v 909.505n 1.8v 919.495n 1.8v 919.505n 1.8v 929.495n 1.8v 929.505n 0.0v 939.495n 0.0v 939.505n 1.8v 949.495n 1.8v 949.505n 0.0v 959.495n 0.0v 959.505n 1.8v 969.495n 1.8v 969.505n 1.8v 979.495n 1.8v 979.505n 1.8v 989.495n 1.8v 989.505n 0.0v 999.495n 0.0v 999.505n 1.8v 1009.495n 1.8v 1009.505n 0.0v 1019.495n 0.0v 1019.505n 0.0v 1029.495n 0.0v 1029.505n 1.8v 1039.495n 1.8v 1039.505n 1.8v 1049.495n 1.8v 1049.505n 0.0v 1059.495n 0.0v 1059.505n 1.8v 1069.495n 1.8v 1069.505n 1.8v 1079.495n 1.8v 1079.505n 0.0v 1089.495n 0.0v 1089.505n 0.0v 1099.495n 0.0v 1099.505n 1.8v 1109.495n 1.8v 1109.505n 0.0v 1119.495n 0.0v 1119.505n 0.0v 1129.495n 0.0v 1129.505n 1.8v 1139.495n 1.8v 1139.505n 1.8v 1149.495n 1.8v 1149.505n 0.0v 1159.495n 0.0v 1159.505n 1.8v 1169.495n 1.8v 1169.505n 0.0v 1179.495n 0.0v 1179.505n 1.8v 1189.495n 1.8v 1189.505n 0.0v 1199.495n 0.0v 1199.505n 1.8v 1209.495n 1.8v 1209.505n 0.0v 1219.495n 0.0v 1219.505n 1.8v 1229.495n 1.8v 1229.505n 1.8v 1239.495n 1.8v 1239.505n 1.8v 1249.495n 1.8v 1249.505n 1.8v 1259.495n 1.8v 1259.505n 1.8v 1269.495n 1.8v 1269.505n 1.8v 1279.495n 1.8v 1279.505n 1.8v 1289.495n 1.8v 1289.505n 0.0v 1299.495n 0.0v 1299.505n 0.0v 1309.495n 0.0v 1309.505n 0.0v 1319.495n 0.0v 1319.505n 1.8v 1329.495n 1.8v 1329.505n 1.8v 1339.495n 1.8v 1339.505n 1.8v 1349.495n 1.8v 1349.505n 0.0v 1359.495n 0.0v 1359.505n 1.8v 1369.495n 1.8v 1369.505n 0.0v 1379.495n 0.0v 1379.505n 0.0v 1389.495n 0.0v 1389.505n 1.8v 1399.495n 1.8v 1399.505n 1.8v 1409.495n 1.8v 1409.505n 1.8v 1419.495n 1.8v 1419.505n 1.8v 1429.495n 1.8v 1429.505n 1.8v 1439.495n 1.8v 1439.505n 0.0v 1449.495n 0.0v 1449.505n 0.0v 1459.495n 0.0v 1459.505n 0.0v 1469.495n 0.0v 1469.505n 0.0v 1479.495n 0.0v 1479.505n 1.8v 1489.495n 1.8v 1489.505n 0.0v 1499.495n 0.0v 1499.505n 1.8v 1509.495n 1.8v 1509.505n 0.0v 1519.495n 0.0v 1519.505n 0.0v 1529.495n 0.0v 1529.505n 1.8v 1539.495n 1.8v 1539.505n 1.8v 1549.495n 1.8v 1549.505n 1.8v 1559.495n 1.8v 1559.505n 0.0v 1569.495n 0.0v 1569.505n 0.0v 1579.495n 0.0v 1579.505n 1.8v 1589.495n 1.8v 1589.505n 0.0v 1599.495n 0.0v 1599.505n 0.0v 1609.495n 0.0v 1609.505n 1.8v 1619.495n 1.8v 1619.505n 1.8v 1629.495n 1.8v 1629.505n 1.8v 1639.495n 1.8v 1639.505n 0.0v 1649.495n 0.0v 1649.505n 0.0v 1659.495n 0.0v 1659.505n 1.8v 1669.495n 1.8v 1669.505n 0.0v 1679.495n 0.0v 1679.505n 1.8v 1689.495n 1.8v 1689.505n 1.8v 1699.495n 1.8v 1699.505n 0.0v 1709.495n 0.0v 1709.505n 1.8v 1719.495n 1.8v 1719.505n 0.0v 1729.495n 0.0v 1729.505n 0.0v 1739.495n 0.0v 1739.505n 1.8v 1749.495n 1.8v 1749.505n 0.0v 1759.495n 0.0v 1759.505n 1.8v 1769.495n 1.8v 1769.505n 1.8v 1779.495n 1.8v 1779.505n 0.0v 1789.495n 0.0v 1789.505n 0.0v 1799.495n 0.0v 1799.505n 1.8v 1809.495n 1.8v 1809.505n 1.8v 1819.495n 1.8v 1819.505n 0.0v 1829.495n 0.0v 1829.505n 0.0v 1839.495n 0.0v 1839.505n 1.8v 1849.495n 1.8v 1849.505n 0.0v 1859.495n 0.0v 1859.505n 1.8v 1869.495n 1.8v 1869.505n 1.8v 1879.495n 1.8v 1879.505n 0.0v 1889.495n 0.0v 1889.505n 0.0v 1899.495n 0.0v 1899.505n 0.0v 1909.495n 0.0v 1909.505n 0.0v 1919.495n 0.0v 1919.505n 1.8v 1929.495n 1.8v 1929.505n 0.0v 1939.495n 0.0v 1939.505n 1.8v 1949.495n 1.8v 1949.505n 1.8v 1959.495n 1.8v 1959.505n 1.8v 1969.495n 1.8v 1969.505n 1.8v 1979.495n 1.8v 1979.505n 1.8v 1989.495n 1.8v 1989.505n 1.8v 1999.495n 1.8v 1999.505n 1.8v 2009.495n 1.8v 2009.505n 1.8v 2019.495n 1.8v 2019.505n 0.0v 2029.495n 0.0v 2029.505n 1.8v 2039.495n 1.8v 2039.505n 0.0v 2049.495n 0.0v 2049.505n 0.0v )
* (time, data): [(0, 0), (10, 0), (20, 0), (30, 1), (40, 0), (50, 0), (60, 1), (70, 1), (80, 1), (90, 0), (100, 1), (110, 0), (120, 0), (130, 0), (140, 1), (150, 0), (160, 1), (170, 1), (180, 0), (190, 0), (200, 0), (210, 0), (220, 1), (230, 1), (240, 0), (250, 0), (260, 0), (270, 0), (280, 1), (290, 0), (300, 0), (310, 1), (320, 0), (330, 1), (340, 0), (350, 0), (360, 0), (370, 1), (380, 1), (390, 1), (400, 0), (410, 0), (420, 0), (430, 0), (440, 0), (450, 1), (460, 1), (470, 1), (480, 1), (490, 0), (500, 1), (510, 0), (520, 0), (530, 0), (540, 1), (550, 0), (560, 0), (570, 0), (580, 0), (590, 0), (600, 0), (610, 1), (620, 0), (630, 1), (640, 1), (650, 1), (660, 1), (670, 0), (680, 0), (690, 0), (700, 0), (710, 1), (720, 1), (730, 1), (740, 0), (750, 1), (760, 0), (770, 0), (780, 1), (790, 1), (800, 1), (810, 1), (820, 0), (830, 0), (840, 0), (850, 0), (860, 0), (870, 0), (880, 0), (890, 0), (900, 0), (910, 1), (920, 1), (930, 0), (940, 1), (950, 0), (960, 1), (970, 1), (980, 1), (990, 0), (1000, 1), (1010, 0), (1020, 0), (1030, 1), (1040, 1), (1050, 0), (1060, 1), (1070, 1), (1080, 0), (1090, 0), (1100, 1), (1110, 0), (1120, 0), (1130, 1), (1140, 1), (1150, 0), (1160, 1), (1170, 0), (1180, 1), (1190, 0), (1200, 1), (1210, 0), (1220, 1), (1230, 1), (1240, 1), (1250, 1), (1260, 1), (1270, 1), (1280, 1), (1290, 0), (1300, 0), (1310, 0), (1320, 1), (1330, 1), (1340, 1), (1350, 0), (1360, 1), (1370, 0), (1380, 0), (1390, 1), (1400, 1), (1410, 1), (1420, 1), (1430, 1), (1440, 0), (1450, 0), (1460, 0), (1470, 0), (1480, 1), (1490, 0), (1500, 1), (1510, 0), (1520, 0), (1530, 1), (1540, 1), (1550, 1), (1560, 0), (1570, 0), (1580, 1), (1590, 0), (1600, 0), (1610, 1), (1620, 1), (1630, 1), (1640, 0), (1650, 0), (1660, 1), (1670, 0), (1680, 1), (1690, 1), (1700, 0), (1710, 1), (1720, 0), (1730, 0), (1740, 1), (1750, 0), (1760, 1), (1770, 1), (1780, 0), (1790, 0), (1800, 1), (1810, 1), (1820, 0), (1830, 0), (1840, 1), (1850, 0), (1860, 1), (1870, 1), (1880, 0), (1890, 0), (1900, 0), (1910, 0), (1920, 1), (1930, 0), (1940, 1), (1950, 1), (1960, 1), (1970, 1), (1980, 1), (1990, 1), (2000, 1), (2010, 1), (2020, 0), (2030, 1), (2040, 0), (2050, 0)]
Va0_4  a0_4  0 PWL (0n 0.0v 9.495n 0.0v 9.505n 0.0v 19.495n 0.0v 19.505n 0.0v 29.495n 0.0v 29.505n 1.8v 39.495n 1.8v 39.505n 0.0v 49.495n 0.0v 49.505n 0.0v 59.495n 0.0v 59.505n 1.8v 69.495n 1.8v 69.505n 1.8v 79.495n 1.8v 79.505n 1.8v 89.495n 1.8v 89.505n 0.0v 99.495n 0.0v 99.505n 1.8v 109.495n 1.8v 109.505n 0.0v 119.495n 0.0v 119.505n 0.0v 129.495n 0.0v 129.505n 0.0v 139.495n 0.0v 139.505n 1.8v 149.495n 1.8v 149.505n 0.0v 159.495n 0.0v 159.505n 1.8v 169.495n 1.8v 169.505n 1.8v 179.495n 1.8v 179.505n 0.0v 189.495n 0.0v 189.505n 0.0v 199.495n 0.0v 199.505n 0.0v 209.495n 0.0v 209.505n 0.0v 219.495n 0.0v 219.505n 1.8v 229.495n 1.8v 229.505n 1.8v 239.495n 1.8v 239.505n 0.0v 249.495n 0.0v 249.505n 0.0v 259.495n 0.0v 259.505n 0.0v 269.495n 0.0v 269.505n 0.0v 279.495n 0.0v 279.505n 1.8v 289.495n 1.8v 289.505n 0.0v 299.495n 0.0v 299.505n 0.0v 309.495n 0.0v 309.505n 1.8v 319.495n 1.8v 319.505n 0.0v 329.495n 0.0v 329.505n 1.8v 339.495n 1.8v 339.505n 0.0v 349.495n 0.0v 349.505n 0.0v 359.495n 0.0v 359.505n 0.0v 369.495n 0.0v 369.505n 1.8v 379.495n 1.8v 379.505n 1.8v 389.495n 1.8v 389.505n 1.8v 399.495n 1.8v 399.505n 0.0v 409.495n 0.0v 409.505n 0.0v 419.495n 0.0v 419.505n 0.0v 429.495n 0.0v 429.505n 0.0v 439.495n 0.0v 439.505n 0.0v 449.495n 0.0v 449.505n 1.8v 459.495n 1.8v 459.505n 1.8v 469.495n 1.8v 469.505n 1.8v 479.495n 1.8v 479.505n 1.8v 489.495n 1.8v 489.505n 0.0v 499.495n 0.0v 499.505n 1.8v 509.495n 1.8v 509.505n 0.0v 519.495n 0.0v 519.505n 0.0v 529.495n 0.0v 529.505n 0.0v 539.495n 0.0v 539.505n 1.8v 549.495n 1.8v 549.505n 0.0v 559.495n 0.0v 559.505n 0.0v 569.495n 0.0v 569.505n 0.0v 579.495n 0.0v 579.505n 0.0v 589.495n 0.0v 589.505n 0.0v 599.495n 0.0v 599.505n 0.0v 609.495n 0.0v 609.505n 1.8v 619.495n 1.8v 619.505n 0.0v 629.495n 0.0v 629.505n 1.8v 639.495n 1.8v 639.505n 1.8v 649.495n 1.8v 649.505n 1.8v 659.495n 1.8v 659.505n 1.8v 669.495n 1.8v 669.505n 0.0v 679.495n 0.0v 679.505n 0.0v 689.495n 0.0v 689.505n 0.0v 699.495n 0.0v 699.505n 0.0v 709.495n 0.0v 709.505n 1.8v 719.495n 1.8v 719.505n 1.8v 729.495n 1.8v 729.505n 1.8v 739.495n 1.8v 739.505n 0.0v 749.495n 0.0v 749.505n 1.8v 759.495n 1.8v 759.505n 0.0v 769.495n 0.0v 769.505n 0.0v 779.495n 0.0v 779.505n 1.8v 789.495n 1.8v 789.505n 1.8v 799.495n 1.8v 799.505n 1.8v 809.495n 1.8v 809.505n 1.8v 819.495n 1.8v 819.505n 0.0v 829.495n 0.0v 829.505n 0.0v 839.495n 0.0v 839.505n 0.0v 849.495n 0.0v 849.505n 0.0v 859.495n 0.0v 859.505n 0.0v 869.495n 0.0v 869.505n 0.0v 879.495n 0.0v 879.505n 0.0v 889.495n 0.0v 889.505n 0.0v 899.495n 0.0v 899.505n 0.0v 909.495n 0.0v 909.505n 1.8v 919.495n 1.8v 919.505n 1.8v 929.495n 1.8v 929.505n 0.0v 939.495n 0.0v 939.505n 1.8v 949.495n 1.8v 949.505n 0.0v 959.495n 0.0v 959.505n 1.8v 969.495n 1.8v 969.505n 1.8v 979.495n 1.8v 979.505n 1.8v 989.495n 1.8v 989.505n 0.0v 999.495n 0.0v 999.505n 1.8v 1009.495n 1.8v 1009.505n 0.0v 1019.495n 0.0v 1019.505n 0.0v 1029.495n 0.0v 1029.505n 1.8v 1039.495n 1.8v 1039.505n 1.8v 1049.495n 1.8v 1049.505n 0.0v 1059.495n 0.0v 1059.505n 1.8v 1069.495n 1.8v 1069.505n 1.8v 1079.495n 1.8v 1079.505n 0.0v 1089.495n 0.0v 1089.505n 0.0v 1099.495n 0.0v 1099.505n 1.8v 1109.495n 1.8v 1109.505n 0.0v 1119.495n 0.0v 1119.505n 0.0v 1129.495n 0.0v 1129.505n 1.8v 1139.495n 1.8v 1139.505n 1.8v 1149.495n 1.8v 1149.505n 0.0v 1159.495n 0.0v 1159.505n 1.8v 1169.495n 1.8v 1169.505n 0.0v 1179.495n 0.0v 1179.505n 1.8v 1189.495n 1.8v 1189.505n 0.0v 1199.495n 0.0v 1199.505n 1.8v 1209.495n 1.8v 1209.505n 0.0v 1219.495n 0.0v 1219.505n 1.8v 1229.495n 1.8v 1229.505n 1.8v 1239.495n 1.8v 1239.505n 1.8v 1249.495n 1.8v 1249.505n 1.8v 1259.495n 1.8v 1259.505n 1.8v 1269.495n 1.8v 1269.505n 1.8v 1279.495n 1.8v 1279.505n 1.8v 1289.495n 1.8v 1289.505n 0.0v 1299.495n 0.0v 1299.505n 0.0v 1309.495n 0.0v 1309.505n 0.0v 1319.495n 0.0v 1319.505n 1.8v 1329.495n 1.8v 1329.505n 1.8v 1339.495n 1.8v 1339.505n 1.8v 1349.495n 1.8v 1349.505n 0.0v 1359.495n 0.0v 1359.505n 1.8v 1369.495n 1.8v 1369.505n 0.0v 1379.495n 0.0v 1379.505n 0.0v 1389.495n 0.0v 1389.505n 1.8v 1399.495n 1.8v 1399.505n 1.8v 1409.495n 1.8v 1409.505n 1.8v 1419.495n 1.8v 1419.505n 1.8v 1429.495n 1.8v 1429.505n 1.8v 1439.495n 1.8v 1439.505n 0.0v 1449.495n 0.0v 1449.505n 0.0v 1459.495n 0.0v 1459.505n 0.0v 1469.495n 0.0v 1469.505n 0.0v 1479.495n 0.0v 1479.505n 1.8v 1489.495n 1.8v 1489.505n 0.0v 1499.495n 0.0v 1499.505n 1.8v 1509.495n 1.8v 1509.505n 0.0v 1519.495n 0.0v 1519.505n 0.0v 1529.495n 0.0v 1529.505n 1.8v 1539.495n 1.8v 1539.505n 1.8v 1549.495n 1.8v 1549.505n 1.8v 1559.495n 1.8v 1559.505n 0.0v 1569.495n 0.0v 1569.505n 0.0v 1579.495n 0.0v 1579.505n 1.8v 1589.495n 1.8v 1589.505n 0.0v 1599.495n 0.0v 1599.505n 0.0v 1609.495n 0.0v 1609.505n 1.8v 1619.495n 1.8v 1619.505n 1.8v 1629.495n 1.8v 1629.505n 1.8v 1639.495n 1.8v 1639.505n 0.0v 1649.495n 0.0v 1649.505n 0.0v 1659.495n 0.0v 1659.505n 1.8v 1669.495n 1.8v 1669.505n 0.0v 1679.495n 0.0v 1679.505n 1.8v 1689.495n 1.8v 1689.505n 1.8v 1699.495n 1.8v 1699.505n 0.0v 1709.495n 0.0v 1709.505n 1.8v 1719.495n 1.8v 1719.505n 0.0v 1729.495n 0.0v 1729.505n 0.0v 1739.495n 0.0v 1739.505n 1.8v 1749.495n 1.8v 1749.505n 0.0v 1759.495n 0.0v 1759.505n 1.8v 1769.495n 1.8v 1769.505n 1.8v 1779.495n 1.8v 1779.505n 0.0v 1789.495n 0.0v 1789.505n 0.0v 1799.495n 0.0v 1799.505n 1.8v 1809.495n 1.8v 1809.505n 1.8v 1819.495n 1.8v 1819.505n 0.0v 1829.495n 0.0v 1829.505n 0.0v 1839.495n 0.0v 1839.505n 1.8v 1849.495n 1.8v 1849.505n 0.0v 1859.495n 0.0v 1859.505n 1.8v 1869.495n 1.8v 1869.505n 1.8v 1879.495n 1.8v 1879.505n 0.0v 1889.495n 0.0v 1889.505n 0.0v 1899.495n 0.0v 1899.505n 0.0v 1909.495n 0.0v 1909.505n 0.0v 1919.495n 0.0v 1919.505n 1.8v 1929.495n 1.8v 1929.505n 0.0v 1939.495n 0.0v 1939.505n 1.8v 1949.495n 1.8v 1949.505n 1.8v 1959.495n 1.8v 1959.505n 1.8v 1969.495n 1.8v 1969.505n 1.8v 1979.495n 1.8v 1979.505n 1.8v 1989.495n 1.8v 1989.505n 1.8v 1999.495n 1.8v 1999.505n 1.8v 2009.495n 1.8v 2009.505n 1.8v 2019.495n 1.8v 2019.505n 0.0v 2029.495n 0.0v 2029.505n 1.8v 2039.495n 1.8v 2039.505n 0.0v 2049.495n 0.0v 2049.505n 0.0v )
* (time, data): [(0, 0), (10, 0), (20, 0), (30, 1), (40, 0), (50, 0), (60, 1), (70, 1), (80, 1), (90, 0), (100, 1), (110, 0), (120, 0), (130, 0), (140, 1), (150, 0), (160, 1), (170, 1), (180, 0), (190, 0), (200, 0), (210, 0), (220, 1), (230, 1), (240, 0), (250, 0), (260, 0), (270, 0), (280, 1), (290, 0), (300, 0), (310, 1), (320, 0), (330, 1), (340, 0), (350, 0), (360, 0), (370, 1), (380, 1), (390, 1), (400, 0), (410, 0), (420, 0), (430, 0), (440, 0), (450, 1), (460, 1), (470, 1), (480, 1), (490, 0), (500, 1), (510, 0), (520, 0), (530, 0), (540, 1), (550, 0), (560, 0), (570, 0), (580, 0), (590, 0), (600, 0), (610, 1), (620, 0), (630, 1), (640, 1), (650, 1), (660, 1), (670, 0), (680, 0), (690, 0), (700, 0), (710, 1), (720, 1), (730, 1), (740, 0), (750, 1), (760, 0), (770, 0), (780, 1), (790, 1), (800, 1), (810, 1), (820, 0), (830, 0), (840, 0), (850, 0), (860, 0), (870, 0), (880, 0), (890, 0), (900, 0), (910, 1), (920, 1), (930, 0), (940, 1), (950, 0), (960, 1), (970, 1), (980, 1), (990, 0), (1000, 1), (1010, 0), (1020, 0), (1030, 1), (1040, 1), (1050, 0), (1060, 1), (1070, 1), (1080, 0), (1090, 0), (1100, 1), (1110, 0), (1120, 0), (1130, 1), (1140, 1), (1150, 0), (1160, 1), (1170, 0), (1180, 1), (1190, 0), (1200, 1), (1210, 0), (1220, 1), (1230, 1), (1240, 1), (1250, 1), (1260, 1), (1270, 1), (1280, 1), (1290, 0), (1300, 0), (1310, 0), (1320, 1), (1330, 1), (1340, 1), (1350, 0), (1360, 1), (1370, 0), (1380, 0), (1390, 1), (1400, 1), (1410, 1), (1420, 1), (1430, 1), (1440, 0), (1450, 0), (1460, 0), (1470, 0), (1480, 1), (1490, 0), (1500, 1), (1510, 0), (1520, 0), (1530, 1), (1540, 1), (1550, 1), (1560, 0), (1570, 0), (1580, 1), (1590, 0), (1600, 0), (1610, 1), (1620, 1), (1630, 1), (1640, 0), (1650, 0), (1660, 1), (1670, 0), (1680, 1), (1690, 1), (1700, 0), (1710, 1), (1720, 0), (1730, 0), (1740, 1), (1750, 0), (1760, 1), (1770, 1), (1780, 0), (1790, 0), (1800, 1), (1810, 1), (1820, 0), (1830, 0), (1840, 1), (1850, 0), (1860, 1), (1870, 1), (1880, 0), (1890, 0), (1900, 0), (1910, 0), (1920, 1), (1930, 0), (1940, 1), (1950, 1), (1960, 1), (1970, 1), (1980, 1), (1990, 1), (2000, 1), (2010, 1), (2020, 0), (2030, 1), (2040, 0), (2050, 0)]
Va0_5  a0_5  0 PWL (0n 0.0v 9.495n 0.0v 9.505n 0.0v 19.495n 0.0v 19.505n 0.0v 29.495n 0.0v 29.505n 1.8v 39.495n 1.8v 39.505n 0.0v 49.495n 0.0v 49.505n 0.0v 59.495n 0.0v 59.505n 1.8v 69.495n 1.8v 69.505n 1.8v 79.495n 1.8v 79.505n 1.8v 89.495n 1.8v 89.505n 0.0v 99.495n 0.0v 99.505n 1.8v 109.495n 1.8v 109.505n 0.0v 119.495n 0.0v 119.505n 0.0v 129.495n 0.0v 129.505n 0.0v 139.495n 0.0v 139.505n 1.8v 149.495n 1.8v 149.505n 0.0v 159.495n 0.0v 159.505n 1.8v 169.495n 1.8v 169.505n 1.8v 179.495n 1.8v 179.505n 0.0v 189.495n 0.0v 189.505n 0.0v 199.495n 0.0v 199.505n 0.0v 209.495n 0.0v 209.505n 0.0v 219.495n 0.0v 219.505n 1.8v 229.495n 1.8v 229.505n 1.8v 239.495n 1.8v 239.505n 0.0v 249.495n 0.0v 249.505n 0.0v 259.495n 0.0v 259.505n 0.0v 269.495n 0.0v 269.505n 0.0v 279.495n 0.0v 279.505n 1.8v 289.495n 1.8v 289.505n 0.0v 299.495n 0.0v 299.505n 0.0v 309.495n 0.0v 309.505n 1.8v 319.495n 1.8v 319.505n 0.0v 329.495n 0.0v 329.505n 1.8v 339.495n 1.8v 339.505n 0.0v 349.495n 0.0v 349.505n 0.0v 359.495n 0.0v 359.505n 0.0v 369.495n 0.0v 369.505n 1.8v 379.495n 1.8v 379.505n 1.8v 389.495n 1.8v 389.505n 1.8v 399.495n 1.8v 399.505n 0.0v 409.495n 0.0v 409.505n 0.0v 419.495n 0.0v 419.505n 0.0v 429.495n 0.0v 429.505n 0.0v 439.495n 0.0v 439.505n 0.0v 449.495n 0.0v 449.505n 1.8v 459.495n 1.8v 459.505n 1.8v 469.495n 1.8v 469.505n 1.8v 479.495n 1.8v 479.505n 1.8v 489.495n 1.8v 489.505n 0.0v 499.495n 0.0v 499.505n 1.8v 509.495n 1.8v 509.505n 0.0v 519.495n 0.0v 519.505n 0.0v 529.495n 0.0v 529.505n 0.0v 539.495n 0.0v 539.505n 1.8v 549.495n 1.8v 549.505n 0.0v 559.495n 0.0v 559.505n 0.0v 569.495n 0.0v 569.505n 0.0v 579.495n 0.0v 579.505n 0.0v 589.495n 0.0v 589.505n 0.0v 599.495n 0.0v 599.505n 0.0v 609.495n 0.0v 609.505n 1.8v 619.495n 1.8v 619.505n 0.0v 629.495n 0.0v 629.505n 1.8v 639.495n 1.8v 639.505n 1.8v 649.495n 1.8v 649.505n 1.8v 659.495n 1.8v 659.505n 1.8v 669.495n 1.8v 669.505n 0.0v 679.495n 0.0v 679.505n 0.0v 689.495n 0.0v 689.505n 0.0v 699.495n 0.0v 699.505n 0.0v 709.495n 0.0v 709.505n 1.8v 719.495n 1.8v 719.505n 1.8v 729.495n 1.8v 729.505n 1.8v 739.495n 1.8v 739.505n 0.0v 749.495n 0.0v 749.505n 1.8v 759.495n 1.8v 759.505n 0.0v 769.495n 0.0v 769.505n 0.0v 779.495n 0.0v 779.505n 1.8v 789.495n 1.8v 789.505n 1.8v 799.495n 1.8v 799.505n 1.8v 809.495n 1.8v 809.505n 1.8v 819.495n 1.8v 819.505n 0.0v 829.495n 0.0v 829.505n 0.0v 839.495n 0.0v 839.505n 0.0v 849.495n 0.0v 849.505n 0.0v 859.495n 0.0v 859.505n 0.0v 869.495n 0.0v 869.505n 0.0v 879.495n 0.0v 879.505n 0.0v 889.495n 0.0v 889.505n 0.0v 899.495n 0.0v 899.505n 0.0v 909.495n 0.0v 909.505n 1.8v 919.495n 1.8v 919.505n 1.8v 929.495n 1.8v 929.505n 0.0v 939.495n 0.0v 939.505n 1.8v 949.495n 1.8v 949.505n 0.0v 959.495n 0.0v 959.505n 1.8v 969.495n 1.8v 969.505n 1.8v 979.495n 1.8v 979.505n 1.8v 989.495n 1.8v 989.505n 0.0v 999.495n 0.0v 999.505n 1.8v 1009.495n 1.8v 1009.505n 0.0v 1019.495n 0.0v 1019.505n 0.0v 1029.495n 0.0v 1029.505n 1.8v 1039.495n 1.8v 1039.505n 1.8v 1049.495n 1.8v 1049.505n 0.0v 1059.495n 0.0v 1059.505n 1.8v 1069.495n 1.8v 1069.505n 1.8v 1079.495n 1.8v 1079.505n 0.0v 1089.495n 0.0v 1089.505n 0.0v 1099.495n 0.0v 1099.505n 1.8v 1109.495n 1.8v 1109.505n 0.0v 1119.495n 0.0v 1119.505n 0.0v 1129.495n 0.0v 1129.505n 1.8v 1139.495n 1.8v 1139.505n 1.8v 1149.495n 1.8v 1149.505n 0.0v 1159.495n 0.0v 1159.505n 1.8v 1169.495n 1.8v 1169.505n 0.0v 1179.495n 0.0v 1179.505n 1.8v 1189.495n 1.8v 1189.505n 0.0v 1199.495n 0.0v 1199.505n 1.8v 1209.495n 1.8v 1209.505n 0.0v 1219.495n 0.0v 1219.505n 1.8v 1229.495n 1.8v 1229.505n 1.8v 1239.495n 1.8v 1239.505n 1.8v 1249.495n 1.8v 1249.505n 1.8v 1259.495n 1.8v 1259.505n 1.8v 1269.495n 1.8v 1269.505n 1.8v 1279.495n 1.8v 1279.505n 1.8v 1289.495n 1.8v 1289.505n 0.0v 1299.495n 0.0v 1299.505n 0.0v 1309.495n 0.0v 1309.505n 0.0v 1319.495n 0.0v 1319.505n 1.8v 1329.495n 1.8v 1329.505n 1.8v 1339.495n 1.8v 1339.505n 1.8v 1349.495n 1.8v 1349.505n 0.0v 1359.495n 0.0v 1359.505n 1.8v 1369.495n 1.8v 1369.505n 0.0v 1379.495n 0.0v 1379.505n 0.0v 1389.495n 0.0v 1389.505n 1.8v 1399.495n 1.8v 1399.505n 1.8v 1409.495n 1.8v 1409.505n 1.8v 1419.495n 1.8v 1419.505n 1.8v 1429.495n 1.8v 1429.505n 1.8v 1439.495n 1.8v 1439.505n 0.0v 1449.495n 0.0v 1449.505n 0.0v 1459.495n 0.0v 1459.505n 0.0v 1469.495n 0.0v 1469.505n 0.0v 1479.495n 0.0v 1479.505n 1.8v 1489.495n 1.8v 1489.505n 0.0v 1499.495n 0.0v 1499.505n 1.8v 1509.495n 1.8v 1509.505n 0.0v 1519.495n 0.0v 1519.505n 0.0v 1529.495n 0.0v 1529.505n 1.8v 1539.495n 1.8v 1539.505n 1.8v 1549.495n 1.8v 1549.505n 1.8v 1559.495n 1.8v 1559.505n 0.0v 1569.495n 0.0v 1569.505n 0.0v 1579.495n 0.0v 1579.505n 1.8v 1589.495n 1.8v 1589.505n 0.0v 1599.495n 0.0v 1599.505n 0.0v 1609.495n 0.0v 1609.505n 1.8v 1619.495n 1.8v 1619.505n 1.8v 1629.495n 1.8v 1629.505n 1.8v 1639.495n 1.8v 1639.505n 0.0v 1649.495n 0.0v 1649.505n 0.0v 1659.495n 0.0v 1659.505n 1.8v 1669.495n 1.8v 1669.505n 0.0v 1679.495n 0.0v 1679.505n 1.8v 1689.495n 1.8v 1689.505n 1.8v 1699.495n 1.8v 1699.505n 0.0v 1709.495n 0.0v 1709.505n 1.8v 1719.495n 1.8v 1719.505n 0.0v 1729.495n 0.0v 1729.505n 0.0v 1739.495n 0.0v 1739.505n 1.8v 1749.495n 1.8v 1749.505n 0.0v 1759.495n 0.0v 1759.505n 1.8v 1769.495n 1.8v 1769.505n 1.8v 1779.495n 1.8v 1779.505n 0.0v 1789.495n 0.0v 1789.505n 0.0v 1799.495n 0.0v 1799.505n 1.8v 1809.495n 1.8v 1809.505n 1.8v 1819.495n 1.8v 1819.505n 0.0v 1829.495n 0.0v 1829.505n 0.0v 1839.495n 0.0v 1839.505n 1.8v 1849.495n 1.8v 1849.505n 0.0v 1859.495n 0.0v 1859.505n 1.8v 1869.495n 1.8v 1869.505n 1.8v 1879.495n 1.8v 1879.505n 0.0v 1889.495n 0.0v 1889.505n 0.0v 1899.495n 0.0v 1899.505n 0.0v 1909.495n 0.0v 1909.505n 0.0v 1919.495n 0.0v 1919.505n 1.8v 1929.495n 1.8v 1929.505n 0.0v 1939.495n 0.0v 1939.505n 1.8v 1949.495n 1.8v 1949.505n 1.8v 1959.495n 1.8v 1959.505n 1.8v 1969.495n 1.8v 1969.505n 1.8v 1979.495n 1.8v 1979.505n 1.8v 1989.495n 1.8v 1989.505n 1.8v 1999.495n 1.8v 1999.505n 1.8v 2009.495n 1.8v 2009.505n 1.8v 2019.495n 1.8v 2019.505n 0.0v 2029.495n 0.0v 2029.505n 1.8v 2039.495n 1.8v 2039.505n 0.0v 2049.495n 0.0v 2049.505n 0.0v )
* (time, data): [(0, 0), (10, 0), (20, 0), (30, 1), (40, 0), (50, 0), (60, 1), (70, 1), (80, 1), (90, 0), (100, 1), (110, 0), (120, 0), (130, 0), (140, 1), (150, 0), (160, 1), (170, 1), (180, 0), (190, 0), (200, 0), (210, 0), (220, 1), (230, 1), (240, 0), (250, 0), (260, 0), (270, 0), (280, 1), (290, 0), (300, 0), (310, 1), (320, 0), (330, 1), (340, 0), (350, 0), (360, 0), (370, 1), (380, 1), (390, 1), (400, 0), (410, 0), (420, 0), (430, 0), (440, 0), (450, 1), (460, 1), (470, 1), (480, 1), (490, 0), (500, 1), (510, 0), (520, 0), (530, 0), (540, 1), (550, 0), (560, 0), (570, 0), (580, 0), (590, 0), (600, 0), (610, 1), (620, 0), (630, 1), (640, 1), (650, 1), (660, 1), (670, 0), (680, 0), (690, 0), (700, 0), (710, 1), (720, 1), (730, 1), (740, 0), (750, 1), (760, 0), (770, 0), (780, 1), (790, 1), (800, 1), (810, 1), (820, 0), (830, 0), (840, 0), (850, 0), (860, 0), (870, 0), (880, 0), (890, 0), (900, 0), (910, 1), (920, 1), (930, 0), (940, 1), (950, 0), (960, 1), (970, 1), (980, 1), (990, 0), (1000, 1), (1010, 0), (1020, 0), (1030, 1), (1040, 1), (1050, 0), (1060, 1), (1070, 1), (1080, 0), (1090, 0), (1100, 1), (1110, 0), (1120, 0), (1130, 1), (1140, 1), (1150, 0), (1160, 1), (1170, 0), (1180, 1), (1190, 0), (1200, 1), (1210, 0), (1220, 1), (1230, 1), (1240, 1), (1250, 1), (1260, 1), (1270, 1), (1280, 1), (1290, 0), (1300, 0), (1310, 0), (1320, 1), (1330, 1), (1340, 1), (1350, 0), (1360, 1), (1370, 0), (1380, 0), (1390, 1), (1400, 1), (1410, 1), (1420, 1), (1430, 1), (1440, 0), (1450, 0), (1460, 0), (1470, 0), (1480, 1), (1490, 0), (1500, 1), (1510, 0), (1520, 0), (1530, 1), (1540, 1), (1550, 1), (1560, 0), (1570, 0), (1580, 1), (1590, 0), (1600, 0), (1610, 1), (1620, 1), (1630, 1), (1640, 0), (1650, 0), (1660, 1), (1670, 0), (1680, 1), (1690, 1), (1700, 0), (1710, 1), (1720, 0), (1730, 0), (1740, 1), (1750, 0), (1760, 1), (1770, 1), (1780, 0), (1790, 0), (1800, 1), (1810, 1), (1820, 0), (1830, 0), (1840, 1), (1850, 0), (1860, 1), (1870, 1), (1880, 0), (1890, 0), (1900, 0), (1910, 0), (1920, 1), (1930, 0), (1940, 1), (1950, 1), (1960, 1), (1970, 1), (1980, 1), (1990, 1), (2000, 1), (2010, 1), (2020, 0), (2030, 1), (2040, 0), (2050, 0)]
Va0_6  a0_6  0 PWL (0n 0.0v 9.495n 0.0v 9.505n 0.0v 19.495n 0.0v 19.505n 0.0v 29.495n 0.0v 29.505n 1.8v 39.495n 1.8v 39.505n 0.0v 49.495n 0.0v 49.505n 0.0v 59.495n 0.0v 59.505n 1.8v 69.495n 1.8v 69.505n 1.8v 79.495n 1.8v 79.505n 1.8v 89.495n 1.8v 89.505n 0.0v 99.495n 0.0v 99.505n 1.8v 109.495n 1.8v 109.505n 0.0v 119.495n 0.0v 119.505n 0.0v 129.495n 0.0v 129.505n 0.0v 139.495n 0.0v 139.505n 1.8v 149.495n 1.8v 149.505n 0.0v 159.495n 0.0v 159.505n 1.8v 169.495n 1.8v 169.505n 1.8v 179.495n 1.8v 179.505n 0.0v 189.495n 0.0v 189.505n 0.0v 199.495n 0.0v 199.505n 0.0v 209.495n 0.0v 209.505n 0.0v 219.495n 0.0v 219.505n 1.8v 229.495n 1.8v 229.505n 1.8v 239.495n 1.8v 239.505n 0.0v 249.495n 0.0v 249.505n 0.0v 259.495n 0.0v 259.505n 0.0v 269.495n 0.0v 269.505n 0.0v 279.495n 0.0v 279.505n 1.8v 289.495n 1.8v 289.505n 0.0v 299.495n 0.0v 299.505n 0.0v 309.495n 0.0v 309.505n 1.8v 319.495n 1.8v 319.505n 0.0v 329.495n 0.0v 329.505n 1.8v 339.495n 1.8v 339.505n 0.0v 349.495n 0.0v 349.505n 0.0v 359.495n 0.0v 359.505n 0.0v 369.495n 0.0v 369.505n 1.8v 379.495n 1.8v 379.505n 1.8v 389.495n 1.8v 389.505n 1.8v 399.495n 1.8v 399.505n 0.0v 409.495n 0.0v 409.505n 0.0v 419.495n 0.0v 419.505n 0.0v 429.495n 0.0v 429.505n 0.0v 439.495n 0.0v 439.505n 0.0v 449.495n 0.0v 449.505n 1.8v 459.495n 1.8v 459.505n 1.8v 469.495n 1.8v 469.505n 1.8v 479.495n 1.8v 479.505n 1.8v 489.495n 1.8v 489.505n 0.0v 499.495n 0.0v 499.505n 1.8v 509.495n 1.8v 509.505n 0.0v 519.495n 0.0v 519.505n 0.0v 529.495n 0.0v 529.505n 0.0v 539.495n 0.0v 539.505n 1.8v 549.495n 1.8v 549.505n 0.0v 559.495n 0.0v 559.505n 0.0v 569.495n 0.0v 569.505n 0.0v 579.495n 0.0v 579.505n 0.0v 589.495n 0.0v 589.505n 0.0v 599.495n 0.0v 599.505n 0.0v 609.495n 0.0v 609.505n 1.8v 619.495n 1.8v 619.505n 0.0v 629.495n 0.0v 629.505n 1.8v 639.495n 1.8v 639.505n 1.8v 649.495n 1.8v 649.505n 1.8v 659.495n 1.8v 659.505n 1.8v 669.495n 1.8v 669.505n 0.0v 679.495n 0.0v 679.505n 0.0v 689.495n 0.0v 689.505n 0.0v 699.495n 0.0v 699.505n 0.0v 709.495n 0.0v 709.505n 1.8v 719.495n 1.8v 719.505n 1.8v 729.495n 1.8v 729.505n 1.8v 739.495n 1.8v 739.505n 0.0v 749.495n 0.0v 749.505n 1.8v 759.495n 1.8v 759.505n 0.0v 769.495n 0.0v 769.505n 0.0v 779.495n 0.0v 779.505n 1.8v 789.495n 1.8v 789.505n 1.8v 799.495n 1.8v 799.505n 1.8v 809.495n 1.8v 809.505n 1.8v 819.495n 1.8v 819.505n 0.0v 829.495n 0.0v 829.505n 0.0v 839.495n 0.0v 839.505n 0.0v 849.495n 0.0v 849.505n 0.0v 859.495n 0.0v 859.505n 0.0v 869.495n 0.0v 869.505n 0.0v 879.495n 0.0v 879.505n 0.0v 889.495n 0.0v 889.505n 0.0v 899.495n 0.0v 899.505n 0.0v 909.495n 0.0v 909.505n 1.8v 919.495n 1.8v 919.505n 1.8v 929.495n 1.8v 929.505n 0.0v 939.495n 0.0v 939.505n 1.8v 949.495n 1.8v 949.505n 0.0v 959.495n 0.0v 959.505n 1.8v 969.495n 1.8v 969.505n 1.8v 979.495n 1.8v 979.505n 1.8v 989.495n 1.8v 989.505n 0.0v 999.495n 0.0v 999.505n 1.8v 1009.495n 1.8v 1009.505n 0.0v 1019.495n 0.0v 1019.505n 0.0v 1029.495n 0.0v 1029.505n 1.8v 1039.495n 1.8v 1039.505n 1.8v 1049.495n 1.8v 1049.505n 0.0v 1059.495n 0.0v 1059.505n 1.8v 1069.495n 1.8v 1069.505n 1.8v 1079.495n 1.8v 1079.505n 0.0v 1089.495n 0.0v 1089.505n 0.0v 1099.495n 0.0v 1099.505n 1.8v 1109.495n 1.8v 1109.505n 0.0v 1119.495n 0.0v 1119.505n 0.0v 1129.495n 0.0v 1129.505n 1.8v 1139.495n 1.8v 1139.505n 1.8v 1149.495n 1.8v 1149.505n 0.0v 1159.495n 0.0v 1159.505n 1.8v 1169.495n 1.8v 1169.505n 0.0v 1179.495n 0.0v 1179.505n 1.8v 1189.495n 1.8v 1189.505n 0.0v 1199.495n 0.0v 1199.505n 1.8v 1209.495n 1.8v 1209.505n 0.0v 1219.495n 0.0v 1219.505n 1.8v 1229.495n 1.8v 1229.505n 1.8v 1239.495n 1.8v 1239.505n 1.8v 1249.495n 1.8v 1249.505n 1.8v 1259.495n 1.8v 1259.505n 1.8v 1269.495n 1.8v 1269.505n 1.8v 1279.495n 1.8v 1279.505n 1.8v 1289.495n 1.8v 1289.505n 0.0v 1299.495n 0.0v 1299.505n 0.0v 1309.495n 0.0v 1309.505n 0.0v 1319.495n 0.0v 1319.505n 1.8v 1329.495n 1.8v 1329.505n 1.8v 1339.495n 1.8v 1339.505n 1.8v 1349.495n 1.8v 1349.505n 0.0v 1359.495n 0.0v 1359.505n 1.8v 1369.495n 1.8v 1369.505n 0.0v 1379.495n 0.0v 1379.505n 0.0v 1389.495n 0.0v 1389.505n 1.8v 1399.495n 1.8v 1399.505n 1.8v 1409.495n 1.8v 1409.505n 1.8v 1419.495n 1.8v 1419.505n 1.8v 1429.495n 1.8v 1429.505n 1.8v 1439.495n 1.8v 1439.505n 0.0v 1449.495n 0.0v 1449.505n 0.0v 1459.495n 0.0v 1459.505n 0.0v 1469.495n 0.0v 1469.505n 0.0v 1479.495n 0.0v 1479.505n 1.8v 1489.495n 1.8v 1489.505n 0.0v 1499.495n 0.0v 1499.505n 1.8v 1509.495n 1.8v 1509.505n 0.0v 1519.495n 0.0v 1519.505n 0.0v 1529.495n 0.0v 1529.505n 1.8v 1539.495n 1.8v 1539.505n 1.8v 1549.495n 1.8v 1549.505n 1.8v 1559.495n 1.8v 1559.505n 0.0v 1569.495n 0.0v 1569.505n 0.0v 1579.495n 0.0v 1579.505n 1.8v 1589.495n 1.8v 1589.505n 0.0v 1599.495n 0.0v 1599.505n 0.0v 1609.495n 0.0v 1609.505n 1.8v 1619.495n 1.8v 1619.505n 1.8v 1629.495n 1.8v 1629.505n 1.8v 1639.495n 1.8v 1639.505n 0.0v 1649.495n 0.0v 1649.505n 0.0v 1659.495n 0.0v 1659.505n 1.8v 1669.495n 1.8v 1669.505n 0.0v 1679.495n 0.0v 1679.505n 1.8v 1689.495n 1.8v 1689.505n 1.8v 1699.495n 1.8v 1699.505n 0.0v 1709.495n 0.0v 1709.505n 1.8v 1719.495n 1.8v 1719.505n 0.0v 1729.495n 0.0v 1729.505n 0.0v 1739.495n 0.0v 1739.505n 1.8v 1749.495n 1.8v 1749.505n 0.0v 1759.495n 0.0v 1759.505n 1.8v 1769.495n 1.8v 1769.505n 1.8v 1779.495n 1.8v 1779.505n 0.0v 1789.495n 0.0v 1789.505n 0.0v 1799.495n 0.0v 1799.505n 1.8v 1809.495n 1.8v 1809.505n 1.8v 1819.495n 1.8v 1819.505n 0.0v 1829.495n 0.0v 1829.505n 0.0v 1839.495n 0.0v 1839.505n 1.8v 1849.495n 1.8v 1849.505n 0.0v 1859.495n 0.0v 1859.505n 1.8v 1869.495n 1.8v 1869.505n 1.8v 1879.495n 1.8v 1879.505n 0.0v 1889.495n 0.0v 1889.505n 0.0v 1899.495n 0.0v 1899.505n 0.0v 1909.495n 0.0v 1909.505n 0.0v 1919.495n 0.0v 1919.505n 1.8v 1929.495n 1.8v 1929.505n 0.0v 1939.495n 0.0v 1939.505n 1.8v 1949.495n 1.8v 1949.505n 1.8v 1959.495n 1.8v 1959.505n 1.8v 1969.495n 1.8v 1969.505n 1.8v 1979.495n 1.8v 1979.505n 1.8v 1989.495n 1.8v 1989.505n 1.8v 1999.495n 1.8v 1999.505n 1.8v 2009.495n 1.8v 2009.505n 1.8v 2019.495n 1.8v 2019.505n 0.0v 2029.495n 0.0v 2029.505n 1.8v 2039.495n 1.8v 2039.505n 0.0v 2049.495n 0.0v 2049.505n 0.0v )
* (time, data): [(0, 0), (10, 0), (20, 0), (30, 0), (40, 1), (50, 0), (60, 0), (70, 0), (80, 1), (90, 1), (100, 1), (110, 1), (120, 1), (130, 1), (140, 1), (150, 0), (160, 0), (170, 0), (180, 0), (190, 0), (200, 0), (210, 0), (220, 0), (230, 0), (240, 0), (250, 1), (260, 1), (270, 1), (280, 1), (290, 1), (300, 1), (310, 1), (320, 0), (330, 0), (340, 0), (350, 0), (360, 1), (370, 1), (380, 1), (390, 1), (400, 0), (410, 1), (420, 1), (430, 0), (440, 0), (450, 1), (460, 1), (470, 0), (480, 0), (490, 0), (500, 0), (510, 0), (520, 0), (530, 0), (540, 1), (550, 1), (560, 1), (570, 0), (580, 0), (590, 0), (600, 0), (610, 0), (620, 0), (630, 0), (640, 0), (650, 1), (660, 1), (670, 1), (680, 1), (690, 0), (700, 0), (710, 0), (720, 0), (730, 1), (740, 1), (750, 1), (760, 1), (770, 1), (780, 1), (790, 1), (800, 0), (810, 0), (820, 0), (830, 0), (840, 0), (850, 0), (860, 1), (870, 0), (880, 0), (890, 0), (900, 0), (910, 0), (920, 0), (930, 0), (940, 1), (950, 1), (960, 0), (970, 0), (980, 0), (990, 1), (1000, 1), (1010, 1), (1020, 1), (1030, 1), (1040, 1), (1050, 1), (1060, 1), (1070, 0), (1080, 0), (1090, 0), (1100, 0), (1110, 0), (1120, 0), (1130, 0), (1140, 0), (1150, 0), (1160, 0), (1170, 1), (1180, 1), (1190, 1), (1200, 1), (1210, 1), (1220, 0), (1230, 0), (1240, 1), (1250, 0), (1260, 0), (1270, 0), (1280, 0), (1290, 0), (1300, 0), (1310, 0), (1320, 1), (1330, 0), (1340, 0), (1350, 0), (1360, 1), (1370, 1), (1380, 1), (1390, 1), (1400, 1), (1410, 1), (1420, 1), (1430, 1), (1440, 1), (1450, 0), (1460, 0), (1470, 0), (1480, 0), (1490, 0), (1500, 0), (1510, 1), (1520, 1), (1530, 1), (1540, 1), (1550, 1), (1560, 1), (1570, 1), (1580, 1), (1590, 0), (1600, 0), (1610, 0), (1620, 0), (1630, 0), (1640, 0), (1650, 1), (1660, 1), (1670, 1), (1680, 1), (1690, 1), (1700, 0), (1710, 0), (1720, 1), (1730, 1), (1740, 1), (1750, 1), (1760, 0), (1770, 0), (1780, 0), (1790, 0), (1800, 1), (1810, 1), (1820, 1), (1830, 1), (1840, 1), (1850, 1), (1860, 1), (1870, 1), (1880, 1), (1890, 1), (1900, 1), (1910, 0), (1920, 0), (1930, 0), (1940, 0), (1950, 0), (1960, 0), (1970, 0), (1980, 0), (1990, 0), (2000, 1), (2010, 1), (2020, 1), (2030, 0), (2040, 1), (2050, 1)]
Va1_0  a1_0  0 PWL (0n 0.0v 9.495n 0.0v 9.505n 0.0v 19.495n 0.0v 19.505n 0.0v 29.495n 0.0v 29.505n 0.0v 39.495n 0.0v 39.505n 1.8v 49.495n 1.8v 49.505n 0.0v 59.495n 0.0v 59.505n 0.0v 69.495n 0.0v 69.505n 0.0v 79.495n 0.0v 79.505n 1.8v 89.495n 1.8v 89.505n 1.8v 99.495n 1.8v 99.505n 1.8v 109.495n 1.8v 109.505n 1.8v 119.495n 1.8v 119.505n 1.8v 129.495n 1.8v 129.505n 1.8v 139.495n 1.8v 139.505n 1.8v 149.495n 1.8v 149.505n 0.0v 159.495n 0.0v 159.505n 0.0v 169.495n 0.0v 169.505n 0.0v 179.495n 0.0v 179.505n 0.0v 189.495n 0.0v 189.505n 0.0v 199.495n 0.0v 199.505n 0.0v 209.495n 0.0v 209.505n 0.0v 219.495n 0.0v 219.505n 0.0v 229.495n 0.0v 229.505n 0.0v 239.495n 0.0v 239.505n 0.0v 249.495n 0.0v 249.505n 1.8v 259.495n 1.8v 259.505n 1.8v 269.495n 1.8v 269.505n 1.8v 279.495n 1.8v 279.505n 1.8v 289.495n 1.8v 289.505n 1.8v 299.495n 1.8v 299.505n 1.8v 309.495n 1.8v 309.505n 1.8v 319.495n 1.8v 319.505n 0.0v 329.495n 0.0v 329.505n 0.0v 339.495n 0.0v 339.505n 0.0v 349.495n 0.0v 349.505n 0.0v 359.495n 0.0v 359.505n 1.8v 369.495n 1.8v 369.505n 1.8v 379.495n 1.8v 379.505n 1.8v 389.495n 1.8v 389.505n 1.8v 399.495n 1.8v 399.505n 0.0v 409.495n 0.0v 409.505n 1.8v 419.495n 1.8v 419.505n 1.8v 429.495n 1.8v 429.505n 0.0v 439.495n 0.0v 439.505n 0.0v 449.495n 0.0v 449.505n 1.8v 459.495n 1.8v 459.505n 1.8v 469.495n 1.8v 469.505n 0.0v 479.495n 0.0v 479.505n 0.0v 489.495n 0.0v 489.505n 0.0v 499.495n 0.0v 499.505n 0.0v 509.495n 0.0v 509.505n 0.0v 519.495n 0.0v 519.505n 0.0v 529.495n 0.0v 529.505n 0.0v 539.495n 0.0v 539.505n 1.8v 549.495n 1.8v 549.505n 1.8v 559.495n 1.8v 559.505n 1.8v 569.495n 1.8v 569.505n 0.0v 579.495n 0.0v 579.505n 0.0v 589.495n 0.0v 589.505n 0.0v 599.495n 0.0v 599.505n 0.0v 609.495n 0.0v 609.505n 0.0v 619.495n 0.0v 619.505n 0.0v 629.495n 0.0v 629.505n 0.0v 639.495n 0.0v 639.505n 0.0v 649.495n 0.0v 649.505n 1.8v 659.495n 1.8v 659.505n 1.8v 669.495n 1.8v 669.505n 1.8v 679.495n 1.8v 679.505n 1.8v 689.495n 1.8v 689.505n 0.0v 699.495n 0.0v 699.505n 0.0v 709.495n 0.0v 709.505n 0.0v 719.495n 0.0v 719.505n 0.0v 729.495n 0.0v 729.505n 1.8v 739.495n 1.8v 739.505n 1.8v 749.495n 1.8v 749.505n 1.8v 759.495n 1.8v 759.505n 1.8v 769.495n 1.8v 769.505n 1.8v 779.495n 1.8v 779.505n 1.8v 789.495n 1.8v 789.505n 1.8v 799.495n 1.8v 799.505n 0.0v 809.495n 0.0v 809.505n 0.0v 819.495n 0.0v 819.505n 0.0v 829.495n 0.0v 829.505n 0.0v 839.495n 0.0v 839.505n 0.0v 849.495n 0.0v 849.505n 0.0v 859.495n 0.0v 859.505n 1.8v 869.495n 1.8v 869.505n 0.0v 879.495n 0.0v 879.505n 0.0v 889.495n 0.0v 889.505n 0.0v 899.495n 0.0v 899.505n 0.0v 909.495n 0.0v 909.505n 0.0v 919.495n 0.0v 919.505n 0.0v 929.495n 0.0v 929.505n 0.0v 939.495n 0.0v 939.505n 1.8v 949.495n 1.8v 949.505n 1.8v 959.495n 1.8v 959.505n 0.0v 969.495n 0.0v 969.505n 0.0v 979.495n 0.0v 979.505n 0.0v 989.495n 0.0v 989.505n 1.8v 999.495n 1.8v 999.505n 1.8v 1009.495n 1.8v 1009.505n 1.8v 1019.495n 1.8v 1019.505n 1.8v 1029.495n 1.8v 1029.505n 1.8v 1039.495n 1.8v 1039.505n 1.8v 1049.495n 1.8v 1049.505n 1.8v 1059.495n 1.8v 1059.505n 1.8v 1069.495n 1.8v 1069.505n 0.0v 1079.495n 0.0v 1079.505n 0.0v 1089.495n 0.0v 1089.505n 0.0v 1099.495n 0.0v 1099.505n 0.0v 1109.495n 0.0v 1109.505n 0.0v 1119.495n 0.0v 1119.505n 0.0v 1129.495n 0.0v 1129.505n 0.0v 1139.495n 0.0v 1139.505n 0.0v 1149.495n 0.0v 1149.505n 0.0v 1159.495n 0.0v 1159.505n 0.0v 1169.495n 0.0v 1169.505n 1.8v 1179.495n 1.8v 1179.505n 1.8v 1189.495n 1.8v 1189.505n 1.8v 1199.495n 1.8v 1199.505n 1.8v 1209.495n 1.8v 1209.505n 1.8v 1219.495n 1.8v 1219.505n 0.0v 1229.495n 0.0v 1229.505n 0.0v 1239.495n 0.0v 1239.505n 1.8v 1249.495n 1.8v 1249.505n 0.0v 1259.495n 0.0v 1259.505n 0.0v 1269.495n 0.0v 1269.505n 0.0v 1279.495n 0.0v 1279.505n 0.0v 1289.495n 0.0v 1289.505n 0.0v 1299.495n 0.0v 1299.505n 0.0v 1309.495n 0.0v 1309.505n 0.0v 1319.495n 0.0v 1319.505n 1.8v 1329.495n 1.8v 1329.505n 0.0v 1339.495n 0.0v 1339.505n 0.0v 1349.495n 0.0v 1349.505n 0.0v 1359.495n 0.0v 1359.505n 1.8v 1369.495n 1.8v 1369.505n 1.8v 1379.495n 1.8v 1379.505n 1.8v 1389.495n 1.8v 1389.505n 1.8v 1399.495n 1.8v 1399.505n 1.8v 1409.495n 1.8v 1409.505n 1.8v 1419.495n 1.8v 1419.505n 1.8v 1429.495n 1.8v 1429.505n 1.8v 1439.495n 1.8v 1439.505n 1.8v 1449.495n 1.8v 1449.505n 0.0v 1459.495n 0.0v 1459.505n 0.0v 1469.495n 0.0v 1469.505n 0.0v 1479.495n 0.0v 1479.505n 0.0v 1489.495n 0.0v 1489.505n 0.0v 1499.495n 0.0v 1499.505n 0.0v 1509.495n 0.0v 1509.505n 1.8v 1519.495n 1.8v 1519.505n 1.8v 1529.495n 1.8v 1529.505n 1.8v 1539.495n 1.8v 1539.505n 1.8v 1549.495n 1.8v 1549.505n 1.8v 1559.495n 1.8v 1559.505n 1.8v 1569.495n 1.8v 1569.505n 1.8v 1579.495n 1.8v 1579.505n 1.8v 1589.495n 1.8v 1589.505n 0.0v 1599.495n 0.0v 1599.505n 0.0v 1609.495n 0.0v 1609.505n 0.0v 1619.495n 0.0v 1619.505n 0.0v 1629.495n 0.0v 1629.505n 0.0v 1639.495n 0.0v 1639.505n 0.0v 1649.495n 0.0v 1649.505n 1.8v 1659.495n 1.8v 1659.505n 1.8v 1669.495n 1.8v 1669.505n 1.8v 1679.495n 1.8v 1679.505n 1.8v 1689.495n 1.8v 1689.505n 1.8v 1699.495n 1.8v 1699.505n 0.0v 1709.495n 0.0v 1709.505n 0.0v 1719.495n 0.0v 1719.505n 1.8v 1729.495n 1.8v 1729.505n 1.8v 1739.495n 1.8v 1739.505n 1.8v 1749.495n 1.8v 1749.505n 1.8v 1759.495n 1.8v 1759.505n 0.0v 1769.495n 0.0v 1769.505n 0.0v 1779.495n 0.0v 1779.505n 0.0v 1789.495n 0.0v 1789.505n 0.0v 1799.495n 0.0v 1799.505n 1.8v 1809.495n 1.8v 1809.505n 1.8v 1819.495n 1.8v 1819.505n 1.8v 1829.495n 1.8v 1829.505n 1.8v 1839.495n 1.8v 1839.505n 1.8v 1849.495n 1.8v 1849.505n 1.8v 1859.495n 1.8v 1859.505n 1.8v 1869.495n 1.8v 1869.505n 1.8v 1879.495n 1.8v 1879.505n 1.8v 1889.495n 1.8v 1889.505n 1.8v 1899.495n 1.8v 1899.505n 1.8v 1909.495n 1.8v 1909.505n 0.0v 1919.495n 0.0v 1919.505n 0.0v 1929.495n 0.0v 1929.505n 0.0v 1939.495n 0.0v 1939.505n 0.0v 1949.495n 0.0v 1949.505n 0.0v 1959.495n 0.0v 1959.505n 0.0v 1969.495n 0.0v 1969.505n 0.0v 1979.495n 0.0v 1979.505n 0.0v 1989.495n 0.0v 1989.505n 0.0v 1999.495n 0.0v 1999.505n 1.8v 2009.495n 1.8v 2009.505n 1.8v 2019.495n 1.8v 2019.505n 1.8v 2029.495n 1.8v 2029.505n 0.0v 2039.495n 0.0v 2039.505n 1.8v 2049.495n 1.8v 2049.505n 1.8v )
* (time, data): [(0, 0), (10, 0), (20, 0), (30, 0), (40, 0), (50, 0), (60, 0), (70, 0), (80, 0), (90, 0), (100, 0), (110, 0), (120, 0), (130, 0), (140, 0), (150, 0), (160, 0), (170, 0), (180, 0), (190, 0), (200, 0), (210, 0), (220, 0), (230, 0), (240, 0), (250, 0), (260, 0), (270, 0), (280, 0), (290, 0), (300, 0), (310, 0), (320, 1), (330, 1), (340, 1), (350, 1), (360, 0), (370, 0), (380, 0), (390, 0), (400, 0), (410, 0), (420, 0), (430, 1), (440, 1), (450, 0), (460, 0), (470, 1), (480, 1), (490, 1), (500, 1), (510, 1), (520, 1), (530, 1), (540, 0), (550, 0), (560, 0), (570, 0), (580, 0), (590, 0), (600, 0), (610, 0), (620, 0), (630, 0), (640, 1), (650, 0), (660, 0), (670, 0), (680, 0), (690, 0), (700, 0), (710, 0), (720, 0), (730, 0), (740, 0), (750, 0), (760, 0), (770, 0), (780, 0), (790, 0), (800, 0), (810, 0), (820, 1), (830, 1), (840, 1), (850, 1), (860, 0), (870, 0), (880, 0), (890, 0), (900, 0), (910, 0), (920, 0), (930, 0), (940, 0), (950, 0), (960, 0), (970, 0), (980, 0), (990, 0), (1000, 0), (1010, 0), (1020, 0), (1030, 0), (1040, 0), (1050, 0), (1060, 0), (1070, 1), (1080, 0), (1090, 0), (1100, 0), (1110, 0), (1120, 0), (1130, 0), (1140, 0), (1150, 0), (1160, 1), (1170, 0), (1180, 0), (1190, 0), (1200, 0), (1210, 0), (1220, 0), (1230, 0), (1240, 0), (1250, 0), (1260, 0), (1270, 1), (1280, 1), (1290, 1), (1300, 1), (1310, 1), (1320, 0), (1330, 1), (1340, 1), (1350, 1), (1360, 0), (1370, 0), (1380, 0), (1390, 0), (1400, 0), (1410, 0), (1420, 0), (1430, 0), (1440, 0), (1450, 1), (1460, 1), (1470, 1), (1480, 0), (1490, 0), (1500, 0), (1510, 0), (1520, 0), (1530, 0), (1540, 0), (1550, 0), (1560, 0), (1570, 0), (1580, 0), (1590, 0), (1600, 0), (1610, 1), (1620, 1), (1630, 1), (1640, 0), (1650, 0), (1660, 0), (1670, 0), (1680, 0), (1690, 0), (1700, 1), (1710, 0), (1720, 0), (1730, 0), (1740, 0), (1750, 0), (1760, 0), (1770, 0), (1780, 0), (1790, 0), (1800, 0), (1810, 0), (1820, 0), (1830, 0), (1840, 0), (1850, 0), (1860, 0), (1870, 0), (1880, 0), (1890, 0), (1900, 0), (1910, 0), (1920, 0), (1930, 1), (1940, 1), (1950, 1), (1960, 1), (1970, 0), (1980, 0), (1990, 1), (2000, 0), (2010, 0), (2020, 0), (2030, 1), (2040, 0), (2050, 0)]
Va1_1  a1_1  0 PWL (0n 0.0v 9.495n 0.0v 9.505n 0.0v 19.495n 0.0v 19.505n 0.0v 29.495n 0.0v 29.505n 0.0v 39.495n 0.0v 39.505n 0.0v 49.495n 0.0v 49.505n 0.0v 59.495n 0.0v 59.505n 0.0v 69.495n 0.0v 69.505n 0.0v 79.495n 0.0v 79.505n 0.0v 89.495n 0.0v 89.505n 0.0v 99.495n 0.0v 99.505n 0.0v 109.495n 0.0v 109.505n 0.0v 119.495n 0.0v 119.505n 0.0v 129.495n 0.0v 129.505n 0.0v 139.495n 0.0v 139.505n 0.0v 149.495n 0.0v 149.505n 0.0v 159.495n 0.0v 159.505n 0.0v 169.495n 0.0v 169.505n 0.0v 179.495n 0.0v 179.505n 0.0v 189.495n 0.0v 189.505n 0.0v 199.495n 0.0v 199.505n 0.0v 209.495n 0.0v 209.505n 0.0v 219.495n 0.0v 219.505n 0.0v 229.495n 0.0v 229.505n 0.0v 239.495n 0.0v 239.505n 0.0v 249.495n 0.0v 249.505n 0.0v 259.495n 0.0v 259.505n 0.0v 269.495n 0.0v 269.505n 0.0v 279.495n 0.0v 279.505n 0.0v 289.495n 0.0v 289.505n 0.0v 299.495n 0.0v 299.505n 0.0v 309.495n 0.0v 309.505n 0.0v 319.495n 0.0v 319.505n 1.8v 329.495n 1.8v 329.505n 1.8v 339.495n 1.8v 339.505n 1.8v 349.495n 1.8v 349.505n 1.8v 359.495n 1.8v 359.505n 0.0v 369.495n 0.0v 369.505n 0.0v 379.495n 0.0v 379.505n 0.0v 389.495n 0.0v 389.505n 0.0v 399.495n 0.0v 399.505n 0.0v 409.495n 0.0v 409.505n 0.0v 419.495n 0.0v 419.505n 0.0v 429.495n 0.0v 429.505n 1.8v 439.495n 1.8v 439.505n 1.8v 449.495n 1.8v 449.505n 0.0v 459.495n 0.0v 459.505n 0.0v 469.495n 0.0v 469.505n 1.8v 479.495n 1.8v 479.505n 1.8v 489.495n 1.8v 489.505n 1.8v 499.495n 1.8v 499.505n 1.8v 509.495n 1.8v 509.505n 1.8v 519.495n 1.8v 519.505n 1.8v 529.495n 1.8v 529.505n 1.8v 539.495n 1.8v 539.505n 0.0v 549.495n 0.0v 549.505n 0.0v 559.495n 0.0v 559.505n 0.0v 569.495n 0.0v 569.505n 0.0v 579.495n 0.0v 579.505n 0.0v 589.495n 0.0v 589.505n 0.0v 599.495n 0.0v 599.505n 0.0v 609.495n 0.0v 609.505n 0.0v 619.495n 0.0v 619.505n 0.0v 629.495n 0.0v 629.505n 0.0v 639.495n 0.0v 639.505n 1.8v 649.495n 1.8v 649.505n 0.0v 659.495n 0.0v 659.505n 0.0v 669.495n 0.0v 669.505n 0.0v 679.495n 0.0v 679.505n 0.0v 689.495n 0.0v 689.505n 0.0v 699.495n 0.0v 699.505n 0.0v 709.495n 0.0v 709.505n 0.0v 719.495n 0.0v 719.505n 0.0v 729.495n 0.0v 729.505n 0.0v 739.495n 0.0v 739.505n 0.0v 749.495n 0.0v 749.505n 0.0v 759.495n 0.0v 759.505n 0.0v 769.495n 0.0v 769.505n 0.0v 779.495n 0.0v 779.505n 0.0v 789.495n 0.0v 789.505n 0.0v 799.495n 0.0v 799.505n 0.0v 809.495n 0.0v 809.505n 0.0v 819.495n 0.0v 819.505n 1.8v 829.495n 1.8v 829.505n 1.8v 839.495n 1.8v 839.505n 1.8v 849.495n 1.8v 849.505n 1.8v 859.495n 1.8v 859.505n 0.0v 869.495n 0.0v 869.505n 0.0v 879.495n 0.0v 879.505n 0.0v 889.495n 0.0v 889.505n 0.0v 899.495n 0.0v 899.505n 0.0v 909.495n 0.0v 909.505n 0.0v 919.495n 0.0v 919.505n 0.0v 929.495n 0.0v 929.505n 0.0v 939.495n 0.0v 939.505n 0.0v 949.495n 0.0v 949.505n 0.0v 959.495n 0.0v 959.505n 0.0v 969.495n 0.0v 969.505n 0.0v 979.495n 0.0v 979.505n 0.0v 989.495n 0.0v 989.505n 0.0v 999.495n 0.0v 999.505n 0.0v 1009.495n 0.0v 1009.505n 0.0v 1019.495n 0.0v 1019.505n 0.0v 1029.495n 0.0v 1029.505n 0.0v 1039.495n 0.0v 1039.505n 0.0v 1049.495n 0.0v 1049.505n 0.0v 1059.495n 0.0v 1059.505n 0.0v 1069.495n 0.0v 1069.505n 1.8v 1079.495n 1.8v 1079.505n 0.0v 1089.495n 0.0v 1089.505n 0.0v 1099.495n 0.0v 1099.505n 0.0v 1109.495n 0.0v 1109.505n 0.0v 1119.495n 0.0v 1119.505n 0.0v 1129.495n 0.0v 1129.505n 0.0v 1139.495n 0.0v 1139.505n 0.0v 1149.495n 0.0v 1149.505n 0.0v 1159.495n 0.0v 1159.505n 1.8v 1169.495n 1.8v 1169.505n 0.0v 1179.495n 0.0v 1179.505n 0.0v 1189.495n 0.0v 1189.505n 0.0v 1199.495n 0.0v 1199.505n 0.0v 1209.495n 0.0v 1209.505n 0.0v 1219.495n 0.0v 1219.505n 0.0v 1229.495n 0.0v 1229.505n 0.0v 1239.495n 0.0v 1239.505n 0.0v 1249.495n 0.0v 1249.505n 0.0v 1259.495n 0.0v 1259.505n 0.0v 1269.495n 0.0v 1269.505n 1.8v 1279.495n 1.8v 1279.505n 1.8v 1289.495n 1.8v 1289.505n 1.8v 1299.495n 1.8v 1299.505n 1.8v 1309.495n 1.8v 1309.505n 1.8v 1319.495n 1.8v 1319.505n 0.0v 1329.495n 0.0v 1329.505n 1.8v 1339.495n 1.8v 1339.505n 1.8v 1349.495n 1.8v 1349.505n 1.8v 1359.495n 1.8v 1359.505n 0.0v 1369.495n 0.0v 1369.505n 0.0v 1379.495n 0.0v 1379.505n 0.0v 1389.495n 0.0v 1389.505n 0.0v 1399.495n 0.0v 1399.505n 0.0v 1409.495n 0.0v 1409.505n 0.0v 1419.495n 0.0v 1419.505n 0.0v 1429.495n 0.0v 1429.505n 0.0v 1439.495n 0.0v 1439.505n 0.0v 1449.495n 0.0v 1449.505n 1.8v 1459.495n 1.8v 1459.505n 1.8v 1469.495n 1.8v 1469.505n 1.8v 1479.495n 1.8v 1479.505n 0.0v 1489.495n 0.0v 1489.505n 0.0v 1499.495n 0.0v 1499.505n 0.0v 1509.495n 0.0v 1509.505n 0.0v 1519.495n 0.0v 1519.505n 0.0v 1529.495n 0.0v 1529.505n 0.0v 1539.495n 0.0v 1539.505n 0.0v 1549.495n 0.0v 1549.505n 0.0v 1559.495n 0.0v 1559.505n 0.0v 1569.495n 0.0v 1569.505n 0.0v 1579.495n 0.0v 1579.505n 0.0v 1589.495n 0.0v 1589.505n 0.0v 1599.495n 0.0v 1599.505n 0.0v 1609.495n 0.0v 1609.505n 1.8v 1619.495n 1.8v 1619.505n 1.8v 1629.495n 1.8v 1629.505n 1.8v 1639.495n 1.8v 1639.505n 0.0v 1649.495n 0.0v 1649.505n 0.0v 1659.495n 0.0v 1659.505n 0.0v 1669.495n 0.0v 1669.505n 0.0v 1679.495n 0.0v 1679.505n 0.0v 1689.495n 0.0v 1689.505n 0.0v 1699.495n 0.0v 1699.505n 1.8v 1709.495n 1.8v 1709.505n 0.0v 1719.495n 0.0v 1719.505n 0.0v 1729.495n 0.0v 1729.505n 0.0v 1739.495n 0.0v 1739.505n 0.0v 1749.495n 0.0v 1749.505n 0.0v 1759.495n 0.0v 1759.505n 0.0v 1769.495n 0.0v 1769.505n 0.0v 1779.495n 0.0v 1779.505n 0.0v 1789.495n 0.0v 1789.505n 0.0v 1799.495n 0.0v 1799.505n 0.0v 1809.495n 0.0v 1809.505n 0.0v 1819.495n 0.0v 1819.505n 0.0v 1829.495n 0.0v 1829.505n 0.0v 1839.495n 0.0v 1839.505n 0.0v 1849.495n 0.0v 1849.505n 0.0v 1859.495n 0.0v 1859.505n 0.0v 1869.495n 0.0v 1869.505n 0.0v 1879.495n 0.0v 1879.505n 0.0v 1889.495n 0.0v 1889.505n 0.0v 1899.495n 0.0v 1899.505n 0.0v 1909.495n 0.0v 1909.505n 0.0v 1919.495n 0.0v 1919.505n 0.0v 1929.495n 0.0v 1929.505n 1.8v 1939.495n 1.8v 1939.505n 1.8v 1949.495n 1.8v 1949.505n 1.8v 1959.495n 1.8v 1959.505n 1.8v 1969.495n 1.8v 1969.505n 0.0v 1979.495n 0.0v 1979.505n 0.0v 1989.495n 0.0v 1989.505n 1.8v 1999.495n 1.8v 1999.505n 0.0v 2009.495n 0.0v 2009.505n 0.0v 2019.495n 0.0v 2019.505n 0.0v 2029.495n 0.0v 2029.505n 1.8v 2039.495n 1.8v 2039.505n 0.0v 2049.495n 0.0v 2049.505n 0.0v )
* (time, data): [(0, 0), (10, 0), (20, 0), (30, 0), (40, 1), (50, 0), (60, 0), (70, 0), (80, 0), (90, 0), (100, 0), (110, 0), (120, 0), (130, 0), (140, 0), (150, 0), (160, 0), (170, 0), (180, 0), (190, 0), (200, 0), (210, 0), (220, 0), (230, 0), (240, 0), (250, 1), (260, 1), (270, 1), (280, 0), (290, 0), (300, 1), (310, 1), (320, 1), (330, 1), (340, 1), (350, 1), (360, 0), (370, 1), (380, 1), (390, 1), (400, 0), (410, 1), (420, 1), (430, 1), (440, 1), (450, 1), (460, 1), (470, 1), (480, 1), (490, 1), (500, 1), (510, 1), (520, 1), (530, 1), (540, 0), (550, 0), (560, 0), (570, 0), (580, 0), (590, 0), (600, 0), (610, 0), (620, 0), (630, 0), (640, 1), (650, 1), (660, 1), (670, 1), (680, 1), (690, 0), (700, 0), (710, 0), (720, 0), (730, 0), (740, 1), (750, 1), (760, 1), (770, 1), (780, 1), (790, 1), (800, 0), (810, 0), (820, 1), (830, 1), (840, 1), (850, 1), (860, 1), (870, 0), (880, 0), (890, 0), (900, 0), (910, 0), (920, 0), (930, 0), (940, 1), (950, 1), (960, 0), (970, 0), (980, 0), (990, 1), (1000, 1), (1010, 1), (1020, 1), (1030, 0), (1040, 0), (1050, 0), (1060, 0), (1070, 1), (1080, 0), (1090, 0), (1100, 0), (1110, 0), (1120, 0), (1130, 0), (1140, 0), (1150, 0), (1160, 1), (1170, 0), (1180, 0), (1190, 1), (1200, 1), (1210, 1), (1220, 0), (1230, 0), (1240, 0), (1250, 0), (1260, 0), (1270, 1), (1280, 1), (1290, 1), (1300, 1), (1310, 1), (1320, 0), (1330, 1), (1340, 1), (1350, 1), (1360, 1), (1370, 1), (1380, 1), (1390, 1), (1400, 1), (1410, 1), (1420, 1), (1430, 1), (1440, 1), (1450, 1), (1460, 1), (1470, 1), (1480, 0), (1490, 0), (1500, 0), (1510, 1), (1520, 1), (1530, 1), (1540, 1), (1550, 1), (1560, 1), (1570, 1), (1580, 0), (1590, 0), (1600, 0), (1610, 1), (1620, 1), (1630, 1), (1640, 0), (1650, 0), (1660, 0), (1670, 0), (1680, 1), (1690, 1), (1700, 1), (1710, 0), (1720, 0), (1730, 0), (1740, 1), (1750, 0), (1760, 0), (1770, 0), (1780, 0), (1790, 0), (1800, 0), (1810, 0), (1820, 0), (1830, 1), (1840, 1), (1850, 1), (1860, 1), (1870, 1), (1880, 1), (1890, 0), (1900, 1), (1910, 0), (1920, 0), (1930, 1), (1940, 1), (1950, 1), (1960, 1), (1970, 0), (1980, 0), (1990, 1), (2000, 0), (2010, 0), (2020, 0), (2030, 1), (2040, 0), (2050, 0)]
Va1_2  a1_2  0 PWL (0n 0.0v 9.495n 0.0v 9.505n 0.0v 19.495n 0.0v 19.505n 0.0v 29.495n 0.0v 29.505n 0.0v 39.495n 0.0v 39.505n 1.8v 49.495n 1.8v 49.505n 0.0v 59.495n 0.0v 59.505n 0.0v 69.495n 0.0v 69.505n 0.0v 79.495n 0.0v 79.505n 0.0v 89.495n 0.0v 89.505n 0.0v 99.495n 0.0v 99.505n 0.0v 109.495n 0.0v 109.505n 0.0v 119.495n 0.0v 119.505n 0.0v 129.495n 0.0v 129.505n 0.0v 139.495n 0.0v 139.505n 0.0v 149.495n 0.0v 149.505n 0.0v 159.495n 0.0v 159.505n 0.0v 169.495n 0.0v 169.505n 0.0v 179.495n 0.0v 179.505n 0.0v 189.495n 0.0v 189.505n 0.0v 199.495n 0.0v 199.505n 0.0v 209.495n 0.0v 209.505n 0.0v 219.495n 0.0v 219.505n 0.0v 229.495n 0.0v 229.505n 0.0v 239.495n 0.0v 239.505n 0.0v 249.495n 0.0v 249.505n 1.8v 259.495n 1.8v 259.505n 1.8v 269.495n 1.8v 269.505n 1.8v 279.495n 1.8v 279.505n 0.0v 289.495n 0.0v 289.505n 0.0v 299.495n 0.0v 299.505n 1.8v 309.495n 1.8v 309.505n 1.8v 319.495n 1.8v 319.505n 1.8v 329.495n 1.8v 329.505n 1.8v 339.495n 1.8v 339.505n 1.8v 349.495n 1.8v 349.505n 1.8v 359.495n 1.8v 359.505n 0.0v 369.495n 0.0v 369.505n 1.8v 379.495n 1.8v 379.505n 1.8v 389.495n 1.8v 389.505n 1.8v 399.495n 1.8v 399.505n 0.0v 409.495n 0.0v 409.505n 1.8v 419.495n 1.8v 419.505n 1.8v 429.495n 1.8v 429.505n 1.8v 439.495n 1.8v 439.505n 1.8v 449.495n 1.8v 449.505n 1.8v 459.495n 1.8v 459.505n 1.8v 469.495n 1.8v 469.505n 1.8v 479.495n 1.8v 479.505n 1.8v 489.495n 1.8v 489.505n 1.8v 499.495n 1.8v 499.505n 1.8v 509.495n 1.8v 509.505n 1.8v 519.495n 1.8v 519.505n 1.8v 529.495n 1.8v 529.505n 1.8v 539.495n 1.8v 539.505n 0.0v 549.495n 0.0v 549.505n 0.0v 559.495n 0.0v 559.505n 0.0v 569.495n 0.0v 569.505n 0.0v 579.495n 0.0v 579.505n 0.0v 589.495n 0.0v 589.505n 0.0v 599.495n 0.0v 599.505n 0.0v 609.495n 0.0v 609.505n 0.0v 619.495n 0.0v 619.505n 0.0v 629.495n 0.0v 629.505n 0.0v 639.495n 0.0v 639.505n 1.8v 649.495n 1.8v 649.505n 1.8v 659.495n 1.8v 659.505n 1.8v 669.495n 1.8v 669.505n 1.8v 679.495n 1.8v 679.505n 1.8v 689.495n 1.8v 689.505n 0.0v 699.495n 0.0v 699.505n 0.0v 709.495n 0.0v 709.505n 0.0v 719.495n 0.0v 719.505n 0.0v 729.495n 0.0v 729.505n 0.0v 739.495n 0.0v 739.505n 1.8v 749.495n 1.8v 749.505n 1.8v 759.495n 1.8v 759.505n 1.8v 769.495n 1.8v 769.505n 1.8v 779.495n 1.8v 779.505n 1.8v 789.495n 1.8v 789.505n 1.8v 799.495n 1.8v 799.505n 0.0v 809.495n 0.0v 809.505n 0.0v 819.495n 0.0v 819.505n 1.8v 829.495n 1.8v 829.505n 1.8v 839.495n 1.8v 839.505n 1.8v 849.495n 1.8v 849.505n 1.8v 859.495n 1.8v 859.505n 1.8v 869.495n 1.8v 869.505n 0.0v 879.495n 0.0v 879.505n 0.0v 889.495n 0.0v 889.505n 0.0v 899.495n 0.0v 899.505n 0.0v 909.495n 0.0v 909.505n 0.0v 919.495n 0.0v 919.505n 0.0v 929.495n 0.0v 929.505n 0.0v 939.495n 0.0v 939.505n 1.8v 949.495n 1.8v 949.505n 1.8v 959.495n 1.8v 959.505n 0.0v 969.495n 0.0v 969.505n 0.0v 979.495n 0.0v 979.505n 0.0v 989.495n 0.0v 989.505n 1.8v 999.495n 1.8v 999.505n 1.8v 1009.495n 1.8v 1009.505n 1.8v 1019.495n 1.8v 1019.505n 1.8v 1029.495n 1.8v 1029.505n 0.0v 1039.495n 0.0v 1039.505n 0.0v 1049.495n 0.0v 1049.505n 0.0v 1059.495n 0.0v 1059.505n 0.0v 1069.495n 0.0v 1069.505n 1.8v 1079.495n 1.8v 1079.505n 0.0v 1089.495n 0.0v 1089.505n 0.0v 1099.495n 0.0v 1099.505n 0.0v 1109.495n 0.0v 1109.505n 0.0v 1119.495n 0.0v 1119.505n 0.0v 1129.495n 0.0v 1129.505n 0.0v 1139.495n 0.0v 1139.505n 0.0v 1149.495n 0.0v 1149.505n 0.0v 1159.495n 0.0v 1159.505n 1.8v 1169.495n 1.8v 1169.505n 0.0v 1179.495n 0.0v 1179.505n 0.0v 1189.495n 0.0v 1189.505n 1.8v 1199.495n 1.8v 1199.505n 1.8v 1209.495n 1.8v 1209.505n 1.8v 1219.495n 1.8v 1219.505n 0.0v 1229.495n 0.0v 1229.505n 0.0v 1239.495n 0.0v 1239.505n 0.0v 1249.495n 0.0v 1249.505n 0.0v 1259.495n 0.0v 1259.505n 0.0v 1269.495n 0.0v 1269.505n 1.8v 1279.495n 1.8v 1279.505n 1.8v 1289.495n 1.8v 1289.505n 1.8v 1299.495n 1.8v 1299.505n 1.8v 1309.495n 1.8v 1309.505n 1.8v 1319.495n 1.8v 1319.505n 0.0v 1329.495n 0.0v 1329.505n 1.8v 1339.495n 1.8v 1339.505n 1.8v 1349.495n 1.8v 1349.505n 1.8v 1359.495n 1.8v 1359.505n 1.8v 1369.495n 1.8v 1369.505n 1.8v 1379.495n 1.8v 1379.505n 1.8v 1389.495n 1.8v 1389.505n 1.8v 1399.495n 1.8v 1399.505n 1.8v 1409.495n 1.8v 1409.505n 1.8v 1419.495n 1.8v 1419.505n 1.8v 1429.495n 1.8v 1429.505n 1.8v 1439.495n 1.8v 1439.505n 1.8v 1449.495n 1.8v 1449.505n 1.8v 1459.495n 1.8v 1459.505n 1.8v 1469.495n 1.8v 1469.505n 1.8v 1479.495n 1.8v 1479.505n 0.0v 1489.495n 0.0v 1489.505n 0.0v 1499.495n 0.0v 1499.505n 0.0v 1509.495n 0.0v 1509.505n 1.8v 1519.495n 1.8v 1519.505n 1.8v 1529.495n 1.8v 1529.505n 1.8v 1539.495n 1.8v 1539.505n 1.8v 1549.495n 1.8v 1549.505n 1.8v 1559.495n 1.8v 1559.505n 1.8v 1569.495n 1.8v 1569.505n 1.8v 1579.495n 1.8v 1579.505n 0.0v 1589.495n 0.0v 1589.505n 0.0v 1599.495n 0.0v 1599.505n 0.0v 1609.495n 0.0v 1609.505n 1.8v 1619.495n 1.8v 1619.505n 1.8v 1629.495n 1.8v 1629.505n 1.8v 1639.495n 1.8v 1639.505n 0.0v 1649.495n 0.0v 1649.505n 0.0v 1659.495n 0.0v 1659.505n 0.0v 1669.495n 0.0v 1669.505n 0.0v 1679.495n 0.0v 1679.505n 1.8v 1689.495n 1.8v 1689.505n 1.8v 1699.495n 1.8v 1699.505n 1.8v 1709.495n 1.8v 1709.505n 0.0v 1719.495n 0.0v 1719.505n 0.0v 1729.495n 0.0v 1729.505n 0.0v 1739.495n 0.0v 1739.505n 1.8v 1749.495n 1.8v 1749.505n 0.0v 1759.495n 0.0v 1759.505n 0.0v 1769.495n 0.0v 1769.505n 0.0v 1779.495n 0.0v 1779.505n 0.0v 1789.495n 0.0v 1789.505n 0.0v 1799.495n 0.0v 1799.505n 0.0v 1809.495n 0.0v 1809.505n 0.0v 1819.495n 0.0v 1819.505n 0.0v 1829.495n 0.0v 1829.505n 1.8v 1839.495n 1.8v 1839.505n 1.8v 1849.495n 1.8v 1849.505n 1.8v 1859.495n 1.8v 1859.505n 1.8v 1869.495n 1.8v 1869.505n 1.8v 1879.495n 1.8v 1879.505n 1.8v 1889.495n 1.8v 1889.505n 0.0v 1899.495n 0.0v 1899.505n 1.8v 1909.495n 1.8v 1909.505n 0.0v 1919.495n 0.0v 1919.505n 0.0v 1929.495n 0.0v 1929.505n 1.8v 1939.495n 1.8v 1939.505n 1.8v 1949.495n 1.8v 1949.505n 1.8v 1959.495n 1.8v 1959.505n 1.8v 1969.495n 1.8v 1969.505n 0.0v 1979.495n 0.0v 1979.505n 0.0v 1989.495n 0.0v 1989.505n 1.8v 1999.495n 1.8v 1999.505n 0.0v 2009.495n 0.0v 2009.505n 0.0v 2019.495n 0.0v 2019.505n 0.0v 2029.495n 0.0v 2029.505n 1.8v 2039.495n 1.8v 2039.505n 0.0v 2049.495n 0.0v 2049.505n 0.0v )
* (time, data): [(0, 0), (10, 0), (20, 0), (30, 0), (40, 1), (50, 0), (60, 0), (70, 0), (80, 0), (90, 0), (100, 0), (110, 0), (120, 0), (130, 0), (140, 0), (150, 0), (160, 0), (170, 0), (180, 0), (190, 0), (200, 0), (210, 0), (220, 0), (230, 0), (240, 0), (250, 1), (260, 1), (270, 1), (280, 0), (290, 0), (300, 1), (310, 1), (320, 1), (330, 1), (340, 1), (350, 1), (360, 0), (370, 1), (380, 1), (390, 1), (400, 0), (410, 1), (420, 1), (430, 1), (440, 1), (450, 1), (460, 1), (470, 1), (480, 1), (490, 1), (500, 1), (510, 1), (520, 1), (530, 1), (540, 0), (550, 0), (560, 0), (570, 0), (580, 0), (590, 0), (600, 0), (610, 0), (620, 0), (630, 0), (640, 1), (650, 1), (660, 1), (670, 1), (680, 1), (690, 0), (700, 0), (710, 0), (720, 0), (730, 0), (740, 1), (750, 1), (760, 1), (770, 1), (780, 1), (790, 1), (800, 0), (810, 0), (820, 1), (830, 1), (840, 1), (850, 1), (860, 1), (870, 0), (880, 0), (890, 0), (900, 0), (910, 0), (920, 0), (930, 0), (940, 1), (950, 1), (960, 0), (970, 0), (980, 0), (990, 1), (1000, 1), (1010, 1), (1020, 1), (1030, 0), (1040, 0), (1050, 0), (1060, 0), (1070, 1), (1080, 0), (1090, 0), (1100, 0), (1110, 0), (1120, 0), (1130, 0), (1140, 0), (1150, 0), (1160, 1), (1170, 0), (1180, 0), (1190, 1), (1200, 1), (1210, 1), (1220, 0), (1230, 0), (1240, 0), (1250, 0), (1260, 0), (1270, 1), (1280, 1), (1290, 1), (1300, 1), (1310, 1), (1320, 0), (1330, 1), (1340, 1), (1350, 1), (1360, 1), (1370, 1), (1380, 1), (1390, 1), (1400, 1), (1410, 1), (1420, 1), (1430, 1), (1440, 1), (1450, 1), (1460, 1), (1470, 1), (1480, 0), (1490, 0), (1500, 0), (1510, 1), (1520, 1), (1530, 1), (1540, 1), (1550, 1), (1560, 1), (1570, 1), (1580, 0), (1590, 0), (1600, 0), (1610, 1), (1620, 1), (1630, 1), (1640, 0), (1650, 0), (1660, 0), (1670, 0), (1680, 1), (1690, 1), (1700, 1), (1710, 0), (1720, 0), (1730, 0), (1740, 1), (1750, 0), (1760, 0), (1770, 0), (1780, 0), (1790, 0), (1800, 0), (1810, 0), (1820, 0), (1830, 1), (1840, 1), (1850, 1), (1860, 1), (1870, 1), (1880, 1), (1890, 0), (1900, 1), (1910, 0), (1920, 0), (1930, 1), (1940, 1), (1950, 1), (1960, 1), (1970, 0), (1980, 0), (1990, 1), (2000, 0), (2010, 0), (2020, 0), (2030, 1), (2040, 0), (2050, 0)]
Va1_3  a1_3  0 PWL (0n 0.0v 9.495n 0.0v 9.505n 0.0v 19.495n 0.0v 19.505n 0.0v 29.495n 0.0v 29.505n 0.0v 39.495n 0.0v 39.505n 1.8v 49.495n 1.8v 49.505n 0.0v 59.495n 0.0v 59.505n 0.0v 69.495n 0.0v 69.505n 0.0v 79.495n 0.0v 79.505n 0.0v 89.495n 0.0v 89.505n 0.0v 99.495n 0.0v 99.505n 0.0v 109.495n 0.0v 109.505n 0.0v 119.495n 0.0v 119.505n 0.0v 129.495n 0.0v 129.505n 0.0v 139.495n 0.0v 139.505n 0.0v 149.495n 0.0v 149.505n 0.0v 159.495n 0.0v 159.505n 0.0v 169.495n 0.0v 169.505n 0.0v 179.495n 0.0v 179.505n 0.0v 189.495n 0.0v 189.505n 0.0v 199.495n 0.0v 199.505n 0.0v 209.495n 0.0v 209.505n 0.0v 219.495n 0.0v 219.505n 0.0v 229.495n 0.0v 229.505n 0.0v 239.495n 0.0v 239.505n 0.0v 249.495n 0.0v 249.505n 1.8v 259.495n 1.8v 259.505n 1.8v 269.495n 1.8v 269.505n 1.8v 279.495n 1.8v 279.505n 0.0v 289.495n 0.0v 289.505n 0.0v 299.495n 0.0v 299.505n 1.8v 309.495n 1.8v 309.505n 1.8v 319.495n 1.8v 319.505n 1.8v 329.495n 1.8v 329.505n 1.8v 339.495n 1.8v 339.505n 1.8v 349.495n 1.8v 349.505n 1.8v 359.495n 1.8v 359.505n 0.0v 369.495n 0.0v 369.505n 1.8v 379.495n 1.8v 379.505n 1.8v 389.495n 1.8v 389.505n 1.8v 399.495n 1.8v 399.505n 0.0v 409.495n 0.0v 409.505n 1.8v 419.495n 1.8v 419.505n 1.8v 429.495n 1.8v 429.505n 1.8v 439.495n 1.8v 439.505n 1.8v 449.495n 1.8v 449.505n 1.8v 459.495n 1.8v 459.505n 1.8v 469.495n 1.8v 469.505n 1.8v 479.495n 1.8v 479.505n 1.8v 489.495n 1.8v 489.505n 1.8v 499.495n 1.8v 499.505n 1.8v 509.495n 1.8v 509.505n 1.8v 519.495n 1.8v 519.505n 1.8v 529.495n 1.8v 529.505n 1.8v 539.495n 1.8v 539.505n 0.0v 549.495n 0.0v 549.505n 0.0v 559.495n 0.0v 559.505n 0.0v 569.495n 0.0v 569.505n 0.0v 579.495n 0.0v 579.505n 0.0v 589.495n 0.0v 589.505n 0.0v 599.495n 0.0v 599.505n 0.0v 609.495n 0.0v 609.505n 0.0v 619.495n 0.0v 619.505n 0.0v 629.495n 0.0v 629.505n 0.0v 639.495n 0.0v 639.505n 1.8v 649.495n 1.8v 649.505n 1.8v 659.495n 1.8v 659.505n 1.8v 669.495n 1.8v 669.505n 1.8v 679.495n 1.8v 679.505n 1.8v 689.495n 1.8v 689.505n 0.0v 699.495n 0.0v 699.505n 0.0v 709.495n 0.0v 709.505n 0.0v 719.495n 0.0v 719.505n 0.0v 729.495n 0.0v 729.505n 0.0v 739.495n 0.0v 739.505n 1.8v 749.495n 1.8v 749.505n 1.8v 759.495n 1.8v 759.505n 1.8v 769.495n 1.8v 769.505n 1.8v 779.495n 1.8v 779.505n 1.8v 789.495n 1.8v 789.505n 1.8v 799.495n 1.8v 799.505n 0.0v 809.495n 0.0v 809.505n 0.0v 819.495n 0.0v 819.505n 1.8v 829.495n 1.8v 829.505n 1.8v 839.495n 1.8v 839.505n 1.8v 849.495n 1.8v 849.505n 1.8v 859.495n 1.8v 859.505n 1.8v 869.495n 1.8v 869.505n 0.0v 879.495n 0.0v 879.505n 0.0v 889.495n 0.0v 889.505n 0.0v 899.495n 0.0v 899.505n 0.0v 909.495n 0.0v 909.505n 0.0v 919.495n 0.0v 919.505n 0.0v 929.495n 0.0v 929.505n 0.0v 939.495n 0.0v 939.505n 1.8v 949.495n 1.8v 949.505n 1.8v 959.495n 1.8v 959.505n 0.0v 969.495n 0.0v 969.505n 0.0v 979.495n 0.0v 979.505n 0.0v 989.495n 0.0v 989.505n 1.8v 999.495n 1.8v 999.505n 1.8v 1009.495n 1.8v 1009.505n 1.8v 1019.495n 1.8v 1019.505n 1.8v 1029.495n 1.8v 1029.505n 0.0v 1039.495n 0.0v 1039.505n 0.0v 1049.495n 0.0v 1049.505n 0.0v 1059.495n 0.0v 1059.505n 0.0v 1069.495n 0.0v 1069.505n 1.8v 1079.495n 1.8v 1079.505n 0.0v 1089.495n 0.0v 1089.505n 0.0v 1099.495n 0.0v 1099.505n 0.0v 1109.495n 0.0v 1109.505n 0.0v 1119.495n 0.0v 1119.505n 0.0v 1129.495n 0.0v 1129.505n 0.0v 1139.495n 0.0v 1139.505n 0.0v 1149.495n 0.0v 1149.505n 0.0v 1159.495n 0.0v 1159.505n 1.8v 1169.495n 1.8v 1169.505n 0.0v 1179.495n 0.0v 1179.505n 0.0v 1189.495n 0.0v 1189.505n 1.8v 1199.495n 1.8v 1199.505n 1.8v 1209.495n 1.8v 1209.505n 1.8v 1219.495n 1.8v 1219.505n 0.0v 1229.495n 0.0v 1229.505n 0.0v 1239.495n 0.0v 1239.505n 0.0v 1249.495n 0.0v 1249.505n 0.0v 1259.495n 0.0v 1259.505n 0.0v 1269.495n 0.0v 1269.505n 1.8v 1279.495n 1.8v 1279.505n 1.8v 1289.495n 1.8v 1289.505n 1.8v 1299.495n 1.8v 1299.505n 1.8v 1309.495n 1.8v 1309.505n 1.8v 1319.495n 1.8v 1319.505n 0.0v 1329.495n 0.0v 1329.505n 1.8v 1339.495n 1.8v 1339.505n 1.8v 1349.495n 1.8v 1349.505n 1.8v 1359.495n 1.8v 1359.505n 1.8v 1369.495n 1.8v 1369.505n 1.8v 1379.495n 1.8v 1379.505n 1.8v 1389.495n 1.8v 1389.505n 1.8v 1399.495n 1.8v 1399.505n 1.8v 1409.495n 1.8v 1409.505n 1.8v 1419.495n 1.8v 1419.505n 1.8v 1429.495n 1.8v 1429.505n 1.8v 1439.495n 1.8v 1439.505n 1.8v 1449.495n 1.8v 1449.505n 1.8v 1459.495n 1.8v 1459.505n 1.8v 1469.495n 1.8v 1469.505n 1.8v 1479.495n 1.8v 1479.505n 0.0v 1489.495n 0.0v 1489.505n 0.0v 1499.495n 0.0v 1499.505n 0.0v 1509.495n 0.0v 1509.505n 1.8v 1519.495n 1.8v 1519.505n 1.8v 1529.495n 1.8v 1529.505n 1.8v 1539.495n 1.8v 1539.505n 1.8v 1549.495n 1.8v 1549.505n 1.8v 1559.495n 1.8v 1559.505n 1.8v 1569.495n 1.8v 1569.505n 1.8v 1579.495n 1.8v 1579.505n 0.0v 1589.495n 0.0v 1589.505n 0.0v 1599.495n 0.0v 1599.505n 0.0v 1609.495n 0.0v 1609.505n 1.8v 1619.495n 1.8v 1619.505n 1.8v 1629.495n 1.8v 1629.505n 1.8v 1639.495n 1.8v 1639.505n 0.0v 1649.495n 0.0v 1649.505n 0.0v 1659.495n 0.0v 1659.505n 0.0v 1669.495n 0.0v 1669.505n 0.0v 1679.495n 0.0v 1679.505n 1.8v 1689.495n 1.8v 1689.505n 1.8v 1699.495n 1.8v 1699.505n 1.8v 1709.495n 1.8v 1709.505n 0.0v 1719.495n 0.0v 1719.505n 0.0v 1729.495n 0.0v 1729.505n 0.0v 1739.495n 0.0v 1739.505n 1.8v 1749.495n 1.8v 1749.505n 0.0v 1759.495n 0.0v 1759.505n 0.0v 1769.495n 0.0v 1769.505n 0.0v 1779.495n 0.0v 1779.505n 0.0v 1789.495n 0.0v 1789.505n 0.0v 1799.495n 0.0v 1799.505n 0.0v 1809.495n 0.0v 1809.505n 0.0v 1819.495n 0.0v 1819.505n 0.0v 1829.495n 0.0v 1829.505n 1.8v 1839.495n 1.8v 1839.505n 1.8v 1849.495n 1.8v 1849.505n 1.8v 1859.495n 1.8v 1859.505n 1.8v 1869.495n 1.8v 1869.505n 1.8v 1879.495n 1.8v 1879.505n 1.8v 1889.495n 1.8v 1889.505n 0.0v 1899.495n 0.0v 1899.505n 1.8v 1909.495n 1.8v 1909.505n 0.0v 1919.495n 0.0v 1919.505n 0.0v 1929.495n 0.0v 1929.505n 1.8v 1939.495n 1.8v 1939.505n 1.8v 1949.495n 1.8v 1949.505n 1.8v 1959.495n 1.8v 1959.505n 1.8v 1969.495n 1.8v 1969.505n 0.0v 1979.495n 0.0v 1979.505n 0.0v 1989.495n 0.0v 1989.505n 1.8v 1999.495n 1.8v 1999.505n 0.0v 2009.495n 0.0v 2009.505n 0.0v 2019.495n 0.0v 2019.505n 0.0v 2029.495n 0.0v 2029.505n 1.8v 2039.495n 1.8v 2039.505n 0.0v 2049.495n 0.0v 2049.505n 0.0v )
* (time, data): [(0, 0), (10, 0), (20, 0), (30, 0), (40, 1), (50, 0), (60, 0), (70, 0), (80, 0), (90, 0), (100, 0), (110, 0), (120, 0), (130, 0), (140, 0), (150, 0), (160, 0), (170, 0), (180, 0), (190, 0), (200, 0), (210, 0), (220, 0), (230, 0), (240, 0), (250, 1), (260, 1), (270, 1), (280, 0), (290, 0), (300, 1), (310, 1), (320, 1), (330, 1), (340, 1), (350, 1), (360, 0), (370, 1), (380, 1), (390, 1), (400, 0), (410, 1), (420, 1), (430, 1), (440, 1), (450, 1), (460, 1), (470, 1), (480, 1), (490, 1), (500, 1), (510, 1), (520, 1), (530, 1), (540, 0), (550, 0), (560, 0), (570, 0), (580, 0), (590, 0), (600, 0), (610, 0), (620, 0), (630, 0), (640, 1), (650, 1), (660, 1), (670, 1), (680, 1), (690, 0), (700, 0), (710, 0), (720, 0), (730, 0), (740, 1), (750, 1), (760, 1), (770, 1), (780, 1), (790, 1), (800, 0), (810, 0), (820, 1), (830, 1), (840, 1), (850, 1), (860, 1), (870, 0), (880, 0), (890, 0), (900, 0), (910, 0), (920, 0), (930, 0), (940, 1), (950, 1), (960, 0), (970, 0), (980, 0), (990, 1), (1000, 1), (1010, 1), (1020, 1), (1030, 0), (1040, 0), (1050, 0), (1060, 0), (1070, 1), (1080, 0), (1090, 0), (1100, 0), (1110, 0), (1120, 0), (1130, 0), (1140, 0), (1150, 0), (1160, 1), (1170, 0), (1180, 0), (1190, 1), (1200, 1), (1210, 1), (1220, 0), (1230, 0), (1240, 0), (1250, 0), (1260, 0), (1270, 1), (1280, 1), (1290, 1), (1300, 1), (1310, 1), (1320, 0), (1330, 1), (1340, 1), (1350, 1), (1360, 1), (1370, 1), (1380, 1), (1390, 1), (1400, 1), (1410, 1), (1420, 1), (1430, 1), (1440, 1), (1450, 1), (1460, 1), (1470, 1), (1480, 0), (1490, 0), (1500, 0), (1510, 1), (1520, 1), (1530, 1), (1540, 1), (1550, 1), (1560, 1), (1570, 1), (1580, 0), (1590, 0), (1600, 0), (1610, 1), (1620, 1), (1630, 1), (1640, 0), (1650, 0), (1660, 0), (1670, 0), (1680, 1), (1690, 1), (1700, 1), (1710, 0), (1720, 0), (1730, 0), (1740, 1), (1750, 0), (1760, 0), (1770, 0), (1780, 0), (1790, 0), (1800, 0), (1810, 0), (1820, 0), (1830, 1), (1840, 1), (1850, 1), (1860, 1), (1870, 1), (1880, 1), (1890, 0), (1900, 1), (1910, 0), (1920, 0), (1930, 1), (1940, 1), (1950, 1), (1960, 1), (1970, 0), (1980, 0), (1990, 1), (2000, 0), (2010, 0), (2020, 0), (2030, 1), (2040, 0), (2050, 0)]
Va1_4  a1_4  0 PWL (0n 0.0v 9.495n 0.0v 9.505n 0.0v 19.495n 0.0v 19.505n 0.0v 29.495n 0.0v 29.505n 0.0v 39.495n 0.0v 39.505n 1.8v 49.495n 1.8v 49.505n 0.0v 59.495n 0.0v 59.505n 0.0v 69.495n 0.0v 69.505n 0.0v 79.495n 0.0v 79.505n 0.0v 89.495n 0.0v 89.505n 0.0v 99.495n 0.0v 99.505n 0.0v 109.495n 0.0v 109.505n 0.0v 119.495n 0.0v 119.505n 0.0v 129.495n 0.0v 129.505n 0.0v 139.495n 0.0v 139.505n 0.0v 149.495n 0.0v 149.505n 0.0v 159.495n 0.0v 159.505n 0.0v 169.495n 0.0v 169.505n 0.0v 179.495n 0.0v 179.505n 0.0v 189.495n 0.0v 189.505n 0.0v 199.495n 0.0v 199.505n 0.0v 209.495n 0.0v 209.505n 0.0v 219.495n 0.0v 219.505n 0.0v 229.495n 0.0v 229.505n 0.0v 239.495n 0.0v 239.505n 0.0v 249.495n 0.0v 249.505n 1.8v 259.495n 1.8v 259.505n 1.8v 269.495n 1.8v 269.505n 1.8v 279.495n 1.8v 279.505n 0.0v 289.495n 0.0v 289.505n 0.0v 299.495n 0.0v 299.505n 1.8v 309.495n 1.8v 309.505n 1.8v 319.495n 1.8v 319.505n 1.8v 329.495n 1.8v 329.505n 1.8v 339.495n 1.8v 339.505n 1.8v 349.495n 1.8v 349.505n 1.8v 359.495n 1.8v 359.505n 0.0v 369.495n 0.0v 369.505n 1.8v 379.495n 1.8v 379.505n 1.8v 389.495n 1.8v 389.505n 1.8v 399.495n 1.8v 399.505n 0.0v 409.495n 0.0v 409.505n 1.8v 419.495n 1.8v 419.505n 1.8v 429.495n 1.8v 429.505n 1.8v 439.495n 1.8v 439.505n 1.8v 449.495n 1.8v 449.505n 1.8v 459.495n 1.8v 459.505n 1.8v 469.495n 1.8v 469.505n 1.8v 479.495n 1.8v 479.505n 1.8v 489.495n 1.8v 489.505n 1.8v 499.495n 1.8v 499.505n 1.8v 509.495n 1.8v 509.505n 1.8v 519.495n 1.8v 519.505n 1.8v 529.495n 1.8v 529.505n 1.8v 539.495n 1.8v 539.505n 0.0v 549.495n 0.0v 549.505n 0.0v 559.495n 0.0v 559.505n 0.0v 569.495n 0.0v 569.505n 0.0v 579.495n 0.0v 579.505n 0.0v 589.495n 0.0v 589.505n 0.0v 599.495n 0.0v 599.505n 0.0v 609.495n 0.0v 609.505n 0.0v 619.495n 0.0v 619.505n 0.0v 629.495n 0.0v 629.505n 0.0v 639.495n 0.0v 639.505n 1.8v 649.495n 1.8v 649.505n 1.8v 659.495n 1.8v 659.505n 1.8v 669.495n 1.8v 669.505n 1.8v 679.495n 1.8v 679.505n 1.8v 689.495n 1.8v 689.505n 0.0v 699.495n 0.0v 699.505n 0.0v 709.495n 0.0v 709.505n 0.0v 719.495n 0.0v 719.505n 0.0v 729.495n 0.0v 729.505n 0.0v 739.495n 0.0v 739.505n 1.8v 749.495n 1.8v 749.505n 1.8v 759.495n 1.8v 759.505n 1.8v 769.495n 1.8v 769.505n 1.8v 779.495n 1.8v 779.505n 1.8v 789.495n 1.8v 789.505n 1.8v 799.495n 1.8v 799.505n 0.0v 809.495n 0.0v 809.505n 0.0v 819.495n 0.0v 819.505n 1.8v 829.495n 1.8v 829.505n 1.8v 839.495n 1.8v 839.505n 1.8v 849.495n 1.8v 849.505n 1.8v 859.495n 1.8v 859.505n 1.8v 869.495n 1.8v 869.505n 0.0v 879.495n 0.0v 879.505n 0.0v 889.495n 0.0v 889.505n 0.0v 899.495n 0.0v 899.505n 0.0v 909.495n 0.0v 909.505n 0.0v 919.495n 0.0v 919.505n 0.0v 929.495n 0.0v 929.505n 0.0v 939.495n 0.0v 939.505n 1.8v 949.495n 1.8v 949.505n 1.8v 959.495n 1.8v 959.505n 0.0v 969.495n 0.0v 969.505n 0.0v 979.495n 0.0v 979.505n 0.0v 989.495n 0.0v 989.505n 1.8v 999.495n 1.8v 999.505n 1.8v 1009.495n 1.8v 1009.505n 1.8v 1019.495n 1.8v 1019.505n 1.8v 1029.495n 1.8v 1029.505n 0.0v 1039.495n 0.0v 1039.505n 0.0v 1049.495n 0.0v 1049.505n 0.0v 1059.495n 0.0v 1059.505n 0.0v 1069.495n 0.0v 1069.505n 1.8v 1079.495n 1.8v 1079.505n 0.0v 1089.495n 0.0v 1089.505n 0.0v 1099.495n 0.0v 1099.505n 0.0v 1109.495n 0.0v 1109.505n 0.0v 1119.495n 0.0v 1119.505n 0.0v 1129.495n 0.0v 1129.505n 0.0v 1139.495n 0.0v 1139.505n 0.0v 1149.495n 0.0v 1149.505n 0.0v 1159.495n 0.0v 1159.505n 1.8v 1169.495n 1.8v 1169.505n 0.0v 1179.495n 0.0v 1179.505n 0.0v 1189.495n 0.0v 1189.505n 1.8v 1199.495n 1.8v 1199.505n 1.8v 1209.495n 1.8v 1209.505n 1.8v 1219.495n 1.8v 1219.505n 0.0v 1229.495n 0.0v 1229.505n 0.0v 1239.495n 0.0v 1239.505n 0.0v 1249.495n 0.0v 1249.505n 0.0v 1259.495n 0.0v 1259.505n 0.0v 1269.495n 0.0v 1269.505n 1.8v 1279.495n 1.8v 1279.505n 1.8v 1289.495n 1.8v 1289.505n 1.8v 1299.495n 1.8v 1299.505n 1.8v 1309.495n 1.8v 1309.505n 1.8v 1319.495n 1.8v 1319.505n 0.0v 1329.495n 0.0v 1329.505n 1.8v 1339.495n 1.8v 1339.505n 1.8v 1349.495n 1.8v 1349.505n 1.8v 1359.495n 1.8v 1359.505n 1.8v 1369.495n 1.8v 1369.505n 1.8v 1379.495n 1.8v 1379.505n 1.8v 1389.495n 1.8v 1389.505n 1.8v 1399.495n 1.8v 1399.505n 1.8v 1409.495n 1.8v 1409.505n 1.8v 1419.495n 1.8v 1419.505n 1.8v 1429.495n 1.8v 1429.505n 1.8v 1439.495n 1.8v 1439.505n 1.8v 1449.495n 1.8v 1449.505n 1.8v 1459.495n 1.8v 1459.505n 1.8v 1469.495n 1.8v 1469.505n 1.8v 1479.495n 1.8v 1479.505n 0.0v 1489.495n 0.0v 1489.505n 0.0v 1499.495n 0.0v 1499.505n 0.0v 1509.495n 0.0v 1509.505n 1.8v 1519.495n 1.8v 1519.505n 1.8v 1529.495n 1.8v 1529.505n 1.8v 1539.495n 1.8v 1539.505n 1.8v 1549.495n 1.8v 1549.505n 1.8v 1559.495n 1.8v 1559.505n 1.8v 1569.495n 1.8v 1569.505n 1.8v 1579.495n 1.8v 1579.505n 0.0v 1589.495n 0.0v 1589.505n 0.0v 1599.495n 0.0v 1599.505n 0.0v 1609.495n 0.0v 1609.505n 1.8v 1619.495n 1.8v 1619.505n 1.8v 1629.495n 1.8v 1629.505n 1.8v 1639.495n 1.8v 1639.505n 0.0v 1649.495n 0.0v 1649.505n 0.0v 1659.495n 0.0v 1659.505n 0.0v 1669.495n 0.0v 1669.505n 0.0v 1679.495n 0.0v 1679.505n 1.8v 1689.495n 1.8v 1689.505n 1.8v 1699.495n 1.8v 1699.505n 1.8v 1709.495n 1.8v 1709.505n 0.0v 1719.495n 0.0v 1719.505n 0.0v 1729.495n 0.0v 1729.505n 0.0v 1739.495n 0.0v 1739.505n 1.8v 1749.495n 1.8v 1749.505n 0.0v 1759.495n 0.0v 1759.505n 0.0v 1769.495n 0.0v 1769.505n 0.0v 1779.495n 0.0v 1779.505n 0.0v 1789.495n 0.0v 1789.505n 0.0v 1799.495n 0.0v 1799.505n 0.0v 1809.495n 0.0v 1809.505n 0.0v 1819.495n 0.0v 1819.505n 0.0v 1829.495n 0.0v 1829.505n 1.8v 1839.495n 1.8v 1839.505n 1.8v 1849.495n 1.8v 1849.505n 1.8v 1859.495n 1.8v 1859.505n 1.8v 1869.495n 1.8v 1869.505n 1.8v 1879.495n 1.8v 1879.505n 1.8v 1889.495n 1.8v 1889.505n 0.0v 1899.495n 0.0v 1899.505n 1.8v 1909.495n 1.8v 1909.505n 0.0v 1919.495n 0.0v 1919.505n 0.0v 1929.495n 0.0v 1929.505n 1.8v 1939.495n 1.8v 1939.505n 1.8v 1949.495n 1.8v 1949.505n 1.8v 1959.495n 1.8v 1959.505n 1.8v 1969.495n 1.8v 1969.505n 0.0v 1979.495n 0.0v 1979.505n 0.0v 1989.495n 0.0v 1989.505n 1.8v 1999.495n 1.8v 1999.505n 0.0v 2009.495n 0.0v 2009.505n 0.0v 2019.495n 0.0v 2019.505n 0.0v 2029.495n 0.0v 2029.505n 1.8v 2039.495n 1.8v 2039.505n 0.0v 2049.495n 0.0v 2049.505n 0.0v )
* (time, data): [(0, 0), (10, 0), (20, 0), (30, 0), (40, 1), (50, 0), (60, 0), (70, 0), (80, 0), (90, 0), (100, 0), (110, 0), (120, 0), (130, 0), (140, 0), (150, 0), (160, 0), (170, 0), (180, 0), (190, 0), (200, 0), (210, 0), (220, 0), (230, 0), (240, 0), (250, 1), (260, 1), (270, 1), (280, 0), (290, 0), (300, 1), (310, 1), (320, 1), (330, 1), (340, 1), (350, 1), (360, 0), (370, 1), (380, 1), (390, 1), (400, 0), (410, 1), (420, 1), (430, 1), (440, 1), (450, 1), (460, 1), (470, 1), (480, 1), (490, 1), (500, 1), (510, 1), (520, 1), (530, 1), (540, 0), (550, 0), (560, 0), (570, 0), (580, 0), (590, 0), (600, 0), (610, 0), (620, 0), (630, 0), (640, 1), (650, 1), (660, 1), (670, 1), (680, 1), (690, 0), (700, 0), (710, 0), (720, 0), (730, 0), (740, 1), (750, 1), (760, 1), (770, 1), (780, 1), (790, 1), (800, 0), (810, 0), (820, 1), (830, 1), (840, 1), (850, 1), (860, 1), (870, 0), (880, 0), (890, 0), (900, 0), (910, 0), (920, 0), (930, 0), (940, 1), (950, 1), (960, 0), (970, 0), (980, 0), (990, 1), (1000, 1), (1010, 1), (1020, 1), (1030, 0), (1040, 0), (1050, 0), (1060, 0), (1070, 1), (1080, 0), (1090, 0), (1100, 0), (1110, 0), (1120, 0), (1130, 0), (1140, 0), (1150, 0), (1160, 1), (1170, 0), (1180, 0), (1190, 1), (1200, 1), (1210, 1), (1220, 0), (1230, 0), (1240, 0), (1250, 0), (1260, 0), (1270, 1), (1280, 1), (1290, 1), (1300, 1), (1310, 1), (1320, 0), (1330, 1), (1340, 1), (1350, 1), (1360, 1), (1370, 1), (1380, 1), (1390, 1), (1400, 1), (1410, 1), (1420, 1), (1430, 1), (1440, 1), (1450, 1), (1460, 1), (1470, 1), (1480, 0), (1490, 0), (1500, 0), (1510, 1), (1520, 1), (1530, 1), (1540, 1), (1550, 1), (1560, 1), (1570, 1), (1580, 0), (1590, 0), (1600, 0), (1610, 1), (1620, 1), (1630, 1), (1640, 0), (1650, 0), (1660, 0), (1670, 0), (1680, 1), (1690, 1), (1700, 1), (1710, 0), (1720, 0), (1730, 0), (1740, 1), (1750, 0), (1760, 0), (1770, 0), (1780, 0), (1790, 0), (1800, 0), (1810, 0), (1820, 0), (1830, 1), (1840, 1), (1850, 1), (1860, 1), (1870, 1), (1880, 1), (1890, 0), (1900, 1), (1910, 0), (1920, 0), (1930, 1), (1940, 1), (1950, 1), (1960, 1), (1970, 0), (1980, 0), (1990, 1), (2000, 0), (2010, 0), (2020, 0), (2030, 1), (2040, 0), (2050, 0)]
Va1_5  a1_5  0 PWL (0n 0.0v 9.495n 0.0v 9.505n 0.0v 19.495n 0.0v 19.505n 0.0v 29.495n 0.0v 29.505n 0.0v 39.495n 0.0v 39.505n 1.8v 49.495n 1.8v 49.505n 0.0v 59.495n 0.0v 59.505n 0.0v 69.495n 0.0v 69.505n 0.0v 79.495n 0.0v 79.505n 0.0v 89.495n 0.0v 89.505n 0.0v 99.495n 0.0v 99.505n 0.0v 109.495n 0.0v 109.505n 0.0v 119.495n 0.0v 119.505n 0.0v 129.495n 0.0v 129.505n 0.0v 139.495n 0.0v 139.505n 0.0v 149.495n 0.0v 149.505n 0.0v 159.495n 0.0v 159.505n 0.0v 169.495n 0.0v 169.505n 0.0v 179.495n 0.0v 179.505n 0.0v 189.495n 0.0v 189.505n 0.0v 199.495n 0.0v 199.505n 0.0v 209.495n 0.0v 209.505n 0.0v 219.495n 0.0v 219.505n 0.0v 229.495n 0.0v 229.505n 0.0v 239.495n 0.0v 239.505n 0.0v 249.495n 0.0v 249.505n 1.8v 259.495n 1.8v 259.505n 1.8v 269.495n 1.8v 269.505n 1.8v 279.495n 1.8v 279.505n 0.0v 289.495n 0.0v 289.505n 0.0v 299.495n 0.0v 299.505n 1.8v 309.495n 1.8v 309.505n 1.8v 319.495n 1.8v 319.505n 1.8v 329.495n 1.8v 329.505n 1.8v 339.495n 1.8v 339.505n 1.8v 349.495n 1.8v 349.505n 1.8v 359.495n 1.8v 359.505n 0.0v 369.495n 0.0v 369.505n 1.8v 379.495n 1.8v 379.505n 1.8v 389.495n 1.8v 389.505n 1.8v 399.495n 1.8v 399.505n 0.0v 409.495n 0.0v 409.505n 1.8v 419.495n 1.8v 419.505n 1.8v 429.495n 1.8v 429.505n 1.8v 439.495n 1.8v 439.505n 1.8v 449.495n 1.8v 449.505n 1.8v 459.495n 1.8v 459.505n 1.8v 469.495n 1.8v 469.505n 1.8v 479.495n 1.8v 479.505n 1.8v 489.495n 1.8v 489.505n 1.8v 499.495n 1.8v 499.505n 1.8v 509.495n 1.8v 509.505n 1.8v 519.495n 1.8v 519.505n 1.8v 529.495n 1.8v 529.505n 1.8v 539.495n 1.8v 539.505n 0.0v 549.495n 0.0v 549.505n 0.0v 559.495n 0.0v 559.505n 0.0v 569.495n 0.0v 569.505n 0.0v 579.495n 0.0v 579.505n 0.0v 589.495n 0.0v 589.505n 0.0v 599.495n 0.0v 599.505n 0.0v 609.495n 0.0v 609.505n 0.0v 619.495n 0.0v 619.505n 0.0v 629.495n 0.0v 629.505n 0.0v 639.495n 0.0v 639.505n 1.8v 649.495n 1.8v 649.505n 1.8v 659.495n 1.8v 659.505n 1.8v 669.495n 1.8v 669.505n 1.8v 679.495n 1.8v 679.505n 1.8v 689.495n 1.8v 689.505n 0.0v 699.495n 0.0v 699.505n 0.0v 709.495n 0.0v 709.505n 0.0v 719.495n 0.0v 719.505n 0.0v 729.495n 0.0v 729.505n 0.0v 739.495n 0.0v 739.505n 1.8v 749.495n 1.8v 749.505n 1.8v 759.495n 1.8v 759.505n 1.8v 769.495n 1.8v 769.505n 1.8v 779.495n 1.8v 779.505n 1.8v 789.495n 1.8v 789.505n 1.8v 799.495n 1.8v 799.505n 0.0v 809.495n 0.0v 809.505n 0.0v 819.495n 0.0v 819.505n 1.8v 829.495n 1.8v 829.505n 1.8v 839.495n 1.8v 839.505n 1.8v 849.495n 1.8v 849.505n 1.8v 859.495n 1.8v 859.505n 1.8v 869.495n 1.8v 869.505n 0.0v 879.495n 0.0v 879.505n 0.0v 889.495n 0.0v 889.505n 0.0v 899.495n 0.0v 899.505n 0.0v 909.495n 0.0v 909.505n 0.0v 919.495n 0.0v 919.505n 0.0v 929.495n 0.0v 929.505n 0.0v 939.495n 0.0v 939.505n 1.8v 949.495n 1.8v 949.505n 1.8v 959.495n 1.8v 959.505n 0.0v 969.495n 0.0v 969.505n 0.0v 979.495n 0.0v 979.505n 0.0v 989.495n 0.0v 989.505n 1.8v 999.495n 1.8v 999.505n 1.8v 1009.495n 1.8v 1009.505n 1.8v 1019.495n 1.8v 1019.505n 1.8v 1029.495n 1.8v 1029.505n 0.0v 1039.495n 0.0v 1039.505n 0.0v 1049.495n 0.0v 1049.505n 0.0v 1059.495n 0.0v 1059.505n 0.0v 1069.495n 0.0v 1069.505n 1.8v 1079.495n 1.8v 1079.505n 0.0v 1089.495n 0.0v 1089.505n 0.0v 1099.495n 0.0v 1099.505n 0.0v 1109.495n 0.0v 1109.505n 0.0v 1119.495n 0.0v 1119.505n 0.0v 1129.495n 0.0v 1129.505n 0.0v 1139.495n 0.0v 1139.505n 0.0v 1149.495n 0.0v 1149.505n 0.0v 1159.495n 0.0v 1159.505n 1.8v 1169.495n 1.8v 1169.505n 0.0v 1179.495n 0.0v 1179.505n 0.0v 1189.495n 0.0v 1189.505n 1.8v 1199.495n 1.8v 1199.505n 1.8v 1209.495n 1.8v 1209.505n 1.8v 1219.495n 1.8v 1219.505n 0.0v 1229.495n 0.0v 1229.505n 0.0v 1239.495n 0.0v 1239.505n 0.0v 1249.495n 0.0v 1249.505n 0.0v 1259.495n 0.0v 1259.505n 0.0v 1269.495n 0.0v 1269.505n 1.8v 1279.495n 1.8v 1279.505n 1.8v 1289.495n 1.8v 1289.505n 1.8v 1299.495n 1.8v 1299.505n 1.8v 1309.495n 1.8v 1309.505n 1.8v 1319.495n 1.8v 1319.505n 0.0v 1329.495n 0.0v 1329.505n 1.8v 1339.495n 1.8v 1339.505n 1.8v 1349.495n 1.8v 1349.505n 1.8v 1359.495n 1.8v 1359.505n 1.8v 1369.495n 1.8v 1369.505n 1.8v 1379.495n 1.8v 1379.505n 1.8v 1389.495n 1.8v 1389.505n 1.8v 1399.495n 1.8v 1399.505n 1.8v 1409.495n 1.8v 1409.505n 1.8v 1419.495n 1.8v 1419.505n 1.8v 1429.495n 1.8v 1429.505n 1.8v 1439.495n 1.8v 1439.505n 1.8v 1449.495n 1.8v 1449.505n 1.8v 1459.495n 1.8v 1459.505n 1.8v 1469.495n 1.8v 1469.505n 1.8v 1479.495n 1.8v 1479.505n 0.0v 1489.495n 0.0v 1489.505n 0.0v 1499.495n 0.0v 1499.505n 0.0v 1509.495n 0.0v 1509.505n 1.8v 1519.495n 1.8v 1519.505n 1.8v 1529.495n 1.8v 1529.505n 1.8v 1539.495n 1.8v 1539.505n 1.8v 1549.495n 1.8v 1549.505n 1.8v 1559.495n 1.8v 1559.505n 1.8v 1569.495n 1.8v 1569.505n 1.8v 1579.495n 1.8v 1579.505n 0.0v 1589.495n 0.0v 1589.505n 0.0v 1599.495n 0.0v 1599.505n 0.0v 1609.495n 0.0v 1609.505n 1.8v 1619.495n 1.8v 1619.505n 1.8v 1629.495n 1.8v 1629.505n 1.8v 1639.495n 1.8v 1639.505n 0.0v 1649.495n 0.0v 1649.505n 0.0v 1659.495n 0.0v 1659.505n 0.0v 1669.495n 0.0v 1669.505n 0.0v 1679.495n 0.0v 1679.505n 1.8v 1689.495n 1.8v 1689.505n 1.8v 1699.495n 1.8v 1699.505n 1.8v 1709.495n 1.8v 1709.505n 0.0v 1719.495n 0.0v 1719.505n 0.0v 1729.495n 0.0v 1729.505n 0.0v 1739.495n 0.0v 1739.505n 1.8v 1749.495n 1.8v 1749.505n 0.0v 1759.495n 0.0v 1759.505n 0.0v 1769.495n 0.0v 1769.505n 0.0v 1779.495n 0.0v 1779.505n 0.0v 1789.495n 0.0v 1789.505n 0.0v 1799.495n 0.0v 1799.505n 0.0v 1809.495n 0.0v 1809.505n 0.0v 1819.495n 0.0v 1819.505n 0.0v 1829.495n 0.0v 1829.505n 1.8v 1839.495n 1.8v 1839.505n 1.8v 1849.495n 1.8v 1849.505n 1.8v 1859.495n 1.8v 1859.505n 1.8v 1869.495n 1.8v 1869.505n 1.8v 1879.495n 1.8v 1879.505n 1.8v 1889.495n 1.8v 1889.505n 0.0v 1899.495n 0.0v 1899.505n 1.8v 1909.495n 1.8v 1909.505n 0.0v 1919.495n 0.0v 1919.505n 0.0v 1929.495n 0.0v 1929.505n 1.8v 1939.495n 1.8v 1939.505n 1.8v 1949.495n 1.8v 1949.505n 1.8v 1959.495n 1.8v 1959.505n 1.8v 1969.495n 1.8v 1969.505n 0.0v 1979.495n 0.0v 1979.505n 0.0v 1989.495n 0.0v 1989.505n 1.8v 1999.495n 1.8v 1999.505n 0.0v 2009.495n 0.0v 2009.505n 0.0v 2019.495n 0.0v 2019.505n 0.0v 2029.495n 0.0v 2029.505n 1.8v 2039.495n 1.8v 2039.505n 0.0v 2049.495n 0.0v 2049.505n 0.0v )
* (time, data): [(0, 0), (10, 0), (20, 0), (30, 0), (40, 1), (50, 0), (60, 0), (70, 0), (80, 0), (90, 0), (100, 0), (110, 0), (120, 0), (130, 0), (140, 0), (150, 0), (160, 0), (170, 0), (180, 0), (190, 0), (200, 0), (210, 0), (220, 0), (230, 0), (240, 0), (250, 1), (260, 1), (270, 1), (280, 0), (290, 0), (300, 1), (310, 1), (320, 1), (330, 1), (340, 1), (350, 1), (360, 0), (370, 1), (380, 1), (390, 1), (400, 0), (410, 1), (420, 1), (430, 1), (440, 1), (450, 1), (460, 1), (470, 1), (480, 1), (490, 1), (500, 1), (510, 1), (520, 1), (530, 1), (540, 0), (550, 0), (560, 0), (570, 0), (580, 0), (590, 0), (600, 0), (610, 0), (620, 0), (630, 0), (640, 1), (650, 1), (660, 1), (670, 1), (680, 1), (690, 0), (700, 0), (710, 0), (720, 0), (730, 0), (740, 1), (750, 1), (760, 1), (770, 1), (780, 1), (790, 1), (800, 0), (810, 0), (820, 1), (830, 1), (840, 1), (850, 1), (860, 1), (870, 0), (880, 0), (890, 0), (900, 0), (910, 0), (920, 0), (930, 0), (940, 1), (950, 1), (960, 0), (970, 0), (980, 0), (990, 1), (1000, 1), (1010, 1), (1020, 1), (1030, 0), (1040, 0), (1050, 0), (1060, 0), (1070, 1), (1080, 0), (1090, 0), (1100, 0), (1110, 0), (1120, 0), (1130, 0), (1140, 0), (1150, 0), (1160, 1), (1170, 0), (1180, 0), (1190, 1), (1200, 1), (1210, 1), (1220, 0), (1230, 0), (1240, 0), (1250, 0), (1260, 0), (1270, 1), (1280, 1), (1290, 1), (1300, 1), (1310, 1), (1320, 0), (1330, 1), (1340, 1), (1350, 1), (1360, 1), (1370, 1), (1380, 1), (1390, 1), (1400, 1), (1410, 1), (1420, 1), (1430, 1), (1440, 1), (1450, 1), (1460, 1), (1470, 1), (1480, 0), (1490, 0), (1500, 0), (1510, 1), (1520, 1), (1530, 1), (1540, 1), (1550, 1), (1560, 1), (1570, 1), (1580, 0), (1590, 0), (1600, 0), (1610, 1), (1620, 1), (1630, 1), (1640, 0), (1650, 0), (1660, 0), (1670, 0), (1680, 1), (1690, 1), (1700, 1), (1710, 0), (1720, 0), (1730, 0), (1740, 1), (1750, 0), (1760, 0), (1770, 0), (1780, 0), (1790, 0), (1800, 0), (1810, 0), (1820, 0), (1830, 1), (1840, 1), (1850, 1), (1860, 1), (1870, 1), (1880, 1), (1890, 0), (1900, 1), (1910, 0), (1920, 0), (1930, 1), (1940, 1), (1950, 1), (1960, 1), (1970, 0), (1980, 0), (1990, 1), (2000, 0), (2010, 0), (2020, 0), (2030, 1), (2040, 0), (2050, 0)]
Va1_6  a1_6  0 PWL (0n 0.0v 9.495n 0.0v 9.505n 0.0v 19.495n 0.0v 19.505n 0.0v 29.495n 0.0v 29.505n 0.0v 39.495n 0.0v 39.505n 1.8v 49.495n 1.8v 49.505n 0.0v 59.495n 0.0v 59.505n 0.0v 69.495n 0.0v 69.505n 0.0v 79.495n 0.0v 79.505n 0.0v 89.495n 0.0v 89.505n 0.0v 99.495n 0.0v 99.505n 0.0v 109.495n 0.0v 109.505n 0.0v 119.495n 0.0v 119.505n 0.0v 129.495n 0.0v 129.505n 0.0v 139.495n 0.0v 139.505n 0.0v 149.495n 0.0v 149.505n 0.0v 159.495n 0.0v 159.505n 0.0v 169.495n 0.0v 169.505n 0.0v 179.495n 0.0v 179.505n 0.0v 189.495n 0.0v 189.505n 0.0v 199.495n 0.0v 199.505n 0.0v 209.495n 0.0v 209.505n 0.0v 219.495n 0.0v 219.505n 0.0v 229.495n 0.0v 229.505n 0.0v 239.495n 0.0v 239.505n 0.0v 249.495n 0.0v 249.505n 1.8v 259.495n 1.8v 259.505n 1.8v 269.495n 1.8v 269.505n 1.8v 279.495n 1.8v 279.505n 0.0v 289.495n 0.0v 289.505n 0.0v 299.495n 0.0v 299.505n 1.8v 309.495n 1.8v 309.505n 1.8v 319.495n 1.8v 319.505n 1.8v 329.495n 1.8v 329.505n 1.8v 339.495n 1.8v 339.505n 1.8v 349.495n 1.8v 349.505n 1.8v 359.495n 1.8v 359.505n 0.0v 369.495n 0.0v 369.505n 1.8v 379.495n 1.8v 379.505n 1.8v 389.495n 1.8v 389.505n 1.8v 399.495n 1.8v 399.505n 0.0v 409.495n 0.0v 409.505n 1.8v 419.495n 1.8v 419.505n 1.8v 429.495n 1.8v 429.505n 1.8v 439.495n 1.8v 439.505n 1.8v 449.495n 1.8v 449.505n 1.8v 459.495n 1.8v 459.505n 1.8v 469.495n 1.8v 469.505n 1.8v 479.495n 1.8v 479.505n 1.8v 489.495n 1.8v 489.505n 1.8v 499.495n 1.8v 499.505n 1.8v 509.495n 1.8v 509.505n 1.8v 519.495n 1.8v 519.505n 1.8v 529.495n 1.8v 529.505n 1.8v 539.495n 1.8v 539.505n 0.0v 549.495n 0.0v 549.505n 0.0v 559.495n 0.0v 559.505n 0.0v 569.495n 0.0v 569.505n 0.0v 579.495n 0.0v 579.505n 0.0v 589.495n 0.0v 589.505n 0.0v 599.495n 0.0v 599.505n 0.0v 609.495n 0.0v 609.505n 0.0v 619.495n 0.0v 619.505n 0.0v 629.495n 0.0v 629.505n 0.0v 639.495n 0.0v 639.505n 1.8v 649.495n 1.8v 649.505n 1.8v 659.495n 1.8v 659.505n 1.8v 669.495n 1.8v 669.505n 1.8v 679.495n 1.8v 679.505n 1.8v 689.495n 1.8v 689.505n 0.0v 699.495n 0.0v 699.505n 0.0v 709.495n 0.0v 709.505n 0.0v 719.495n 0.0v 719.505n 0.0v 729.495n 0.0v 729.505n 0.0v 739.495n 0.0v 739.505n 1.8v 749.495n 1.8v 749.505n 1.8v 759.495n 1.8v 759.505n 1.8v 769.495n 1.8v 769.505n 1.8v 779.495n 1.8v 779.505n 1.8v 789.495n 1.8v 789.505n 1.8v 799.495n 1.8v 799.505n 0.0v 809.495n 0.0v 809.505n 0.0v 819.495n 0.0v 819.505n 1.8v 829.495n 1.8v 829.505n 1.8v 839.495n 1.8v 839.505n 1.8v 849.495n 1.8v 849.505n 1.8v 859.495n 1.8v 859.505n 1.8v 869.495n 1.8v 869.505n 0.0v 879.495n 0.0v 879.505n 0.0v 889.495n 0.0v 889.505n 0.0v 899.495n 0.0v 899.505n 0.0v 909.495n 0.0v 909.505n 0.0v 919.495n 0.0v 919.505n 0.0v 929.495n 0.0v 929.505n 0.0v 939.495n 0.0v 939.505n 1.8v 949.495n 1.8v 949.505n 1.8v 959.495n 1.8v 959.505n 0.0v 969.495n 0.0v 969.505n 0.0v 979.495n 0.0v 979.505n 0.0v 989.495n 0.0v 989.505n 1.8v 999.495n 1.8v 999.505n 1.8v 1009.495n 1.8v 1009.505n 1.8v 1019.495n 1.8v 1019.505n 1.8v 1029.495n 1.8v 1029.505n 0.0v 1039.495n 0.0v 1039.505n 0.0v 1049.495n 0.0v 1049.505n 0.0v 1059.495n 0.0v 1059.505n 0.0v 1069.495n 0.0v 1069.505n 1.8v 1079.495n 1.8v 1079.505n 0.0v 1089.495n 0.0v 1089.505n 0.0v 1099.495n 0.0v 1099.505n 0.0v 1109.495n 0.0v 1109.505n 0.0v 1119.495n 0.0v 1119.505n 0.0v 1129.495n 0.0v 1129.505n 0.0v 1139.495n 0.0v 1139.505n 0.0v 1149.495n 0.0v 1149.505n 0.0v 1159.495n 0.0v 1159.505n 1.8v 1169.495n 1.8v 1169.505n 0.0v 1179.495n 0.0v 1179.505n 0.0v 1189.495n 0.0v 1189.505n 1.8v 1199.495n 1.8v 1199.505n 1.8v 1209.495n 1.8v 1209.505n 1.8v 1219.495n 1.8v 1219.505n 0.0v 1229.495n 0.0v 1229.505n 0.0v 1239.495n 0.0v 1239.505n 0.0v 1249.495n 0.0v 1249.505n 0.0v 1259.495n 0.0v 1259.505n 0.0v 1269.495n 0.0v 1269.505n 1.8v 1279.495n 1.8v 1279.505n 1.8v 1289.495n 1.8v 1289.505n 1.8v 1299.495n 1.8v 1299.505n 1.8v 1309.495n 1.8v 1309.505n 1.8v 1319.495n 1.8v 1319.505n 0.0v 1329.495n 0.0v 1329.505n 1.8v 1339.495n 1.8v 1339.505n 1.8v 1349.495n 1.8v 1349.505n 1.8v 1359.495n 1.8v 1359.505n 1.8v 1369.495n 1.8v 1369.505n 1.8v 1379.495n 1.8v 1379.505n 1.8v 1389.495n 1.8v 1389.505n 1.8v 1399.495n 1.8v 1399.505n 1.8v 1409.495n 1.8v 1409.505n 1.8v 1419.495n 1.8v 1419.505n 1.8v 1429.495n 1.8v 1429.505n 1.8v 1439.495n 1.8v 1439.505n 1.8v 1449.495n 1.8v 1449.505n 1.8v 1459.495n 1.8v 1459.505n 1.8v 1469.495n 1.8v 1469.505n 1.8v 1479.495n 1.8v 1479.505n 0.0v 1489.495n 0.0v 1489.505n 0.0v 1499.495n 0.0v 1499.505n 0.0v 1509.495n 0.0v 1509.505n 1.8v 1519.495n 1.8v 1519.505n 1.8v 1529.495n 1.8v 1529.505n 1.8v 1539.495n 1.8v 1539.505n 1.8v 1549.495n 1.8v 1549.505n 1.8v 1559.495n 1.8v 1559.505n 1.8v 1569.495n 1.8v 1569.505n 1.8v 1579.495n 1.8v 1579.505n 0.0v 1589.495n 0.0v 1589.505n 0.0v 1599.495n 0.0v 1599.505n 0.0v 1609.495n 0.0v 1609.505n 1.8v 1619.495n 1.8v 1619.505n 1.8v 1629.495n 1.8v 1629.505n 1.8v 1639.495n 1.8v 1639.505n 0.0v 1649.495n 0.0v 1649.505n 0.0v 1659.495n 0.0v 1659.505n 0.0v 1669.495n 0.0v 1669.505n 0.0v 1679.495n 0.0v 1679.505n 1.8v 1689.495n 1.8v 1689.505n 1.8v 1699.495n 1.8v 1699.505n 1.8v 1709.495n 1.8v 1709.505n 0.0v 1719.495n 0.0v 1719.505n 0.0v 1729.495n 0.0v 1729.505n 0.0v 1739.495n 0.0v 1739.505n 1.8v 1749.495n 1.8v 1749.505n 0.0v 1759.495n 0.0v 1759.505n 0.0v 1769.495n 0.0v 1769.505n 0.0v 1779.495n 0.0v 1779.505n 0.0v 1789.495n 0.0v 1789.505n 0.0v 1799.495n 0.0v 1799.505n 0.0v 1809.495n 0.0v 1809.505n 0.0v 1819.495n 0.0v 1819.505n 0.0v 1829.495n 0.0v 1829.505n 1.8v 1839.495n 1.8v 1839.505n 1.8v 1849.495n 1.8v 1849.505n 1.8v 1859.495n 1.8v 1859.505n 1.8v 1869.495n 1.8v 1869.505n 1.8v 1879.495n 1.8v 1879.505n 1.8v 1889.495n 1.8v 1889.505n 0.0v 1899.495n 0.0v 1899.505n 1.8v 1909.495n 1.8v 1909.505n 0.0v 1919.495n 0.0v 1919.505n 0.0v 1929.495n 0.0v 1929.505n 1.8v 1939.495n 1.8v 1939.505n 1.8v 1949.495n 1.8v 1949.505n 1.8v 1959.495n 1.8v 1959.505n 1.8v 1969.495n 1.8v 1969.505n 0.0v 1979.495n 0.0v 1979.505n 0.0v 1989.495n 0.0v 1989.505n 1.8v 1999.495n 1.8v 1999.505n 0.0v 2009.495n 0.0v 2009.505n 0.0v 2019.495n 0.0v 2019.505n 0.0v 2029.495n 0.0v 2029.505n 1.8v 2039.495n 1.8v 2039.505n 0.0v 2049.495n 0.0v 2049.505n 0.0v )

 * Generation of control signals
* (time, data): [(0, 1), (10, 0), (20, 0), (30, 0), (40, 0), (50, 1), (60, 0), (70, 1), (80, 0), (90, 0), (100, 0), (110, 0), (120, 0), (130, 0), (140, 0), (150, 0), (160, 0), (170, 0), (180, 0), (190, 1), (200, 0), (210, 1), (220, 0), (230, 0), (240, 0), (250, 0), (260, 0), (270, 0), (280, 0), (290, 0), (300, 0), (310, 0), (320, 0), (330, 0), (340, 0), (350, 0), (360, 0), (370, 0), (380, 1), (390, 0), (400, 0), (410, 0), (420, 1), (430, 0), (440, 1), (450, 0), (460, 1), (470, 0), (480, 0), (490, 0), (500, 0), (510, 0), (520, 0), (530, 0), (540, 0), (550, 0), (560, 0), (570, 0), (580, 0), (590, 0), (600, 0), (610, 0), (620, 0), (630, 0), (640, 1), (650, 0), (660, 1), (670, 0), (680, 1), (690, 0), (700, 0), (710, 0), (720, 0), (730, 0), (740, 0), (750, 0), (760, 0), (770, 0), (780, 0), (790, 0), (800, 1), (810, 0), (820, 0), (830, 1), (840, 1), (850, 0), (860, 0), (870, 1), (880, 0), (890, 0), (900, 0), (910, 0), (920, 0), (930, 0), (940, 0), (950, 0), (960, 0), (970, 1), (980, 1), (990, 0), (1000, 0), (1010, 0), (1020, 1), (1030, 0), (1040, 0), (1050, 0), (1060, 0), (1070, 0), (1080, 0), (1090, 0), (1100, 0), (1110, 0), (1120, 0), (1130, 0), (1140, 0), (1150, 0), (1160, 0), (1170, 0), (1180, 0), (1190, 0), (1200, 0), (1210, 0), (1220, 0), (1230, 0), (1240, 0), (1250, 0), (1260, 0), (1270, 1), (1280, 1), (1290, 0), (1300, 1), (1310, 1), (1320, 0), (1330, 0), (1340, 0), (1350, 0), (1360, 0), (1370, 0), (1380, 0), (1390, 0), (1400, 0), (1410, 0), (1420, 0), (1430, 0), (1440, 0), (1450, 0), (1460, 0), (1470, 0), (1480, 0), (1490, 0), (1500, 0), (1510, 0), (1520, 1), (1530, 0), (1540, 1), (1550, 0), (1560, 0), (1570, 0), (1580, 0), (1590, 0), (1600, 1), (1610, 0), (1620, 1), (1630, 0), (1640, 0), (1650, 1), (1660, 0), (1670, 0), (1680, 0), (1690, 0), (1700, 0), (1710, 0), (1720, 0), (1730, 0), (1740, 0), (1750, 0), (1760, 0), (1770, 0), (1780, 0), (1790, 0), (1800, 0), (1810, 0), (1820, 0), (1830, 1), (1840, 0), (1850, 0), (1860, 0), (1870, 0), (1880, 0), (1890, 1), (1900, 0), (1910, 0), (1920, 0), (1930, 0), (1940, 0), (1950, 0), (1960, 0), (1970, 0), (1980, 0), (1990, 0), (2000, 0), (2010, 0), (2020, 0), (2030, 0), (2040, 0), (2050, 1)]
VCSB0 CSB0 0 PWL (0n 1.8v 9.495n 1.8v 9.505n 0.0v 19.495n 0.0v 19.505n 0.0v 29.495n 0.0v 29.505n 0.0v 39.495n 0.0v 39.505n 0.0v 49.495n 0.0v 49.505n 1.8v 59.495n 1.8v 59.505n 0.0v 69.495n 0.0v 69.505n 1.8v 79.495n 1.8v 79.505n 0.0v 89.495n 0.0v 89.505n 0.0v 99.495n 0.0v 99.505n 0.0v 109.495n 0.0v 109.505n 0.0v 119.495n 0.0v 119.505n 0.0v 129.495n 0.0v 129.505n 0.0v 139.495n 0.0v 139.505n 0.0v 149.495n 0.0v 149.505n 0.0v 159.495n 0.0v 159.505n 0.0v 169.495n 0.0v 169.505n 0.0v 179.495n 0.0v 179.505n 0.0v 189.495n 0.0v 189.505n 1.8v 199.495n 1.8v 199.505n 0.0v 209.495n 0.0v 209.505n 1.8v 219.495n 1.8v 219.505n 0.0v 229.495n 0.0v 229.505n 0.0v 239.495n 0.0v 239.505n 0.0v 249.495n 0.0v 249.505n 0.0v 259.495n 0.0v 259.505n 0.0v 269.495n 0.0v 269.505n 0.0v 279.495n 0.0v 279.505n 0.0v 289.495n 0.0v 289.505n 0.0v 299.495n 0.0v 299.505n 0.0v 309.495n 0.0v 309.505n 0.0v 319.495n 0.0v 319.505n 0.0v 329.495n 0.0v 329.505n 0.0v 339.495n 0.0v 339.505n 0.0v 349.495n 0.0v 349.505n 0.0v 359.495n 0.0v 359.505n 0.0v 369.495n 0.0v 369.505n 0.0v 379.495n 0.0v 379.505n 1.8v 389.495n 1.8v 389.505n 0.0v 399.495n 0.0v 399.505n 0.0v 409.495n 0.0v 409.505n 0.0v 419.495n 0.0v 419.505n 1.8v 429.495n 1.8v 429.505n 0.0v 439.495n 0.0v 439.505n 1.8v 449.495n 1.8v 449.505n 0.0v 459.495n 0.0v 459.505n 1.8v 469.495n 1.8v 469.505n 0.0v 479.495n 0.0v 479.505n 0.0v 489.495n 0.0v 489.505n 0.0v 499.495n 0.0v 499.505n 0.0v 509.495n 0.0v 509.505n 0.0v 519.495n 0.0v 519.505n 0.0v 529.495n 0.0v 529.505n 0.0v 539.495n 0.0v 539.505n 0.0v 549.495n 0.0v 549.505n 0.0v 559.495n 0.0v 559.505n 0.0v 569.495n 0.0v 569.505n 0.0v 579.495n 0.0v 579.505n 0.0v 589.495n 0.0v 589.505n 0.0v 599.495n 0.0v 599.505n 0.0v 609.495n 0.0v 609.505n 0.0v 619.495n 0.0v 619.505n 0.0v 629.495n 0.0v 629.505n 0.0v 639.495n 0.0v 639.505n 1.8v 649.495n 1.8v 649.505n 0.0v 659.495n 0.0v 659.505n 1.8v 669.495n 1.8v 669.505n 0.0v 679.495n 0.0v 679.505n 1.8v 689.495n 1.8v 689.505n 0.0v 699.495n 0.0v 699.505n 0.0v 709.495n 0.0v 709.505n 0.0v 719.495n 0.0v 719.505n 0.0v 729.495n 0.0v 729.505n 0.0v 739.495n 0.0v 739.505n 0.0v 749.495n 0.0v 749.505n 0.0v 759.495n 0.0v 759.505n 0.0v 769.495n 0.0v 769.505n 0.0v 779.495n 0.0v 779.505n 0.0v 789.495n 0.0v 789.505n 0.0v 799.495n 0.0v 799.505n 1.8v 809.495n 1.8v 809.505n 0.0v 819.495n 0.0v 819.505n 0.0v 829.495n 0.0v 829.505n 1.8v 839.495n 1.8v 839.505n 1.8v 849.495n 1.8v 849.505n 0.0v 859.495n 0.0v 859.505n 0.0v 869.495n 0.0v 869.505n 1.8v 879.495n 1.8v 879.505n 0.0v 889.495n 0.0v 889.505n 0.0v 899.495n 0.0v 899.505n 0.0v 909.495n 0.0v 909.505n 0.0v 919.495n 0.0v 919.505n 0.0v 929.495n 0.0v 929.505n 0.0v 939.495n 0.0v 939.505n 0.0v 949.495n 0.0v 949.505n 0.0v 959.495n 0.0v 959.505n 0.0v 969.495n 0.0v 969.505n 1.8v 979.495n 1.8v 979.505n 1.8v 989.495n 1.8v 989.505n 0.0v 999.495n 0.0v 999.505n 0.0v 1009.495n 0.0v 1009.505n 0.0v 1019.495n 0.0v 1019.505n 1.8v 1029.495n 1.8v 1029.505n 0.0v 1039.495n 0.0v 1039.505n 0.0v 1049.495n 0.0v 1049.505n 0.0v 1059.495n 0.0v 1059.505n 0.0v 1069.495n 0.0v 1069.505n 0.0v 1079.495n 0.0v 1079.505n 0.0v 1089.495n 0.0v 1089.505n 0.0v 1099.495n 0.0v 1099.505n 0.0v 1109.495n 0.0v 1109.505n 0.0v 1119.495n 0.0v 1119.505n 0.0v 1129.495n 0.0v 1129.505n 0.0v 1139.495n 0.0v 1139.505n 0.0v 1149.495n 0.0v 1149.505n 0.0v 1159.495n 0.0v 1159.505n 0.0v 1169.495n 0.0v 1169.505n 0.0v 1179.495n 0.0v 1179.505n 0.0v 1189.495n 0.0v 1189.505n 0.0v 1199.495n 0.0v 1199.505n 0.0v 1209.495n 0.0v 1209.505n 0.0v 1219.495n 0.0v 1219.505n 0.0v 1229.495n 0.0v 1229.505n 0.0v 1239.495n 0.0v 1239.505n 0.0v 1249.495n 0.0v 1249.505n 0.0v 1259.495n 0.0v 1259.505n 0.0v 1269.495n 0.0v 1269.505n 1.8v 1279.495n 1.8v 1279.505n 1.8v 1289.495n 1.8v 1289.505n 0.0v 1299.495n 0.0v 1299.505n 1.8v 1309.495n 1.8v 1309.505n 1.8v 1319.495n 1.8v 1319.505n 0.0v 1329.495n 0.0v 1329.505n 0.0v 1339.495n 0.0v 1339.505n 0.0v 1349.495n 0.0v 1349.505n 0.0v 1359.495n 0.0v 1359.505n 0.0v 1369.495n 0.0v 1369.505n 0.0v 1379.495n 0.0v 1379.505n 0.0v 1389.495n 0.0v 1389.505n 0.0v 1399.495n 0.0v 1399.505n 0.0v 1409.495n 0.0v 1409.505n 0.0v 1419.495n 0.0v 1419.505n 0.0v 1429.495n 0.0v 1429.505n 0.0v 1439.495n 0.0v 1439.505n 0.0v 1449.495n 0.0v 1449.505n 0.0v 1459.495n 0.0v 1459.505n 0.0v 1469.495n 0.0v 1469.505n 0.0v 1479.495n 0.0v 1479.505n 0.0v 1489.495n 0.0v 1489.505n 0.0v 1499.495n 0.0v 1499.505n 0.0v 1509.495n 0.0v 1509.505n 0.0v 1519.495n 0.0v 1519.505n 1.8v 1529.495n 1.8v 1529.505n 0.0v 1539.495n 0.0v 1539.505n 1.8v 1549.495n 1.8v 1549.505n 0.0v 1559.495n 0.0v 1559.505n 0.0v 1569.495n 0.0v 1569.505n 0.0v 1579.495n 0.0v 1579.505n 0.0v 1589.495n 0.0v 1589.505n 0.0v 1599.495n 0.0v 1599.505n 1.8v 1609.495n 1.8v 1609.505n 0.0v 1619.495n 0.0v 1619.505n 1.8v 1629.495n 1.8v 1629.505n 0.0v 1639.495n 0.0v 1639.505n 0.0v 1649.495n 0.0v 1649.505n 1.8v 1659.495n 1.8v 1659.505n 0.0v 1669.495n 0.0v 1669.505n 0.0v 1679.495n 0.0v 1679.505n 0.0v 1689.495n 0.0v 1689.505n 0.0v 1699.495n 0.0v 1699.505n 0.0v 1709.495n 0.0v 1709.505n 0.0v 1719.495n 0.0v 1719.505n 0.0v 1729.495n 0.0v 1729.505n 0.0v 1739.495n 0.0v 1739.505n 0.0v 1749.495n 0.0v 1749.505n 0.0v 1759.495n 0.0v 1759.505n 0.0v 1769.495n 0.0v 1769.505n 0.0v 1779.495n 0.0v 1779.505n 0.0v 1789.495n 0.0v 1789.505n 0.0v 1799.495n 0.0v 1799.505n 0.0v 1809.495n 0.0v 1809.505n 0.0v 1819.495n 0.0v 1819.505n 0.0v 1829.495n 0.0v 1829.505n 1.8v 1839.495n 1.8v 1839.505n 0.0v 1849.495n 0.0v 1849.505n 0.0v 1859.495n 0.0v 1859.505n 0.0v 1869.495n 0.0v 1869.505n 0.0v 1879.495n 0.0v 1879.505n 0.0v 1889.495n 0.0v 1889.505n 1.8v 1899.495n 1.8v 1899.505n 0.0v 1909.495n 0.0v 1909.505n 0.0v 1919.495n 0.0v 1919.505n 0.0v 1929.495n 0.0v 1929.505n 0.0v 1939.495n 0.0v 1939.505n 0.0v 1949.495n 0.0v 1949.505n 0.0v 1959.495n 0.0v 1959.505n 0.0v 1969.495n 0.0v 1969.505n 0.0v 1979.495n 0.0v 1979.505n 0.0v 1989.495n 0.0v 1989.505n 0.0v 1999.495n 0.0v 1999.505n 0.0v 2009.495n 0.0v 2009.505n 0.0v 2019.495n 0.0v 2019.505n 0.0v 2029.495n 0.0v 2029.505n 0.0v 2039.495n 0.0v 2039.505n 0.0v 2049.495n 0.0v 2049.505n 1.8v )
* (time, data): [(0, 1), (10, 1), (20, 1), (30, 1), (40, 0), (50, 0), (60, 0), (70, 0), (80, 0), (90, 1), (100, 1), (110, 1), (120, 1), (130, 0), (140, 0), (150, 0), (160, 1), (170, 1), (180, 1), (190, 0), (200, 1), (210, 1), (220, 0), (230, 1), (240, 0), (250, 0), (260, 1), (270, 1), (280, 0), (290, 1), (300, 0), (310, 1), (320, 0), (330, 0), (340, 1), (350, 1), (360, 0), (370, 0), (380, 1), (390, 1), (400, 0), (410, 0), (420, 1), (430, 0), (440, 1), (450, 0), (460, 1), (470, 0), (480, 1), (490, 0), (500, 1), (510, 1), (520, 0), (530, 1), (540, 0), (550, 1), (560, 1), (570, 0), (580, 1), (590, 1), (600, 0), (610, 1), (620, 1), (630, 1), (640, 0), (650, 0), (660, 0), (670, 0), (680, 1), (690, 0), (700, 1), (710, 0), (720, 1), (730, 0), (740, 0), (750, 1), (760, 1), (770, 0), (780, 1), (790, 1), (800, 0), (810, 1), (820, 0), (830, 1), (840, 1), (850, 0), (860, 0), (870, 0), (880, 1), (890, 0), (900, 1), (910, 1), (920, 1), (930, 0), (940, 0), (950, 1), (960, 0), (970, 0), (980, 1), (990, 0), (1000, 1), (1010, 1), (1020, 1), (1030, 0), (1040, 1), (1050, 1), (1060, 0), (1070, 0), (1080, 0), (1090, 1), (1100, 0), (1110, 0), (1120, 1), (1130, 1), (1140, 1), (1150, 0), (1160, 0), (1170, 0), (1180, 1), (1190, 0), (1200, 1), (1210, 1), (1220, 0), (1230, 0), (1240, 0), (1250, 0), (1260, 1), (1270, 0), (1280, 1), (1290, 1), (1300, 1), (1310, 1), (1320, 0), (1330, 0), (1340, 1), (1350, 1), (1360, 0), (1370, 1), (1380, 1), (1390, 1), (1400, 1), (1410, 1), (1420, 1), (1430, 1), (1440, 1), (1450, 0), (1460, 1), (1470, 0), (1480, 0), (1490, 1), (1500, 1), (1510, 0), (1520, 1), (1530, 1), (1540, 1), (1550, 1), (1560, 1), (1570, 1), (1580, 0), (1590, 0), (1600, 1), (1610, 0), (1620, 1), (1630, 1), (1640, 0), (1650, 0), (1660, 1), (1670, 1), (1680, 0), (1690, 1), (1700, 0), (1710, 0), (1720, 0), (1730, 1), (1740, 0), (1750, 0), (1760, 0), (1770, 0), (1780, 1), (1790, 1), (1800, 0), (1810, 1), (1820, 1), (1830, 0), (1840, 1), (1850, 1), (1860, 1), (1870, 0), (1880, 1), (1890, 0), (1900, 0), (1910, 0), (1920, 1), (1930, 0), (1940, 1), (1950, 1), (1960, 1), (1970, 0), (1980, 1), (1990, 0), (2000, 0), (2010, 1), (2020, 1), (2030, 0), (2040, 0), (2050, 1)]
VCSB1 CSB1 0 PWL (0n 1.8v 9.495n 1.8v 9.505n 1.8v 19.495n 1.8v 19.505n 1.8v 29.495n 1.8v 29.505n 1.8v 39.495n 1.8v 39.505n 0.0v 49.495n 0.0v 49.505n 0.0v 59.495n 0.0v 59.505n 0.0v 69.495n 0.0v 69.505n 0.0v 79.495n 0.0v 79.505n 0.0v 89.495n 0.0v 89.505n 1.8v 99.495n 1.8v 99.505n 1.8v 109.495n 1.8v 109.505n 1.8v 119.495n 1.8v 119.505n 1.8v 129.495n 1.8v 129.505n 0.0v 139.495n 0.0v 139.505n 0.0v 149.495n 0.0v 149.505n 0.0v 159.495n 0.0v 159.505n 1.8v 169.495n 1.8v 169.505n 1.8v 179.495n 1.8v 179.505n 1.8v 189.495n 1.8v 189.505n 0.0v 199.495n 0.0v 199.505n 1.8v 209.495n 1.8v 209.505n 1.8v 219.495n 1.8v 219.505n 0.0v 229.495n 0.0v 229.505n 1.8v 239.495n 1.8v 239.505n 0.0v 249.495n 0.0v 249.505n 0.0v 259.495n 0.0v 259.505n 1.8v 269.495n 1.8v 269.505n 1.8v 279.495n 1.8v 279.505n 0.0v 289.495n 0.0v 289.505n 1.8v 299.495n 1.8v 299.505n 0.0v 309.495n 0.0v 309.505n 1.8v 319.495n 1.8v 319.505n 0.0v 329.495n 0.0v 329.505n 0.0v 339.495n 0.0v 339.505n 1.8v 349.495n 1.8v 349.505n 1.8v 359.495n 1.8v 359.505n 0.0v 369.495n 0.0v 369.505n 0.0v 379.495n 0.0v 379.505n 1.8v 389.495n 1.8v 389.505n 1.8v 399.495n 1.8v 399.505n 0.0v 409.495n 0.0v 409.505n 0.0v 419.495n 0.0v 419.505n 1.8v 429.495n 1.8v 429.505n 0.0v 439.495n 0.0v 439.505n 1.8v 449.495n 1.8v 449.505n 0.0v 459.495n 0.0v 459.505n 1.8v 469.495n 1.8v 469.505n 0.0v 479.495n 0.0v 479.505n 1.8v 489.495n 1.8v 489.505n 0.0v 499.495n 0.0v 499.505n 1.8v 509.495n 1.8v 509.505n 1.8v 519.495n 1.8v 519.505n 0.0v 529.495n 0.0v 529.505n 1.8v 539.495n 1.8v 539.505n 0.0v 549.495n 0.0v 549.505n 1.8v 559.495n 1.8v 559.505n 1.8v 569.495n 1.8v 569.505n 0.0v 579.495n 0.0v 579.505n 1.8v 589.495n 1.8v 589.505n 1.8v 599.495n 1.8v 599.505n 0.0v 609.495n 0.0v 609.505n 1.8v 619.495n 1.8v 619.505n 1.8v 629.495n 1.8v 629.505n 1.8v 639.495n 1.8v 639.505n 0.0v 649.495n 0.0v 649.505n 0.0v 659.495n 0.0v 659.505n 0.0v 669.495n 0.0v 669.505n 0.0v 679.495n 0.0v 679.505n 1.8v 689.495n 1.8v 689.505n 0.0v 699.495n 0.0v 699.505n 1.8v 709.495n 1.8v 709.505n 0.0v 719.495n 0.0v 719.505n 1.8v 729.495n 1.8v 729.505n 0.0v 739.495n 0.0v 739.505n 0.0v 749.495n 0.0v 749.505n 1.8v 759.495n 1.8v 759.505n 1.8v 769.495n 1.8v 769.505n 0.0v 779.495n 0.0v 779.505n 1.8v 789.495n 1.8v 789.505n 1.8v 799.495n 1.8v 799.505n 0.0v 809.495n 0.0v 809.505n 1.8v 819.495n 1.8v 819.505n 0.0v 829.495n 0.0v 829.505n 1.8v 839.495n 1.8v 839.505n 1.8v 849.495n 1.8v 849.505n 0.0v 859.495n 0.0v 859.505n 0.0v 869.495n 0.0v 869.505n 0.0v 879.495n 0.0v 879.505n 1.8v 889.495n 1.8v 889.505n 0.0v 899.495n 0.0v 899.505n 1.8v 909.495n 1.8v 909.505n 1.8v 919.495n 1.8v 919.505n 1.8v 929.495n 1.8v 929.505n 0.0v 939.495n 0.0v 939.505n 0.0v 949.495n 0.0v 949.505n 1.8v 959.495n 1.8v 959.505n 0.0v 969.495n 0.0v 969.505n 0.0v 979.495n 0.0v 979.505n 1.8v 989.495n 1.8v 989.505n 0.0v 999.495n 0.0v 999.505n 1.8v 1009.495n 1.8v 1009.505n 1.8v 1019.495n 1.8v 1019.505n 1.8v 1029.495n 1.8v 1029.505n 0.0v 1039.495n 0.0v 1039.505n 1.8v 1049.495n 1.8v 1049.505n 1.8v 1059.495n 1.8v 1059.505n 0.0v 1069.495n 0.0v 1069.505n 0.0v 1079.495n 0.0v 1079.505n 0.0v 1089.495n 0.0v 1089.505n 1.8v 1099.495n 1.8v 1099.505n 0.0v 1109.495n 0.0v 1109.505n 0.0v 1119.495n 0.0v 1119.505n 1.8v 1129.495n 1.8v 1129.505n 1.8v 1139.495n 1.8v 1139.505n 1.8v 1149.495n 1.8v 1149.505n 0.0v 1159.495n 0.0v 1159.505n 0.0v 1169.495n 0.0v 1169.505n 0.0v 1179.495n 0.0v 1179.505n 1.8v 1189.495n 1.8v 1189.505n 0.0v 1199.495n 0.0v 1199.505n 1.8v 1209.495n 1.8v 1209.505n 1.8v 1219.495n 1.8v 1219.505n 0.0v 1229.495n 0.0v 1229.505n 0.0v 1239.495n 0.0v 1239.505n 0.0v 1249.495n 0.0v 1249.505n 0.0v 1259.495n 0.0v 1259.505n 1.8v 1269.495n 1.8v 1269.505n 0.0v 1279.495n 0.0v 1279.505n 1.8v 1289.495n 1.8v 1289.505n 1.8v 1299.495n 1.8v 1299.505n 1.8v 1309.495n 1.8v 1309.505n 1.8v 1319.495n 1.8v 1319.505n 0.0v 1329.495n 0.0v 1329.505n 0.0v 1339.495n 0.0v 1339.505n 1.8v 1349.495n 1.8v 1349.505n 1.8v 1359.495n 1.8v 1359.505n 0.0v 1369.495n 0.0v 1369.505n 1.8v 1379.495n 1.8v 1379.505n 1.8v 1389.495n 1.8v 1389.505n 1.8v 1399.495n 1.8v 1399.505n 1.8v 1409.495n 1.8v 1409.505n 1.8v 1419.495n 1.8v 1419.505n 1.8v 1429.495n 1.8v 1429.505n 1.8v 1439.495n 1.8v 1439.505n 1.8v 1449.495n 1.8v 1449.505n 0.0v 1459.495n 0.0v 1459.505n 1.8v 1469.495n 1.8v 1469.505n 0.0v 1479.495n 0.0v 1479.505n 0.0v 1489.495n 0.0v 1489.505n 1.8v 1499.495n 1.8v 1499.505n 1.8v 1509.495n 1.8v 1509.505n 0.0v 1519.495n 0.0v 1519.505n 1.8v 1529.495n 1.8v 1529.505n 1.8v 1539.495n 1.8v 1539.505n 1.8v 1549.495n 1.8v 1549.505n 1.8v 1559.495n 1.8v 1559.505n 1.8v 1569.495n 1.8v 1569.505n 1.8v 1579.495n 1.8v 1579.505n 0.0v 1589.495n 0.0v 1589.505n 0.0v 1599.495n 0.0v 1599.505n 1.8v 1609.495n 1.8v 1609.505n 0.0v 1619.495n 0.0v 1619.505n 1.8v 1629.495n 1.8v 1629.505n 1.8v 1639.495n 1.8v 1639.505n 0.0v 1649.495n 0.0v 1649.505n 0.0v 1659.495n 0.0v 1659.505n 1.8v 1669.495n 1.8v 1669.505n 1.8v 1679.495n 1.8v 1679.505n 0.0v 1689.495n 0.0v 1689.505n 1.8v 1699.495n 1.8v 1699.505n 0.0v 1709.495n 0.0v 1709.505n 0.0v 1719.495n 0.0v 1719.505n 0.0v 1729.495n 0.0v 1729.505n 1.8v 1739.495n 1.8v 1739.505n 0.0v 1749.495n 0.0v 1749.505n 0.0v 1759.495n 0.0v 1759.505n 0.0v 1769.495n 0.0v 1769.505n 0.0v 1779.495n 0.0v 1779.505n 1.8v 1789.495n 1.8v 1789.505n 1.8v 1799.495n 1.8v 1799.505n 0.0v 1809.495n 0.0v 1809.505n 1.8v 1819.495n 1.8v 1819.505n 1.8v 1829.495n 1.8v 1829.505n 0.0v 1839.495n 0.0v 1839.505n 1.8v 1849.495n 1.8v 1849.505n 1.8v 1859.495n 1.8v 1859.505n 1.8v 1869.495n 1.8v 1869.505n 0.0v 1879.495n 0.0v 1879.505n 1.8v 1889.495n 1.8v 1889.505n 0.0v 1899.495n 0.0v 1899.505n 0.0v 1909.495n 0.0v 1909.505n 0.0v 1919.495n 0.0v 1919.505n 1.8v 1929.495n 1.8v 1929.505n 0.0v 1939.495n 0.0v 1939.505n 1.8v 1949.495n 1.8v 1949.505n 1.8v 1959.495n 1.8v 1959.505n 1.8v 1969.495n 1.8v 1969.505n 0.0v 1979.495n 0.0v 1979.505n 1.8v 1989.495n 1.8v 1989.505n 0.0v 1999.495n 0.0v 1999.505n 0.0v 2009.495n 0.0v 2009.505n 1.8v 2019.495n 1.8v 2019.505n 1.8v 2029.495n 1.8v 2029.505n 0.0v 2039.495n 0.0v 2039.505n 0.0v 2049.495n 0.0v 2049.505n 1.8v )
* (time, data): [(0, 1), (10, 0), (20, 0), (30, 0), (40, 1), (50, 1), (60, 1), (70, 1), (80, 0), (90, 1), (100, 1), (110, 0), (120, 1), (130, 1), (140, 1), (150, 1), (160, 1), (170, 0), (180, 1), (190, 1), (200, 0), (210, 1), (220, 1), (230, 1), (240, 0), (250, 1), (260, 1), (270, 0), (280, 0), (290, 1), (300, 1), (310, 0), (320, 0), (330, 1), (340, 0), (350, 1), (360, 1), (370, 1), (380, 1), (390, 0), (400, 0), (410, 0), (420, 1), (430, 0), (440, 1), (450, 1), (460, 1), (470, 1), (480, 1), (490, 1), (500, 0), (510, 0), (520, 1), (530, 0), (540, 0), (550, 1), (560, 1), (570, 1), (580, 1), (590, 1), (600, 0), (610, 1), (620, 0), (630, 1), (640, 1), (650, 0), (660, 1), (670, 0), (680, 1), (690, 1), (700, 1), (710, 1), (720, 1), (730, 1), (740, 0), (750, 0), (760, 0), (770, 0), (780, 1), (790, 1), (800, 1), (810, 1), (820, 1), (830, 1), (840, 1), (850, 1), (860, 0), (870, 1), (880, 1), (890, 1), (900, 0), (910, 0), (920, 0), (930, 1), (940, 1), (950, 1), (960, 1), (970, 1), (980, 1), (990, 0), (1000, 0), (1010, 1), (1020, 1), (1030, 1), (1040, 0), (1050, 1), (1060, 0), (1070, 1), (1080, 1), (1090, 1), (1100, 0), (1110, 1), (1120, 0), (1130, 0), (1140, 1), (1150, 0), (1160, 1), (1170, 1), (1180, 1), (1190, 1), (1200, 1), (1210, 0), (1220, 0), (1230, 0), (1240, 0), (1250, 0), (1260, 0), (1270, 1), (1280, 1), (1290, 1), (1300, 1), (1310, 1), (1320, 1), (1330, 1), (1340, 0), (1350, 0), (1360, 1), (1370, 1), (1380, 1), (1390, 0), (1400, 1), (1410, 0), (1420, 0), (1430, 1), (1440, 1), (1450, 1), (1460, 1), (1470, 1), (1480, 0), (1490, 1), (1500, 1), (1510, 0), (1520, 1), (1530, 0), (1540, 1), (1550, 0), (1560, 1), (1570, 0), (1580, 0), (1590, 0), (1600, 1), (1610, 0), (1620, 1), (1630, 1), (1640, 1), (1650, 1), (1660, 0), (1670, 1), (1680, 0), (1690, 0), (1700, 1), (1710, 0), (1720, 1), (1730, 0), (1740, 1), (1750, 1), (1760, 1), (1770, 1), (1780, 0), (1790, 1), (1800, 0), (1810, 1), (1820, 1), (1830, 1), (1840, 0), (1850, 0), (1860, 1), (1870, 1), (1880, 1), (1890, 1), (1900, 0), (1910, 1), (1920, 1), (1930, 1), (1940, 0), (1950, 0), (1960, 1), (1970, 0), (1980, 1), (1990, 0), (2000, 1), (2010, 1), (2020, 1), (2030, 1), (2040, 0), (2050, 1)]
VWEB0 WEB0 0 PWL (0n 1.8v 9.495n 1.8v 9.505n 0.0v 19.495n 0.0v 19.505n 0.0v 29.495n 0.0v 29.505n 0.0v 39.495n 0.0v 39.505n 1.8v 49.495n 1.8v 49.505n 1.8v 59.495n 1.8v 59.505n 1.8v 69.495n 1.8v 69.505n 1.8v 79.495n 1.8v 79.505n 0.0v 89.495n 0.0v 89.505n 1.8v 99.495n 1.8v 99.505n 1.8v 109.495n 1.8v 109.505n 0.0v 119.495n 0.0v 119.505n 1.8v 129.495n 1.8v 129.505n 1.8v 139.495n 1.8v 139.505n 1.8v 149.495n 1.8v 149.505n 1.8v 159.495n 1.8v 159.505n 1.8v 169.495n 1.8v 169.505n 0.0v 179.495n 0.0v 179.505n 1.8v 189.495n 1.8v 189.505n 1.8v 199.495n 1.8v 199.505n 0.0v 209.495n 0.0v 209.505n 1.8v 219.495n 1.8v 219.505n 1.8v 229.495n 1.8v 229.505n 1.8v 239.495n 1.8v 239.505n 0.0v 249.495n 0.0v 249.505n 1.8v 259.495n 1.8v 259.505n 1.8v 269.495n 1.8v 269.505n 0.0v 279.495n 0.0v 279.505n 0.0v 289.495n 0.0v 289.505n 1.8v 299.495n 1.8v 299.505n 1.8v 309.495n 1.8v 309.505n 0.0v 319.495n 0.0v 319.505n 0.0v 329.495n 0.0v 329.505n 1.8v 339.495n 1.8v 339.505n 0.0v 349.495n 0.0v 349.505n 1.8v 359.495n 1.8v 359.505n 1.8v 369.495n 1.8v 369.505n 1.8v 379.495n 1.8v 379.505n 1.8v 389.495n 1.8v 389.505n 0.0v 399.495n 0.0v 399.505n 0.0v 409.495n 0.0v 409.505n 0.0v 419.495n 0.0v 419.505n 1.8v 429.495n 1.8v 429.505n 0.0v 439.495n 0.0v 439.505n 1.8v 449.495n 1.8v 449.505n 1.8v 459.495n 1.8v 459.505n 1.8v 469.495n 1.8v 469.505n 1.8v 479.495n 1.8v 479.505n 1.8v 489.495n 1.8v 489.505n 1.8v 499.495n 1.8v 499.505n 0.0v 509.495n 0.0v 509.505n 0.0v 519.495n 0.0v 519.505n 1.8v 529.495n 1.8v 529.505n 0.0v 539.495n 0.0v 539.505n 0.0v 549.495n 0.0v 549.505n 1.8v 559.495n 1.8v 559.505n 1.8v 569.495n 1.8v 569.505n 1.8v 579.495n 1.8v 579.505n 1.8v 589.495n 1.8v 589.505n 1.8v 599.495n 1.8v 599.505n 0.0v 609.495n 0.0v 609.505n 1.8v 619.495n 1.8v 619.505n 0.0v 629.495n 0.0v 629.505n 1.8v 639.495n 1.8v 639.505n 1.8v 649.495n 1.8v 649.505n 0.0v 659.495n 0.0v 659.505n 1.8v 669.495n 1.8v 669.505n 0.0v 679.495n 0.0v 679.505n 1.8v 689.495n 1.8v 689.505n 1.8v 699.495n 1.8v 699.505n 1.8v 709.495n 1.8v 709.505n 1.8v 719.495n 1.8v 719.505n 1.8v 729.495n 1.8v 729.505n 1.8v 739.495n 1.8v 739.505n 0.0v 749.495n 0.0v 749.505n 0.0v 759.495n 0.0v 759.505n 0.0v 769.495n 0.0v 769.505n 0.0v 779.495n 0.0v 779.505n 1.8v 789.495n 1.8v 789.505n 1.8v 799.495n 1.8v 799.505n 1.8v 809.495n 1.8v 809.505n 1.8v 819.495n 1.8v 819.505n 1.8v 829.495n 1.8v 829.505n 1.8v 839.495n 1.8v 839.505n 1.8v 849.495n 1.8v 849.505n 1.8v 859.495n 1.8v 859.505n 0.0v 869.495n 0.0v 869.505n 1.8v 879.495n 1.8v 879.505n 1.8v 889.495n 1.8v 889.505n 1.8v 899.495n 1.8v 899.505n 0.0v 909.495n 0.0v 909.505n 0.0v 919.495n 0.0v 919.505n 0.0v 929.495n 0.0v 929.505n 1.8v 939.495n 1.8v 939.505n 1.8v 949.495n 1.8v 949.505n 1.8v 959.495n 1.8v 959.505n 1.8v 969.495n 1.8v 969.505n 1.8v 979.495n 1.8v 979.505n 1.8v 989.495n 1.8v 989.505n 0.0v 999.495n 0.0v 999.505n 0.0v 1009.495n 0.0v 1009.505n 1.8v 1019.495n 1.8v 1019.505n 1.8v 1029.495n 1.8v 1029.505n 1.8v 1039.495n 1.8v 1039.505n 0.0v 1049.495n 0.0v 1049.505n 1.8v 1059.495n 1.8v 1059.505n 0.0v 1069.495n 0.0v 1069.505n 1.8v 1079.495n 1.8v 1079.505n 1.8v 1089.495n 1.8v 1089.505n 1.8v 1099.495n 1.8v 1099.505n 0.0v 1109.495n 0.0v 1109.505n 1.8v 1119.495n 1.8v 1119.505n 0.0v 1129.495n 0.0v 1129.505n 0.0v 1139.495n 0.0v 1139.505n 1.8v 1149.495n 1.8v 1149.505n 0.0v 1159.495n 0.0v 1159.505n 1.8v 1169.495n 1.8v 1169.505n 1.8v 1179.495n 1.8v 1179.505n 1.8v 1189.495n 1.8v 1189.505n 1.8v 1199.495n 1.8v 1199.505n 1.8v 1209.495n 1.8v 1209.505n 0.0v 1219.495n 0.0v 1219.505n 0.0v 1229.495n 0.0v 1229.505n 0.0v 1239.495n 0.0v 1239.505n 0.0v 1249.495n 0.0v 1249.505n 0.0v 1259.495n 0.0v 1259.505n 0.0v 1269.495n 0.0v 1269.505n 1.8v 1279.495n 1.8v 1279.505n 1.8v 1289.495n 1.8v 1289.505n 1.8v 1299.495n 1.8v 1299.505n 1.8v 1309.495n 1.8v 1309.505n 1.8v 1319.495n 1.8v 1319.505n 1.8v 1329.495n 1.8v 1329.505n 1.8v 1339.495n 1.8v 1339.505n 0.0v 1349.495n 0.0v 1349.505n 0.0v 1359.495n 0.0v 1359.505n 1.8v 1369.495n 1.8v 1369.505n 1.8v 1379.495n 1.8v 1379.505n 1.8v 1389.495n 1.8v 1389.505n 0.0v 1399.495n 0.0v 1399.505n 1.8v 1409.495n 1.8v 1409.505n 0.0v 1419.495n 0.0v 1419.505n 0.0v 1429.495n 0.0v 1429.505n 1.8v 1439.495n 1.8v 1439.505n 1.8v 1449.495n 1.8v 1449.505n 1.8v 1459.495n 1.8v 1459.505n 1.8v 1469.495n 1.8v 1469.505n 1.8v 1479.495n 1.8v 1479.505n 0.0v 1489.495n 0.0v 1489.505n 1.8v 1499.495n 1.8v 1499.505n 1.8v 1509.495n 1.8v 1509.505n 0.0v 1519.495n 0.0v 1519.505n 1.8v 1529.495n 1.8v 1529.505n 0.0v 1539.495n 0.0v 1539.505n 1.8v 1549.495n 1.8v 1549.505n 0.0v 1559.495n 0.0v 1559.505n 1.8v 1569.495n 1.8v 1569.505n 0.0v 1579.495n 0.0v 1579.505n 0.0v 1589.495n 0.0v 1589.505n 0.0v 1599.495n 0.0v 1599.505n 1.8v 1609.495n 1.8v 1609.505n 0.0v 1619.495n 0.0v 1619.505n 1.8v 1629.495n 1.8v 1629.505n 1.8v 1639.495n 1.8v 1639.505n 1.8v 1649.495n 1.8v 1649.505n 1.8v 1659.495n 1.8v 1659.505n 0.0v 1669.495n 0.0v 1669.505n 1.8v 1679.495n 1.8v 1679.505n 0.0v 1689.495n 0.0v 1689.505n 0.0v 1699.495n 0.0v 1699.505n 1.8v 1709.495n 1.8v 1709.505n 0.0v 1719.495n 0.0v 1719.505n 1.8v 1729.495n 1.8v 1729.505n 0.0v 1739.495n 0.0v 1739.505n 1.8v 1749.495n 1.8v 1749.505n 1.8v 1759.495n 1.8v 1759.505n 1.8v 1769.495n 1.8v 1769.505n 1.8v 1779.495n 1.8v 1779.505n 0.0v 1789.495n 0.0v 1789.505n 1.8v 1799.495n 1.8v 1799.505n 0.0v 1809.495n 0.0v 1809.505n 1.8v 1819.495n 1.8v 1819.505n 1.8v 1829.495n 1.8v 1829.505n 1.8v 1839.495n 1.8v 1839.505n 0.0v 1849.495n 0.0v 1849.505n 0.0v 1859.495n 0.0v 1859.505n 1.8v 1869.495n 1.8v 1869.505n 1.8v 1879.495n 1.8v 1879.505n 1.8v 1889.495n 1.8v 1889.505n 1.8v 1899.495n 1.8v 1899.505n 0.0v 1909.495n 0.0v 1909.505n 1.8v 1919.495n 1.8v 1919.505n 1.8v 1929.495n 1.8v 1929.505n 1.8v 1939.495n 1.8v 1939.505n 0.0v 1949.495n 0.0v 1949.505n 0.0v 1959.495n 0.0v 1959.505n 1.8v 1969.495n 1.8v 1969.505n 0.0v 1979.495n 0.0v 1979.505n 1.8v 1989.495n 1.8v 1989.505n 0.0v 1999.495n 0.0v 1999.505n 1.8v 2009.495n 1.8v 2009.505n 1.8v 2019.495n 1.8v 2019.505n 1.8v 2029.495n 1.8v 2029.505n 1.8v 2039.495n 1.8v 2039.505n 0.0v 2049.495n 0.0v 2049.505n 1.8v )

* Generation of wmask signals
* (time, data): [(0, 0), (10, 1), (20, 1), (30, 1), (40, 1), (50, 1), (60, 1), (70, 1), (80, 1), (90, 1), (100, 1), (110, 0), (120, 0), (130, 0), (140, 0), (150, 0), (160, 0), (170, 0), (180, 0), (190, 0), (200, 1), (210, 1), (220, 1), (230, 1), (240, 1), (250, 1), (260, 1), (270, 1), (280, 1), (290, 1), (300, 1), (310, 1), (320, 0), (330, 0), (340, 0), (350, 0), (360, 0), (370, 0), (380, 0), (390, 1), (400, 0), (410, 1), (420, 1), (430, 1), (440, 1), (450, 1), (460, 1), (470, 1), (480, 1), (490, 1), (500, 1), (510, 0), (520, 0), (530, 1), (540, 1), (550, 1), (560, 1), (570, 1), (580, 1), (590, 1), (600, 0), (610, 0), (620, 0), (630, 0), (640, 0), (650, 1), (660, 1), (670, 1), (680, 1), (690, 1), (700, 1), (710, 1), (720, 1), (730, 1), (740, 1), (750, 1), (760, 1), (770, 1), (780, 1), (790, 1), (800, 1), (810, 1), (820, 1), (830, 1), (840, 1), (850, 1), (860, 1), (870, 1), (880, 1), (890, 1), (900, 1), (910, 1), (920, 1), (930, 1), (940, 1), (950, 1), (960, 1), (970, 1), (980, 1), (990, 1), (1000, 0), (1010, 0), (1020, 0), (1030, 0), (1040, 1), (1050, 1), (1060, 1), (1070, 1), (1080, 1), (1090, 1), (1100, 0), (1110, 0), (1120, 1), (1130, 1), (1140, 1), (1150, 1), (1160, 1), (1170, 1), (1180, 1), (1190, 1), (1200, 1), (1210, 1), (1220, 1), (1230, 1), (1240, 1), (1250, 1), (1260, 1), (1270, 1), (1280, 1), (1290, 1), (1300, 1), (1310, 1), (1320, 1), (1330, 1), (1340, 1), (1350, 1), (1360, 1), (1370, 1), (1380, 1), (1390, 0), (1400, 0), (1410, 1), (1420, 1), (1430, 1), (1440, 1), (1450, 1), (1460, 1), (1470, 1), (1480, 1), (1490, 1), (1500, 1), (1510, 0), (1520, 0), (1530, 0), (1540, 0), (1550, 0), (1560, 0), (1570, 1), (1580, 1), (1590, 0), (1600, 0), (1610, 0), (1620, 0), (1630, 0), (1640, 0), (1650, 0), (1660, 1), (1670, 1), (1680, 0), (1690, 1), (1700, 1), (1710, 1), (1720, 1), (1730, 1), (1740, 1), (1750, 1), (1760, 1), (1770, 1), (1780, 1), (1790, 1), (1800, 1), (1810, 1), (1820, 1), (1830, 1), (1840, 1), (1850, 1), (1860, 1), (1870, 1), (1880, 1), (1890, 1), (1900, 1), (1910, 1), (1920, 1), (1930, 1), (1940, 1), (1950, 1), (1960, 1), (1970, 1), (1980, 1), (1990, 0), (2000, 0), (2010, 0), (2020, 0), (2030, 0), (2040, 1), (2050, 1)]
VWMASK0_0  WMASK0_0  0 PWL (0n 0.0v 9.495n 0.0v 9.505n 1.8v 19.495n 1.8v 19.505n 1.8v 29.495n 1.8v 29.505n 1.8v 39.495n 1.8v 39.505n 1.8v 49.495n 1.8v 49.505n 1.8v 59.495n 1.8v 59.505n 1.8v 69.495n 1.8v 69.505n 1.8v 79.495n 1.8v 79.505n 1.8v 89.495n 1.8v 89.505n 1.8v 99.495n 1.8v 99.505n 1.8v 109.495n 1.8v 109.505n 0.0v 119.495n 0.0v 119.505n 0.0v 129.495n 0.0v 129.505n 0.0v 139.495n 0.0v 139.505n 0.0v 149.495n 0.0v 149.505n 0.0v 159.495n 0.0v 159.505n 0.0v 169.495n 0.0v 169.505n 0.0v 179.495n 0.0v 179.505n 0.0v 189.495n 0.0v 189.505n 0.0v 199.495n 0.0v 199.505n 1.8v 209.495n 1.8v 209.505n 1.8v 219.495n 1.8v 219.505n 1.8v 229.495n 1.8v 229.505n 1.8v 239.495n 1.8v 239.505n 1.8v 249.495n 1.8v 249.505n 1.8v 259.495n 1.8v 259.505n 1.8v 269.495n 1.8v 269.505n 1.8v 279.495n 1.8v 279.505n 1.8v 289.495n 1.8v 289.505n 1.8v 299.495n 1.8v 299.505n 1.8v 309.495n 1.8v 309.505n 1.8v 319.495n 1.8v 319.505n 0.0v 329.495n 0.0v 329.505n 0.0v 339.495n 0.0v 339.505n 0.0v 349.495n 0.0v 349.505n 0.0v 359.495n 0.0v 359.505n 0.0v 369.495n 0.0v 369.505n 0.0v 379.495n 0.0v 379.505n 0.0v 389.495n 0.0v 389.505n 1.8v 399.495n 1.8v 399.505n 0.0v 409.495n 0.0v 409.505n 1.8v 419.495n 1.8v 419.505n 1.8v 429.495n 1.8v 429.505n 1.8v 439.495n 1.8v 439.505n 1.8v 449.495n 1.8v 449.505n 1.8v 459.495n 1.8v 459.505n 1.8v 469.495n 1.8v 469.505n 1.8v 479.495n 1.8v 479.505n 1.8v 489.495n 1.8v 489.505n 1.8v 499.495n 1.8v 499.505n 1.8v 509.495n 1.8v 509.505n 0.0v 519.495n 0.0v 519.505n 0.0v 529.495n 0.0v 529.505n 1.8v 539.495n 1.8v 539.505n 1.8v 549.495n 1.8v 549.505n 1.8v 559.495n 1.8v 559.505n 1.8v 569.495n 1.8v 569.505n 1.8v 579.495n 1.8v 579.505n 1.8v 589.495n 1.8v 589.505n 1.8v 599.495n 1.8v 599.505n 0.0v 609.495n 0.0v 609.505n 0.0v 619.495n 0.0v 619.505n 0.0v 629.495n 0.0v 629.505n 0.0v 639.495n 0.0v 639.505n 0.0v 649.495n 0.0v 649.505n 1.8v 659.495n 1.8v 659.505n 1.8v 669.495n 1.8v 669.505n 1.8v 679.495n 1.8v 679.505n 1.8v 689.495n 1.8v 689.505n 1.8v 699.495n 1.8v 699.505n 1.8v 709.495n 1.8v 709.505n 1.8v 719.495n 1.8v 719.505n 1.8v 729.495n 1.8v 729.505n 1.8v 739.495n 1.8v 739.505n 1.8v 749.495n 1.8v 749.505n 1.8v 759.495n 1.8v 759.505n 1.8v 769.495n 1.8v 769.505n 1.8v 779.495n 1.8v 779.505n 1.8v 789.495n 1.8v 789.505n 1.8v 799.495n 1.8v 799.505n 1.8v 809.495n 1.8v 809.505n 1.8v 819.495n 1.8v 819.505n 1.8v 829.495n 1.8v 829.505n 1.8v 839.495n 1.8v 839.505n 1.8v 849.495n 1.8v 849.505n 1.8v 859.495n 1.8v 859.505n 1.8v 869.495n 1.8v 869.505n 1.8v 879.495n 1.8v 879.505n 1.8v 889.495n 1.8v 889.505n 1.8v 899.495n 1.8v 899.505n 1.8v 909.495n 1.8v 909.505n 1.8v 919.495n 1.8v 919.505n 1.8v 929.495n 1.8v 929.505n 1.8v 939.495n 1.8v 939.505n 1.8v 949.495n 1.8v 949.505n 1.8v 959.495n 1.8v 959.505n 1.8v 969.495n 1.8v 969.505n 1.8v 979.495n 1.8v 979.505n 1.8v 989.495n 1.8v 989.505n 1.8v 999.495n 1.8v 999.505n 0.0v 1009.495n 0.0v 1009.505n 0.0v 1019.495n 0.0v 1019.505n 0.0v 1029.495n 0.0v 1029.505n 0.0v 1039.495n 0.0v 1039.505n 1.8v 1049.495n 1.8v 1049.505n 1.8v 1059.495n 1.8v 1059.505n 1.8v 1069.495n 1.8v 1069.505n 1.8v 1079.495n 1.8v 1079.505n 1.8v 1089.495n 1.8v 1089.505n 1.8v 1099.495n 1.8v 1099.505n 0.0v 1109.495n 0.0v 1109.505n 0.0v 1119.495n 0.0v 1119.505n 1.8v 1129.495n 1.8v 1129.505n 1.8v 1139.495n 1.8v 1139.505n 1.8v 1149.495n 1.8v 1149.505n 1.8v 1159.495n 1.8v 1159.505n 1.8v 1169.495n 1.8v 1169.505n 1.8v 1179.495n 1.8v 1179.505n 1.8v 1189.495n 1.8v 1189.505n 1.8v 1199.495n 1.8v 1199.505n 1.8v 1209.495n 1.8v 1209.505n 1.8v 1219.495n 1.8v 1219.505n 1.8v 1229.495n 1.8v 1229.505n 1.8v 1239.495n 1.8v 1239.505n 1.8v 1249.495n 1.8v 1249.505n 1.8v 1259.495n 1.8v 1259.505n 1.8v 1269.495n 1.8v 1269.505n 1.8v 1279.495n 1.8v 1279.505n 1.8v 1289.495n 1.8v 1289.505n 1.8v 1299.495n 1.8v 1299.505n 1.8v 1309.495n 1.8v 1309.505n 1.8v 1319.495n 1.8v 1319.505n 1.8v 1329.495n 1.8v 1329.505n 1.8v 1339.495n 1.8v 1339.505n 1.8v 1349.495n 1.8v 1349.505n 1.8v 1359.495n 1.8v 1359.505n 1.8v 1369.495n 1.8v 1369.505n 1.8v 1379.495n 1.8v 1379.505n 1.8v 1389.495n 1.8v 1389.505n 0.0v 1399.495n 0.0v 1399.505n 0.0v 1409.495n 0.0v 1409.505n 1.8v 1419.495n 1.8v 1419.505n 1.8v 1429.495n 1.8v 1429.505n 1.8v 1439.495n 1.8v 1439.505n 1.8v 1449.495n 1.8v 1449.505n 1.8v 1459.495n 1.8v 1459.505n 1.8v 1469.495n 1.8v 1469.505n 1.8v 1479.495n 1.8v 1479.505n 1.8v 1489.495n 1.8v 1489.505n 1.8v 1499.495n 1.8v 1499.505n 1.8v 1509.495n 1.8v 1509.505n 0.0v 1519.495n 0.0v 1519.505n 0.0v 1529.495n 0.0v 1529.505n 0.0v 1539.495n 0.0v 1539.505n 0.0v 1549.495n 0.0v 1549.505n 0.0v 1559.495n 0.0v 1559.505n 0.0v 1569.495n 0.0v 1569.505n 1.8v 1579.495n 1.8v 1579.505n 1.8v 1589.495n 1.8v 1589.505n 0.0v 1599.495n 0.0v 1599.505n 0.0v 1609.495n 0.0v 1609.505n 0.0v 1619.495n 0.0v 1619.505n 0.0v 1629.495n 0.0v 1629.505n 0.0v 1639.495n 0.0v 1639.505n 0.0v 1649.495n 0.0v 1649.505n 0.0v 1659.495n 0.0v 1659.505n 1.8v 1669.495n 1.8v 1669.505n 1.8v 1679.495n 1.8v 1679.505n 0.0v 1689.495n 0.0v 1689.505n 1.8v 1699.495n 1.8v 1699.505n 1.8v 1709.495n 1.8v 1709.505n 1.8v 1719.495n 1.8v 1719.505n 1.8v 1729.495n 1.8v 1729.505n 1.8v 1739.495n 1.8v 1739.505n 1.8v 1749.495n 1.8v 1749.505n 1.8v 1759.495n 1.8v 1759.505n 1.8v 1769.495n 1.8v 1769.505n 1.8v 1779.495n 1.8v 1779.505n 1.8v 1789.495n 1.8v 1789.505n 1.8v 1799.495n 1.8v 1799.505n 1.8v 1809.495n 1.8v 1809.505n 1.8v 1819.495n 1.8v 1819.505n 1.8v 1829.495n 1.8v 1829.505n 1.8v 1839.495n 1.8v 1839.505n 1.8v 1849.495n 1.8v 1849.505n 1.8v 1859.495n 1.8v 1859.505n 1.8v 1869.495n 1.8v 1869.505n 1.8v 1879.495n 1.8v 1879.505n 1.8v 1889.495n 1.8v 1889.505n 1.8v 1899.495n 1.8v 1899.505n 1.8v 1909.495n 1.8v 1909.505n 1.8v 1919.495n 1.8v 1919.505n 1.8v 1929.495n 1.8v 1929.505n 1.8v 1939.495n 1.8v 1939.505n 1.8v 1949.495n 1.8v 1949.505n 1.8v 1959.495n 1.8v 1959.505n 1.8v 1969.495n 1.8v 1969.505n 1.8v 1979.495n 1.8v 1979.505n 1.8v 1989.495n 1.8v 1989.505n 0.0v 1999.495n 0.0v 1999.505n 0.0v 2009.495n 0.0v 2009.505n 0.0v 2019.495n 0.0v 2019.505n 0.0v 2029.495n 0.0v 2029.505n 0.0v 2039.495n 0.0v 2039.505n 1.8v 2049.495n 1.8v 2049.505n 1.8v )
* (time, data): [(0, 0), (10, 1), (20, 1), (30, 1), (40, 1), (50, 1), (60, 1), (70, 1), (80, 1), (90, 1), (100, 1), (110, 0), (120, 0), (130, 0), (140, 0), (150, 0), (160, 0), (170, 0), (180, 0), (190, 0), (200, 1), (210, 1), (220, 1), (230, 1), (240, 1), (250, 1), (260, 1), (270, 1), (280, 1), (290, 1), (300, 1), (310, 1), (320, 0), (330, 0), (340, 0), (350, 0), (360, 0), (370, 0), (380, 0), (390, 1), (400, 0), (410, 0), (420, 0), (430, 1), (440, 1), (450, 1), (460, 1), (470, 1), (480, 1), (490, 1), (500, 1), (510, 1), (520, 1), (530, 1), (540, 1), (550, 1), (560, 1), (570, 1), (580, 1), (590, 1), (600, 1), (610, 1), (620, 0), (630, 0), (640, 0), (650, 1), (660, 1), (670, 1), (680, 1), (690, 1), (700, 1), (710, 1), (720, 1), (730, 1), (740, 0), (750, 1), (760, 1), (770, 1), (780, 1), (790, 1), (800, 1), (810, 1), (820, 1), (830, 1), (840, 1), (850, 1), (860, 1), (870, 1), (880, 1), (890, 1), (900, 1), (910, 1), (920, 1), (930, 1), (940, 1), (950, 1), (960, 1), (970, 1), (980, 1), (990, 1), (1000, 0), (1010, 0), (1020, 0), (1030, 0), (1040, 1), (1050, 1), (1060, 1), (1070, 1), (1080, 1), (1090, 1), (1100, 0), (1110, 0), (1120, 1), (1130, 1), (1140, 1), (1150, 1), (1160, 1), (1170, 1), (1180, 1), (1190, 1), (1200, 1), (1210, 1), (1220, 0), (1230, 1), (1240, 0), (1250, 1), (1260, 1), (1270, 1), (1280, 1), (1290, 1), (1300, 1), (1310, 1), (1320, 1), (1330, 1), (1340, 1), (1350, 1), (1360, 1), (1370, 1), (1380, 1), (1390, 0), (1400, 0), (1410, 0), (1420, 1), (1430, 1), (1440, 1), (1450, 1), (1460, 1), (1470, 1), (1480, 1), (1490, 1), (1500, 1), (1510, 1), (1520, 1), (1530, 0), (1540, 0), (1550, 1), (1560, 1), (1570, 1), (1580, 1), (1590, 1), (1600, 1), (1610, 0), (1620, 0), (1630, 0), (1640, 0), (1650, 0), (1660, 1), (1670, 1), (1680, 0), (1690, 1), (1700, 1), (1710, 1), (1720, 1), (1730, 1), (1740, 1), (1750, 1), (1760, 1), (1770, 1), (1780, 1), (1790, 1), (1800, 1), (1810, 1), (1820, 1), (1830, 1), (1840, 1), (1850, 1), (1860, 1), (1870, 1), (1880, 1), (1890, 1), (1900, 1), (1910, 1), (1920, 1), (1930, 1), (1940, 1), (1950, 1), (1960, 1), (1970, 1), (1980, 1), (1990, 1), (2000, 1), (2010, 1), (2020, 1), (2030, 1), (2040, 1), (2050, 1)]
VWMASK0_1  WMASK0_1  0 PWL (0n 0.0v 9.495n 0.0v 9.505n 1.8v 19.495n 1.8v 19.505n 1.8v 29.495n 1.8v 29.505n 1.8v 39.495n 1.8v 39.505n 1.8v 49.495n 1.8v 49.505n 1.8v 59.495n 1.8v 59.505n 1.8v 69.495n 1.8v 69.505n 1.8v 79.495n 1.8v 79.505n 1.8v 89.495n 1.8v 89.505n 1.8v 99.495n 1.8v 99.505n 1.8v 109.495n 1.8v 109.505n 0.0v 119.495n 0.0v 119.505n 0.0v 129.495n 0.0v 129.505n 0.0v 139.495n 0.0v 139.505n 0.0v 149.495n 0.0v 149.505n 0.0v 159.495n 0.0v 159.505n 0.0v 169.495n 0.0v 169.505n 0.0v 179.495n 0.0v 179.505n 0.0v 189.495n 0.0v 189.505n 0.0v 199.495n 0.0v 199.505n 1.8v 209.495n 1.8v 209.505n 1.8v 219.495n 1.8v 219.505n 1.8v 229.495n 1.8v 229.505n 1.8v 239.495n 1.8v 239.505n 1.8v 249.495n 1.8v 249.505n 1.8v 259.495n 1.8v 259.505n 1.8v 269.495n 1.8v 269.505n 1.8v 279.495n 1.8v 279.505n 1.8v 289.495n 1.8v 289.505n 1.8v 299.495n 1.8v 299.505n 1.8v 309.495n 1.8v 309.505n 1.8v 319.495n 1.8v 319.505n 0.0v 329.495n 0.0v 329.505n 0.0v 339.495n 0.0v 339.505n 0.0v 349.495n 0.0v 349.505n 0.0v 359.495n 0.0v 359.505n 0.0v 369.495n 0.0v 369.505n 0.0v 379.495n 0.0v 379.505n 0.0v 389.495n 0.0v 389.505n 1.8v 399.495n 1.8v 399.505n 0.0v 409.495n 0.0v 409.505n 0.0v 419.495n 0.0v 419.505n 0.0v 429.495n 0.0v 429.505n 1.8v 439.495n 1.8v 439.505n 1.8v 449.495n 1.8v 449.505n 1.8v 459.495n 1.8v 459.505n 1.8v 469.495n 1.8v 469.505n 1.8v 479.495n 1.8v 479.505n 1.8v 489.495n 1.8v 489.505n 1.8v 499.495n 1.8v 499.505n 1.8v 509.495n 1.8v 509.505n 1.8v 519.495n 1.8v 519.505n 1.8v 529.495n 1.8v 529.505n 1.8v 539.495n 1.8v 539.505n 1.8v 549.495n 1.8v 549.505n 1.8v 559.495n 1.8v 559.505n 1.8v 569.495n 1.8v 569.505n 1.8v 579.495n 1.8v 579.505n 1.8v 589.495n 1.8v 589.505n 1.8v 599.495n 1.8v 599.505n 1.8v 609.495n 1.8v 609.505n 1.8v 619.495n 1.8v 619.505n 0.0v 629.495n 0.0v 629.505n 0.0v 639.495n 0.0v 639.505n 0.0v 649.495n 0.0v 649.505n 1.8v 659.495n 1.8v 659.505n 1.8v 669.495n 1.8v 669.505n 1.8v 679.495n 1.8v 679.505n 1.8v 689.495n 1.8v 689.505n 1.8v 699.495n 1.8v 699.505n 1.8v 709.495n 1.8v 709.505n 1.8v 719.495n 1.8v 719.505n 1.8v 729.495n 1.8v 729.505n 1.8v 739.495n 1.8v 739.505n 0.0v 749.495n 0.0v 749.505n 1.8v 759.495n 1.8v 759.505n 1.8v 769.495n 1.8v 769.505n 1.8v 779.495n 1.8v 779.505n 1.8v 789.495n 1.8v 789.505n 1.8v 799.495n 1.8v 799.505n 1.8v 809.495n 1.8v 809.505n 1.8v 819.495n 1.8v 819.505n 1.8v 829.495n 1.8v 829.505n 1.8v 839.495n 1.8v 839.505n 1.8v 849.495n 1.8v 849.505n 1.8v 859.495n 1.8v 859.505n 1.8v 869.495n 1.8v 869.505n 1.8v 879.495n 1.8v 879.505n 1.8v 889.495n 1.8v 889.505n 1.8v 899.495n 1.8v 899.505n 1.8v 909.495n 1.8v 909.505n 1.8v 919.495n 1.8v 919.505n 1.8v 929.495n 1.8v 929.505n 1.8v 939.495n 1.8v 939.505n 1.8v 949.495n 1.8v 949.505n 1.8v 959.495n 1.8v 959.505n 1.8v 969.495n 1.8v 969.505n 1.8v 979.495n 1.8v 979.505n 1.8v 989.495n 1.8v 989.505n 1.8v 999.495n 1.8v 999.505n 0.0v 1009.495n 0.0v 1009.505n 0.0v 1019.495n 0.0v 1019.505n 0.0v 1029.495n 0.0v 1029.505n 0.0v 1039.495n 0.0v 1039.505n 1.8v 1049.495n 1.8v 1049.505n 1.8v 1059.495n 1.8v 1059.505n 1.8v 1069.495n 1.8v 1069.505n 1.8v 1079.495n 1.8v 1079.505n 1.8v 1089.495n 1.8v 1089.505n 1.8v 1099.495n 1.8v 1099.505n 0.0v 1109.495n 0.0v 1109.505n 0.0v 1119.495n 0.0v 1119.505n 1.8v 1129.495n 1.8v 1129.505n 1.8v 1139.495n 1.8v 1139.505n 1.8v 1149.495n 1.8v 1149.505n 1.8v 1159.495n 1.8v 1159.505n 1.8v 1169.495n 1.8v 1169.505n 1.8v 1179.495n 1.8v 1179.505n 1.8v 1189.495n 1.8v 1189.505n 1.8v 1199.495n 1.8v 1199.505n 1.8v 1209.495n 1.8v 1209.505n 1.8v 1219.495n 1.8v 1219.505n 0.0v 1229.495n 0.0v 1229.505n 1.8v 1239.495n 1.8v 1239.505n 0.0v 1249.495n 0.0v 1249.505n 1.8v 1259.495n 1.8v 1259.505n 1.8v 1269.495n 1.8v 1269.505n 1.8v 1279.495n 1.8v 1279.505n 1.8v 1289.495n 1.8v 1289.505n 1.8v 1299.495n 1.8v 1299.505n 1.8v 1309.495n 1.8v 1309.505n 1.8v 1319.495n 1.8v 1319.505n 1.8v 1329.495n 1.8v 1329.505n 1.8v 1339.495n 1.8v 1339.505n 1.8v 1349.495n 1.8v 1349.505n 1.8v 1359.495n 1.8v 1359.505n 1.8v 1369.495n 1.8v 1369.505n 1.8v 1379.495n 1.8v 1379.505n 1.8v 1389.495n 1.8v 1389.505n 0.0v 1399.495n 0.0v 1399.505n 0.0v 1409.495n 0.0v 1409.505n 0.0v 1419.495n 0.0v 1419.505n 1.8v 1429.495n 1.8v 1429.505n 1.8v 1439.495n 1.8v 1439.505n 1.8v 1449.495n 1.8v 1449.505n 1.8v 1459.495n 1.8v 1459.505n 1.8v 1469.495n 1.8v 1469.505n 1.8v 1479.495n 1.8v 1479.505n 1.8v 1489.495n 1.8v 1489.505n 1.8v 1499.495n 1.8v 1499.505n 1.8v 1509.495n 1.8v 1509.505n 1.8v 1519.495n 1.8v 1519.505n 1.8v 1529.495n 1.8v 1529.505n 0.0v 1539.495n 0.0v 1539.505n 0.0v 1549.495n 0.0v 1549.505n 1.8v 1559.495n 1.8v 1559.505n 1.8v 1569.495n 1.8v 1569.505n 1.8v 1579.495n 1.8v 1579.505n 1.8v 1589.495n 1.8v 1589.505n 1.8v 1599.495n 1.8v 1599.505n 1.8v 1609.495n 1.8v 1609.505n 0.0v 1619.495n 0.0v 1619.505n 0.0v 1629.495n 0.0v 1629.505n 0.0v 1639.495n 0.0v 1639.505n 0.0v 1649.495n 0.0v 1649.505n 0.0v 1659.495n 0.0v 1659.505n 1.8v 1669.495n 1.8v 1669.505n 1.8v 1679.495n 1.8v 1679.505n 0.0v 1689.495n 0.0v 1689.505n 1.8v 1699.495n 1.8v 1699.505n 1.8v 1709.495n 1.8v 1709.505n 1.8v 1719.495n 1.8v 1719.505n 1.8v 1729.495n 1.8v 1729.505n 1.8v 1739.495n 1.8v 1739.505n 1.8v 1749.495n 1.8v 1749.505n 1.8v 1759.495n 1.8v 1759.505n 1.8v 1769.495n 1.8v 1769.505n 1.8v 1779.495n 1.8v 1779.505n 1.8v 1789.495n 1.8v 1789.505n 1.8v 1799.495n 1.8v 1799.505n 1.8v 1809.495n 1.8v 1809.505n 1.8v 1819.495n 1.8v 1819.505n 1.8v 1829.495n 1.8v 1829.505n 1.8v 1839.495n 1.8v 1839.505n 1.8v 1849.495n 1.8v 1849.505n 1.8v 1859.495n 1.8v 1859.505n 1.8v 1869.495n 1.8v 1869.505n 1.8v 1879.495n 1.8v 1879.505n 1.8v 1889.495n 1.8v 1889.505n 1.8v 1899.495n 1.8v 1899.505n 1.8v 1909.495n 1.8v 1909.505n 1.8v 1919.495n 1.8v 1919.505n 1.8v 1929.495n 1.8v 1929.505n 1.8v 1939.495n 1.8v 1939.505n 1.8v 1949.495n 1.8v 1949.505n 1.8v 1959.495n 1.8v 1959.505n 1.8v 1969.495n 1.8v 1969.505n 1.8v 1979.495n 1.8v 1979.505n 1.8v 1989.495n 1.8v 1989.505n 1.8v 1999.495n 1.8v 1999.505n 1.8v 2009.495n 1.8v 2009.505n 1.8v 2019.495n 1.8v 2019.505n 1.8v 2029.495n 1.8v 2029.505n 1.8v 2039.495n 1.8v 2039.505n 1.8v 2049.495n 1.8v 2049.505n 1.8v )
* (time, data): [(0, 0), (10, 1), (20, 1), (30, 1), (40, 1), (50, 1), (60, 1), (70, 1), (80, 1), (90, 1), (100, 1), (110, 0), (120, 0), (130, 0), (140, 0), (150, 0), (160, 0), (170, 1), (180, 1), (190, 1), (200, 1), (210, 1), (220, 1), (230, 1), (240, 1), (250, 1), (260, 1), (270, 1), (280, 1), (290, 1), (300, 1), (310, 1), (320, 1), (330, 1), (340, 0), (350, 0), (360, 0), (370, 0), (380, 0), (390, 1), (400, 1), (410, 1), (420, 1), (430, 1), (440, 1), (450, 1), (460, 1), (470, 1), (480, 1), (490, 1), (500, 1), (510, 1), (520, 1), (530, 1), (540, 1), (550, 1), (560, 1), (570, 1), (580, 1), (590, 1), (600, 1), (610, 1), (620, 0), (630, 0), (640, 0), (650, 1), (660, 1), (670, 1), (680, 1), (690, 1), (700, 1), (710, 1), (720, 1), (730, 1), (740, 0), (750, 1), (760, 1), (770, 1), (780, 1), (790, 1), (800, 1), (810, 1), (820, 1), (830, 1), (840, 1), (850, 1), (860, 1), (870, 1), (880, 1), (890, 1), (900, 1), (910, 1), (920, 1), (930, 1), (940, 1), (950, 1), (960, 1), (970, 1), (980, 1), (990, 1), (1000, 1), (1010, 1), (1020, 1), (1030, 1), (1040, 1), (1050, 1), (1060, 1), (1070, 1), (1080, 1), (1090, 1), (1100, 1), (1110, 1), (1120, 1), (1130, 1), (1140, 1), (1150, 1), (1160, 1), (1170, 1), (1180, 1), (1190, 1), (1200, 1), (1210, 0), (1220, 1), (1230, 1), (1240, 0), (1250, 1), (1260, 1), (1270, 1), (1280, 1), (1290, 1), (1300, 1), (1310, 1), (1320, 1), (1330, 1), (1340, 1), (1350, 0), (1360, 0), (1370, 0), (1380, 0), (1390, 1), (1400, 1), (1410, 1), (1420, 1), (1430, 1), (1440, 1), (1450, 1), (1460, 1), (1470, 1), (1480, 1), (1490, 1), (1500, 1), (1510, 1), (1520, 1), (1530, 0), (1540, 0), (1550, 0), (1560, 0), (1570, 1), (1580, 1), (1590, 1), (1600, 1), (1610, 1), (1620, 1), (1630, 1), (1640, 1), (1650, 1), (1660, 1), (1670, 1), (1680, 0), (1690, 1), (1700, 1), (1710, 1), (1720, 1), (1730, 1), (1740, 1), (1750, 1), (1760, 1), (1770, 1), (1780, 1), (1790, 1), (1800, 1), (1810, 1), (1820, 1), (1830, 1), (1840, 0), (1850, 1), (1860, 1), (1870, 1), (1880, 1), (1890, 1), (1900, 1), (1910, 1), (1920, 1), (1930, 1), (1940, 1), (1950, 1), (1960, 1), (1970, 1), (1980, 1), (1990, 0), (2000, 0), (2010, 0), (2020, 0), (2030, 0), (2040, 1), (2050, 1)]
VWMASK0_2  WMASK0_2  0 PWL (0n 0.0v 9.495n 0.0v 9.505n 1.8v 19.495n 1.8v 19.505n 1.8v 29.495n 1.8v 29.505n 1.8v 39.495n 1.8v 39.505n 1.8v 49.495n 1.8v 49.505n 1.8v 59.495n 1.8v 59.505n 1.8v 69.495n 1.8v 69.505n 1.8v 79.495n 1.8v 79.505n 1.8v 89.495n 1.8v 89.505n 1.8v 99.495n 1.8v 99.505n 1.8v 109.495n 1.8v 109.505n 0.0v 119.495n 0.0v 119.505n 0.0v 129.495n 0.0v 129.505n 0.0v 139.495n 0.0v 139.505n 0.0v 149.495n 0.0v 149.505n 0.0v 159.495n 0.0v 159.505n 0.0v 169.495n 0.0v 169.505n 1.8v 179.495n 1.8v 179.505n 1.8v 189.495n 1.8v 189.505n 1.8v 199.495n 1.8v 199.505n 1.8v 209.495n 1.8v 209.505n 1.8v 219.495n 1.8v 219.505n 1.8v 229.495n 1.8v 229.505n 1.8v 239.495n 1.8v 239.505n 1.8v 249.495n 1.8v 249.505n 1.8v 259.495n 1.8v 259.505n 1.8v 269.495n 1.8v 269.505n 1.8v 279.495n 1.8v 279.505n 1.8v 289.495n 1.8v 289.505n 1.8v 299.495n 1.8v 299.505n 1.8v 309.495n 1.8v 309.505n 1.8v 319.495n 1.8v 319.505n 1.8v 329.495n 1.8v 329.505n 1.8v 339.495n 1.8v 339.505n 0.0v 349.495n 0.0v 349.505n 0.0v 359.495n 0.0v 359.505n 0.0v 369.495n 0.0v 369.505n 0.0v 379.495n 0.0v 379.505n 0.0v 389.495n 0.0v 389.505n 1.8v 399.495n 1.8v 399.505n 1.8v 409.495n 1.8v 409.505n 1.8v 419.495n 1.8v 419.505n 1.8v 429.495n 1.8v 429.505n 1.8v 439.495n 1.8v 439.505n 1.8v 449.495n 1.8v 449.505n 1.8v 459.495n 1.8v 459.505n 1.8v 469.495n 1.8v 469.505n 1.8v 479.495n 1.8v 479.505n 1.8v 489.495n 1.8v 489.505n 1.8v 499.495n 1.8v 499.505n 1.8v 509.495n 1.8v 509.505n 1.8v 519.495n 1.8v 519.505n 1.8v 529.495n 1.8v 529.505n 1.8v 539.495n 1.8v 539.505n 1.8v 549.495n 1.8v 549.505n 1.8v 559.495n 1.8v 559.505n 1.8v 569.495n 1.8v 569.505n 1.8v 579.495n 1.8v 579.505n 1.8v 589.495n 1.8v 589.505n 1.8v 599.495n 1.8v 599.505n 1.8v 609.495n 1.8v 609.505n 1.8v 619.495n 1.8v 619.505n 0.0v 629.495n 0.0v 629.505n 0.0v 639.495n 0.0v 639.505n 0.0v 649.495n 0.0v 649.505n 1.8v 659.495n 1.8v 659.505n 1.8v 669.495n 1.8v 669.505n 1.8v 679.495n 1.8v 679.505n 1.8v 689.495n 1.8v 689.505n 1.8v 699.495n 1.8v 699.505n 1.8v 709.495n 1.8v 709.505n 1.8v 719.495n 1.8v 719.505n 1.8v 729.495n 1.8v 729.505n 1.8v 739.495n 1.8v 739.505n 0.0v 749.495n 0.0v 749.505n 1.8v 759.495n 1.8v 759.505n 1.8v 769.495n 1.8v 769.505n 1.8v 779.495n 1.8v 779.505n 1.8v 789.495n 1.8v 789.505n 1.8v 799.495n 1.8v 799.505n 1.8v 809.495n 1.8v 809.505n 1.8v 819.495n 1.8v 819.505n 1.8v 829.495n 1.8v 829.505n 1.8v 839.495n 1.8v 839.505n 1.8v 849.495n 1.8v 849.505n 1.8v 859.495n 1.8v 859.505n 1.8v 869.495n 1.8v 869.505n 1.8v 879.495n 1.8v 879.505n 1.8v 889.495n 1.8v 889.505n 1.8v 899.495n 1.8v 899.505n 1.8v 909.495n 1.8v 909.505n 1.8v 919.495n 1.8v 919.505n 1.8v 929.495n 1.8v 929.505n 1.8v 939.495n 1.8v 939.505n 1.8v 949.495n 1.8v 949.505n 1.8v 959.495n 1.8v 959.505n 1.8v 969.495n 1.8v 969.505n 1.8v 979.495n 1.8v 979.505n 1.8v 989.495n 1.8v 989.505n 1.8v 999.495n 1.8v 999.505n 1.8v 1009.495n 1.8v 1009.505n 1.8v 1019.495n 1.8v 1019.505n 1.8v 1029.495n 1.8v 1029.505n 1.8v 1039.495n 1.8v 1039.505n 1.8v 1049.495n 1.8v 1049.505n 1.8v 1059.495n 1.8v 1059.505n 1.8v 1069.495n 1.8v 1069.505n 1.8v 1079.495n 1.8v 1079.505n 1.8v 1089.495n 1.8v 1089.505n 1.8v 1099.495n 1.8v 1099.505n 1.8v 1109.495n 1.8v 1109.505n 1.8v 1119.495n 1.8v 1119.505n 1.8v 1129.495n 1.8v 1129.505n 1.8v 1139.495n 1.8v 1139.505n 1.8v 1149.495n 1.8v 1149.505n 1.8v 1159.495n 1.8v 1159.505n 1.8v 1169.495n 1.8v 1169.505n 1.8v 1179.495n 1.8v 1179.505n 1.8v 1189.495n 1.8v 1189.505n 1.8v 1199.495n 1.8v 1199.505n 1.8v 1209.495n 1.8v 1209.505n 0.0v 1219.495n 0.0v 1219.505n 1.8v 1229.495n 1.8v 1229.505n 1.8v 1239.495n 1.8v 1239.505n 0.0v 1249.495n 0.0v 1249.505n 1.8v 1259.495n 1.8v 1259.505n 1.8v 1269.495n 1.8v 1269.505n 1.8v 1279.495n 1.8v 1279.505n 1.8v 1289.495n 1.8v 1289.505n 1.8v 1299.495n 1.8v 1299.505n 1.8v 1309.495n 1.8v 1309.505n 1.8v 1319.495n 1.8v 1319.505n 1.8v 1329.495n 1.8v 1329.505n 1.8v 1339.495n 1.8v 1339.505n 1.8v 1349.495n 1.8v 1349.505n 0.0v 1359.495n 0.0v 1359.505n 0.0v 1369.495n 0.0v 1369.505n 0.0v 1379.495n 0.0v 1379.505n 0.0v 1389.495n 0.0v 1389.505n 1.8v 1399.495n 1.8v 1399.505n 1.8v 1409.495n 1.8v 1409.505n 1.8v 1419.495n 1.8v 1419.505n 1.8v 1429.495n 1.8v 1429.505n 1.8v 1439.495n 1.8v 1439.505n 1.8v 1449.495n 1.8v 1449.505n 1.8v 1459.495n 1.8v 1459.505n 1.8v 1469.495n 1.8v 1469.505n 1.8v 1479.495n 1.8v 1479.505n 1.8v 1489.495n 1.8v 1489.505n 1.8v 1499.495n 1.8v 1499.505n 1.8v 1509.495n 1.8v 1509.505n 1.8v 1519.495n 1.8v 1519.505n 1.8v 1529.495n 1.8v 1529.505n 0.0v 1539.495n 0.0v 1539.505n 0.0v 1549.495n 0.0v 1549.505n 0.0v 1559.495n 0.0v 1559.505n 0.0v 1569.495n 0.0v 1569.505n 1.8v 1579.495n 1.8v 1579.505n 1.8v 1589.495n 1.8v 1589.505n 1.8v 1599.495n 1.8v 1599.505n 1.8v 1609.495n 1.8v 1609.505n 1.8v 1619.495n 1.8v 1619.505n 1.8v 1629.495n 1.8v 1629.505n 1.8v 1639.495n 1.8v 1639.505n 1.8v 1649.495n 1.8v 1649.505n 1.8v 1659.495n 1.8v 1659.505n 1.8v 1669.495n 1.8v 1669.505n 1.8v 1679.495n 1.8v 1679.505n 0.0v 1689.495n 0.0v 1689.505n 1.8v 1699.495n 1.8v 1699.505n 1.8v 1709.495n 1.8v 1709.505n 1.8v 1719.495n 1.8v 1719.505n 1.8v 1729.495n 1.8v 1729.505n 1.8v 1739.495n 1.8v 1739.505n 1.8v 1749.495n 1.8v 1749.505n 1.8v 1759.495n 1.8v 1759.505n 1.8v 1769.495n 1.8v 1769.505n 1.8v 1779.495n 1.8v 1779.505n 1.8v 1789.495n 1.8v 1789.505n 1.8v 1799.495n 1.8v 1799.505n 1.8v 1809.495n 1.8v 1809.505n 1.8v 1819.495n 1.8v 1819.505n 1.8v 1829.495n 1.8v 1829.505n 1.8v 1839.495n 1.8v 1839.505n 0.0v 1849.495n 0.0v 1849.505n 1.8v 1859.495n 1.8v 1859.505n 1.8v 1869.495n 1.8v 1869.505n 1.8v 1879.495n 1.8v 1879.505n 1.8v 1889.495n 1.8v 1889.505n 1.8v 1899.495n 1.8v 1899.505n 1.8v 1909.495n 1.8v 1909.505n 1.8v 1919.495n 1.8v 1919.505n 1.8v 1929.495n 1.8v 1929.505n 1.8v 1939.495n 1.8v 1939.505n 1.8v 1949.495n 1.8v 1949.505n 1.8v 1959.495n 1.8v 1959.505n 1.8v 1969.495n 1.8v 1969.505n 1.8v 1979.495n 1.8v 1979.505n 1.8v 1989.495n 1.8v 1989.505n 0.0v 1999.495n 0.0v 1999.505n 0.0v 2009.495n 0.0v 2009.505n 0.0v 2019.495n 0.0v 2019.505n 0.0v 2029.495n 0.0v 2029.505n 0.0v 2039.495n 0.0v 2039.505n 1.8v 2049.495n 1.8v 2049.505n 1.8v )
* (time, data): [(0, 0), (10, 1), (20, 1), (30, 1), (40, 1), (50, 1), (60, 1), (70, 1), (80, 1), (90, 1), (100, 1), (110, 1), (120, 1), (130, 1), (140, 1), (150, 1), (160, 1), (170, 0), (180, 0), (190, 0), (200, 1), (210, 1), (220, 1), (230, 1), (240, 1), (250, 1), (260, 1), (270, 1), (280, 1), (290, 1), (300, 1), (310, 1), (320, 1), (330, 1), (340, 1), (350, 1), (360, 1), (370, 1), (380, 1), (390, 1), (400, 0), (410, 1), (420, 1), (430, 1), (440, 1), (450, 1), (460, 1), (470, 1), (480, 1), (490, 1), (500, 1), (510, 0), (520, 0), (530, 1), (540, 1), (550, 1), (560, 1), (570, 1), (580, 1), (590, 1), (600, 1), (610, 1), (620, 1), (630, 1), (640, 1), (650, 1), (660, 1), (670, 1), (680, 1), (690, 1), (700, 1), (710, 1), (720, 1), (730, 1), (740, 0), (750, 1), (760, 1), (770, 1), (780, 1), (790, 1), (800, 1), (810, 1), (820, 1), (830, 1), (840, 1), (850, 1), (860, 1), (870, 1), (880, 1), (890, 1), (900, 1), (910, 1), (920, 1), (930, 1), (940, 1), (950, 1), (960, 1), (970, 1), (980, 1), (990, 1), (1000, 0), (1010, 0), (1020, 0), (1030, 0), (1040, 1), (1050, 1), (1060, 1), (1070, 1), (1080, 1), (1090, 1), (1100, 0), (1110, 0), (1120, 1), (1130, 1), (1140, 1), (1150, 1), (1160, 1), (1170, 1), (1180, 1), (1190, 1), (1200, 1), (1210, 0), (1220, 0), (1230, 1), (1240, 0), (1250, 1), (1260, 1), (1270, 1), (1280, 1), (1290, 1), (1300, 1), (1310, 1), (1320, 1), (1330, 1), (1340, 1), (1350, 0), (1360, 0), (1370, 0), (1380, 0), (1390, 0), (1400, 0), (1410, 1), (1420, 1), (1430, 1), (1440, 1), (1450, 1), (1460, 1), (1470, 1), (1480, 0), (1490, 0), (1500, 0), (1510, 0), (1520, 0), (1530, 1), (1540, 1), (1550, 0), (1560, 0), (1570, 0), (1580, 0), (1590, 1), (1600, 1), (1610, 1), (1620, 1), (1630, 1), (1640, 1), (1650, 1), (1660, 1), (1670, 1), (1680, 1), (1690, 1), (1700, 1), (1710, 1), (1720, 1), (1730, 1), (1740, 1), (1750, 1), (1760, 1), (1770, 1), (1780, 1), (1790, 1), (1800, 1), (1810, 1), (1820, 1), (1830, 1), (1840, 0), (1850, 1), (1860, 1), (1870, 1), (1880, 1), (1890, 1), (1900, 1), (1910, 1), (1920, 1), (1930, 1), (1940, 1), (1950, 1), (1960, 1), (1970, 1), (1980, 1), (1990, 1), (2000, 1), (2010, 1), (2020, 1), (2030, 1), (2040, 1), (2050, 1)]
VWMASK0_3  WMASK0_3  0 PWL (0n 0.0v 9.495n 0.0v 9.505n 1.8v 19.495n 1.8v 19.505n 1.8v 29.495n 1.8v 29.505n 1.8v 39.495n 1.8v 39.505n 1.8v 49.495n 1.8v 49.505n 1.8v 59.495n 1.8v 59.505n 1.8v 69.495n 1.8v 69.505n 1.8v 79.495n 1.8v 79.505n 1.8v 89.495n 1.8v 89.505n 1.8v 99.495n 1.8v 99.505n 1.8v 109.495n 1.8v 109.505n 1.8v 119.495n 1.8v 119.505n 1.8v 129.495n 1.8v 129.505n 1.8v 139.495n 1.8v 139.505n 1.8v 149.495n 1.8v 149.505n 1.8v 159.495n 1.8v 159.505n 1.8v 169.495n 1.8v 169.505n 0.0v 179.495n 0.0v 179.505n 0.0v 189.495n 0.0v 189.505n 0.0v 199.495n 0.0v 199.505n 1.8v 209.495n 1.8v 209.505n 1.8v 219.495n 1.8v 219.505n 1.8v 229.495n 1.8v 229.505n 1.8v 239.495n 1.8v 239.505n 1.8v 249.495n 1.8v 249.505n 1.8v 259.495n 1.8v 259.505n 1.8v 269.495n 1.8v 269.505n 1.8v 279.495n 1.8v 279.505n 1.8v 289.495n 1.8v 289.505n 1.8v 299.495n 1.8v 299.505n 1.8v 309.495n 1.8v 309.505n 1.8v 319.495n 1.8v 319.505n 1.8v 329.495n 1.8v 329.505n 1.8v 339.495n 1.8v 339.505n 1.8v 349.495n 1.8v 349.505n 1.8v 359.495n 1.8v 359.505n 1.8v 369.495n 1.8v 369.505n 1.8v 379.495n 1.8v 379.505n 1.8v 389.495n 1.8v 389.505n 1.8v 399.495n 1.8v 399.505n 0.0v 409.495n 0.0v 409.505n 1.8v 419.495n 1.8v 419.505n 1.8v 429.495n 1.8v 429.505n 1.8v 439.495n 1.8v 439.505n 1.8v 449.495n 1.8v 449.505n 1.8v 459.495n 1.8v 459.505n 1.8v 469.495n 1.8v 469.505n 1.8v 479.495n 1.8v 479.505n 1.8v 489.495n 1.8v 489.505n 1.8v 499.495n 1.8v 499.505n 1.8v 509.495n 1.8v 509.505n 0.0v 519.495n 0.0v 519.505n 0.0v 529.495n 0.0v 529.505n 1.8v 539.495n 1.8v 539.505n 1.8v 549.495n 1.8v 549.505n 1.8v 559.495n 1.8v 559.505n 1.8v 569.495n 1.8v 569.505n 1.8v 579.495n 1.8v 579.505n 1.8v 589.495n 1.8v 589.505n 1.8v 599.495n 1.8v 599.505n 1.8v 609.495n 1.8v 609.505n 1.8v 619.495n 1.8v 619.505n 1.8v 629.495n 1.8v 629.505n 1.8v 639.495n 1.8v 639.505n 1.8v 649.495n 1.8v 649.505n 1.8v 659.495n 1.8v 659.505n 1.8v 669.495n 1.8v 669.505n 1.8v 679.495n 1.8v 679.505n 1.8v 689.495n 1.8v 689.505n 1.8v 699.495n 1.8v 699.505n 1.8v 709.495n 1.8v 709.505n 1.8v 719.495n 1.8v 719.505n 1.8v 729.495n 1.8v 729.505n 1.8v 739.495n 1.8v 739.505n 0.0v 749.495n 0.0v 749.505n 1.8v 759.495n 1.8v 759.505n 1.8v 769.495n 1.8v 769.505n 1.8v 779.495n 1.8v 779.505n 1.8v 789.495n 1.8v 789.505n 1.8v 799.495n 1.8v 799.505n 1.8v 809.495n 1.8v 809.505n 1.8v 819.495n 1.8v 819.505n 1.8v 829.495n 1.8v 829.505n 1.8v 839.495n 1.8v 839.505n 1.8v 849.495n 1.8v 849.505n 1.8v 859.495n 1.8v 859.505n 1.8v 869.495n 1.8v 869.505n 1.8v 879.495n 1.8v 879.505n 1.8v 889.495n 1.8v 889.505n 1.8v 899.495n 1.8v 899.505n 1.8v 909.495n 1.8v 909.505n 1.8v 919.495n 1.8v 919.505n 1.8v 929.495n 1.8v 929.505n 1.8v 939.495n 1.8v 939.505n 1.8v 949.495n 1.8v 949.505n 1.8v 959.495n 1.8v 959.505n 1.8v 969.495n 1.8v 969.505n 1.8v 979.495n 1.8v 979.505n 1.8v 989.495n 1.8v 989.505n 1.8v 999.495n 1.8v 999.505n 0.0v 1009.495n 0.0v 1009.505n 0.0v 1019.495n 0.0v 1019.505n 0.0v 1029.495n 0.0v 1029.505n 0.0v 1039.495n 0.0v 1039.505n 1.8v 1049.495n 1.8v 1049.505n 1.8v 1059.495n 1.8v 1059.505n 1.8v 1069.495n 1.8v 1069.505n 1.8v 1079.495n 1.8v 1079.505n 1.8v 1089.495n 1.8v 1089.505n 1.8v 1099.495n 1.8v 1099.505n 0.0v 1109.495n 0.0v 1109.505n 0.0v 1119.495n 0.0v 1119.505n 1.8v 1129.495n 1.8v 1129.505n 1.8v 1139.495n 1.8v 1139.505n 1.8v 1149.495n 1.8v 1149.505n 1.8v 1159.495n 1.8v 1159.505n 1.8v 1169.495n 1.8v 1169.505n 1.8v 1179.495n 1.8v 1179.505n 1.8v 1189.495n 1.8v 1189.505n 1.8v 1199.495n 1.8v 1199.505n 1.8v 1209.495n 1.8v 1209.505n 0.0v 1219.495n 0.0v 1219.505n 0.0v 1229.495n 0.0v 1229.505n 1.8v 1239.495n 1.8v 1239.505n 0.0v 1249.495n 0.0v 1249.505n 1.8v 1259.495n 1.8v 1259.505n 1.8v 1269.495n 1.8v 1269.505n 1.8v 1279.495n 1.8v 1279.505n 1.8v 1289.495n 1.8v 1289.505n 1.8v 1299.495n 1.8v 1299.505n 1.8v 1309.495n 1.8v 1309.505n 1.8v 1319.495n 1.8v 1319.505n 1.8v 1329.495n 1.8v 1329.505n 1.8v 1339.495n 1.8v 1339.505n 1.8v 1349.495n 1.8v 1349.505n 0.0v 1359.495n 0.0v 1359.505n 0.0v 1369.495n 0.0v 1369.505n 0.0v 1379.495n 0.0v 1379.505n 0.0v 1389.495n 0.0v 1389.505n 0.0v 1399.495n 0.0v 1399.505n 0.0v 1409.495n 0.0v 1409.505n 1.8v 1419.495n 1.8v 1419.505n 1.8v 1429.495n 1.8v 1429.505n 1.8v 1439.495n 1.8v 1439.505n 1.8v 1449.495n 1.8v 1449.505n 1.8v 1459.495n 1.8v 1459.505n 1.8v 1469.495n 1.8v 1469.505n 1.8v 1479.495n 1.8v 1479.505n 0.0v 1489.495n 0.0v 1489.505n 0.0v 1499.495n 0.0v 1499.505n 0.0v 1509.495n 0.0v 1509.505n 0.0v 1519.495n 0.0v 1519.505n 0.0v 1529.495n 0.0v 1529.505n 1.8v 1539.495n 1.8v 1539.505n 1.8v 1549.495n 1.8v 1549.505n 0.0v 1559.495n 0.0v 1559.505n 0.0v 1569.495n 0.0v 1569.505n 0.0v 1579.495n 0.0v 1579.505n 0.0v 1589.495n 0.0v 1589.505n 1.8v 1599.495n 1.8v 1599.505n 1.8v 1609.495n 1.8v 1609.505n 1.8v 1619.495n 1.8v 1619.505n 1.8v 1629.495n 1.8v 1629.505n 1.8v 1639.495n 1.8v 1639.505n 1.8v 1649.495n 1.8v 1649.505n 1.8v 1659.495n 1.8v 1659.505n 1.8v 1669.495n 1.8v 1669.505n 1.8v 1679.495n 1.8v 1679.505n 1.8v 1689.495n 1.8v 1689.505n 1.8v 1699.495n 1.8v 1699.505n 1.8v 1709.495n 1.8v 1709.505n 1.8v 1719.495n 1.8v 1719.505n 1.8v 1729.495n 1.8v 1729.505n 1.8v 1739.495n 1.8v 1739.505n 1.8v 1749.495n 1.8v 1749.505n 1.8v 1759.495n 1.8v 1759.505n 1.8v 1769.495n 1.8v 1769.505n 1.8v 1779.495n 1.8v 1779.505n 1.8v 1789.495n 1.8v 1789.505n 1.8v 1799.495n 1.8v 1799.505n 1.8v 1809.495n 1.8v 1809.505n 1.8v 1819.495n 1.8v 1819.505n 1.8v 1829.495n 1.8v 1829.505n 1.8v 1839.495n 1.8v 1839.505n 0.0v 1849.495n 0.0v 1849.505n 1.8v 1859.495n 1.8v 1859.505n 1.8v 1869.495n 1.8v 1869.505n 1.8v 1879.495n 1.8v 1879.505n 1.8v 1889.495n 1.8v 1889.505n 1.8v 1899.495n 1.8v 1899.505n 1.8v 1909.495n 1.8v 1909.505n 1.8v 1919.495n 1.8v 1919.505n 1.8v 1929.495n 1.8v 1929.505n 1.8v 1939.495n 1.8v 1939.505n 1.8v 1949.495n 1.8v 1949.505n 1.8v 1959.495n 1.8v 1959.505n 1.8v 1969.495n 1.8v 1969.505n 1.8v 1979.495n 1.8v 1979.505n 1.8v 1989.495n 1.8v 1989.505n 1.8v 1999.495n 1.8v 1999.505n 1.8v 2009.495n 1.8v 2009.505n 1.8v 2019.495n 1.8v 2019.505n 1.8v 2029.495n 1.8v 2029.505n 1.8v 2039.495n 1.8v 2039.505n 1.8v 2049.495n 1.8v 2049.505n 1.8v )
* PULSE: period=10
Vclk0 clk0 0 PULSE (0 1.8 9.995n 0.01n 0.01n 4.99n 10n)
* PULSE: period=10
Vclk1 clk1 0 PULSE (0 1.8 9.995n 0.01n 0.01n 4.99n 10n)

 * Generation of dout measurements
* CHECK dout0_0 vdout0_0ck4 = 0 time = 50
* CHECK dout0_1 vdout0_1ck4 = 0 time = 50
* CHECK dout0_2 vdout0_2ck4 = 1.8 time = 50
* CHECK dout0_3 vdout0_3ck4 = 0 time = 50
* CHECK dout0_4 vdout0_4ck4 = 1.8 time = 50
* CHECK dout0_5 vdout0_5ck4 = 1.8 time = 50
* CHECK dout0_6 vdout0_6ck4 = 0 time = 50
* CHECK dout0_7 vdout0_7ck4 = 1.8 time = 50
* CHECK dout0_8 vdout0_8ck4 = 0 time = 50
* CHECK dout0_9 vdout0_9ck4 = 1.8 time = 50
* CHECK dout0_10 vdout0_10ck4 = 1.8 time = 50
* CHECK dout0_11 vdout0_11ck4 = 0 time = 50
* CHECK dout0_12 vdout0_12ck4 = 0 time = 50
* CHECK dout0_13 vdout0_13ck4 = 1.8 time = 50
* CHECK dout0_14 vdout0_14ck4 = 0 time = 50
* CHECK dout0_15 vdout0_15ck4 = 1.8 time = 50
* CHECK dout0_16 vdout0_16ck4 = 1.8 time = 50
* CHECK dout0_17 vdout0_17ck4 = 0 time = 50
* CHECK dout0_18 vdout0_18ck4 = 0 time = 50
* CHECK dout0_19 vdout0_19ck4 = 0 time = 50
* CHECK dout0_20 vdout0_20ck4 = 0 time = 50
* CHECK dout0_21 vdout0_21ck4 = 0 time = 50
* CHECK dout0_22 vdout0_22ck4 = 1.8 time = 50
* CHECK dout0_23 vdout0_23ck4 = 1.8 time = 50
* CHECK dout0_24 vdout0_24ck4 = 0 time = 50
* CHECK dout0_25 vdout0_25ck4 = 1.8 time = 50
* CHECK dout0_26 vdout0_26ck4 = 1.8 time = 50
* CHECK dout0_27 vdout0_27ck4 = 0 time = 50
* CHECK dout0_28 vdout0_28ck4 = 0 time = 50
* CHECK dout0_29 vdout0_29ck4 = 1.8 time = 50
* CHECK dout0_30 vdout0_30ck4 = 0 time = 50
* CHECK dout0_31 vdout0_31ck4 = 0 time = 50
* CHECK dout1_0 vdout1_0ck4 = 0 time = 50
* CHECK dout1_1 vdout1_1ck4 = 1.8 time = 50
* CHECK dout1_2 vdout1_2ck4 = 1.8 time = 50
* CHECK dout1_3 vdout1_3ck4 = 1.8 time = 50
* CHECK dout1_4 vdout1_4ck4 = 1.8 time = 50
* CHECK dout1_5 vdout1_5ck4 = 1.8 time = 50
* CHECK dout1_6 vdout1_6ck4 = 1.8 time = 50
* CHECK dout1_7 vdout1_7ck4 = 0 time = 50
* CHECK dout1_8 vdout1_8ck4 = 0 time = 50
* CHECK dout1_9 vdout1_9ck4 = 0 time = 50
* CHECK dout1_10 vdout1_10ck4 = 1.8 time = 50
* CHECK dout1_11 vdout1_11ck4 = 1.8 time = 50
* CHECK dout1_12 vdout1_12ck4 = 0 time = 50
* CHECK dout1_13 vdout1_13ck4 = 0 time = 50
* CHECK dout1_14 vdout1_14ck4 = 0 time = 50
* CHECK dout1_15 vdout1_15ck4 = 0 time = 50
* CHECK dout1_16 vdout1_16ck4 = 0 time = 50
* CHECK dout1_17 vdout1_17ck4 = 0 time = 50
* CHECK dout1_18 vdout1_18ck4 = 0 time = 50
* CHECK dout1_19 vdout1_19ck4 = 0 time = 50
* CHECK dout1_20 vdout1_20ck4 = 0 time = 50
* CHECK dout1_21 vdout1_21ck4 = 1.8 time = 50
* CHECK dout1_22 vdout1_22ck4 = 1.8 time = 50
* CHECK dout1_23 vdout1_23ck4 = 1.8 time = 50
* CHECK dout1_24 vdout1_24ck4 = 1.8 time = 50
* CHECK dout1_25 vdout1_25ck4 = 0 time = 50
* CHECK dout1_26 vdout1_26ck4 = 1.8 time = 50
* CHECK dout1_27 vdout1_27ck4 = 0 time = 50
* CHECK dout1_28 vdout1_28ck4 = 0 time = 50
* CHECK dout1_29 vdout1_29ck4 = 0 time = 50
* CHECK dout1_30 vdout1_30ck4 = 1.8 time = 50
* CHECK dout1_31 vdout1_31ck4 = 1.8 time = 50
* CHECK dout1_0 vdout1_0ck5 = 0 time = 60
* CHECK dout1_1 vdout1_1ck5 = 0 time = 60
* CHECK dout1_2 vdout1_2ck5 = 1.8 time = 60
* CHECK dout1_3 vdout1_3ck5 = 0 time = 60
* CHECK dout1_4 vdout1_4ck5 = 1.8 time = 60
* CHECK dout1_5 vdout1_5ck5 = 1.8 time = 60
* CHECK dout1_6 vdout1_6ck5 = 0 time = 60
* CHECK dout1_7 vdout1_7ck5 = 1.8 time = 60
* CHECK dout1_8 vdout1_8ck5 = 0 time = 60
* CHECK dout1_9 vdout1_9ck5 = 1.8 time = 60
* CHECK dout1_10 vdout1_10ck5 = 1.8 time = 60
* CHECK dout1_11 vdout1_11ck5 = 0 time = 60
* CHECK dout1_12 vdout1_12ck5 = 0 time = 60
* CHECK dout1_13 vdout1_13ck5 = 1.8 time = 60
* CHECK dout1_14 vdout1_14ck5 = 0 time = 60
* CHECK dout1_15 vdout1_15ck5 = 1.8 time = 60
* CHECK dout1_16 vdout1_16ck5 = 1.8 time = 60
* CHECK dout1_17 vdout1_17ck5 = 0 time = 60
* CHECK dout1_18 vdout1_18ck5 = 0 time = 60
* CHECK dout1_19 vdout1_19ck5 = 0 time = 60
* CHECK dout1_20 vdout1_20ck5 = 0 time = 60
* CHECK dout1_21 vdout1_21ck5 = 0 time = 60
* CHECK dout1_22 vdout1_22ck5 = 1.8 time = 60
* CHECK dout1_23 vdout1_23ck5 = 1.8 time = 60
* CHECK dout1_24 vdout1_24ck5 = 0 time = 60
* CHECK dout1_25 vdout1_25ck5 = 1.8 time = 60
* CHECK dout1_26 vdout1_26ck5 = 1.8 time = 60
* CHECK dout1_27 vdout1_27ck5 = 0 time = 60
* CHECK dout1_28 vdout1_28ck5 = 0 time = 60
* CHECK dout1_29 vdout1_29ck5 = 1.8 time = 60
* CHECK dout1_30 vdout1_30ck5 = 0 time = 60
* CHECK dout1_31 vdout1_31ck5 = 0 time = 60
* CHECK dout0_0 vdout0_0ck6 = 0 time = 70
* CHECK dout0_1 vdout0_1ck6 = 1.8 time = 70
* CHECK dout0_2 vdout0_2ck6 = 1.8 time = 70
* CHECK dout0_3 vdout0_3ck6 = 1.8 time = 70
* CHECK dout0_4 vdout0_4ck6 = 1.8 time = 70
* CHECK dout0_5 vdout0_5ck6 = 1.8 time = 70
* CHECK dout0_6 vdout0_6ck6 = 1.8 time = 70
* CHECK dout0_7 vdout0_7ck6 = 0 time = 70
* CHECK dout0_8 vdout0_8ck6 = 0 time = 70
* CHECK dout0_9 vdout0_9ck6 = 0 time = 70
* CHECK dout0_10 vdout0_10ck6 = 1.8 time = 70
* CHECK dout0_11 vdout0_11ck6 = 1.8 time = 70
* CHECK dout0_12 vdout0_12ck6 = 0 time = 70
* CHECK dout0_13 vdout0_13ck6 = 0 time = 70
* CHECK dout0_14 vdout0_14ck6 = 0 time = 70
* CHECK dout0_15 vdout0_15ck6 = 0 time = 70
* CHECK dout0_16 vdout0_16ck6 = 0 time = 70
* CHECK dout0_17 vdout0_17ck6 = 0 time = 70
* CHECK dout0_18 vdout0_18ck6 = 0 time = 70
* CHECK dout0_19 vdout0_19ck6 = 0 time = 70
* CHECK dout0_20 vdout0_20ck6 = 0 time = 70
* CHECK dout0_21 vdout0_21ck6 = 1.8 time = 70
* CHECK dout0_22 vdout0_22ck6 = 1.8 time = 70
* CHECK dout0_23 vdout0_23ck6 = 1.8 time = 70
* CHECK dout0_24 vdout0_24ck6 = 1.8 time = 70
* CHECK dout0_25 vdout0_25ck6 = 0 time = 70
* CHECK dout0_26 vdout0_26ck6 = 1.8 time = 70
* CHECK dout0_27 vdout0_27ck6 = 0 time = 70
* CHECK dout0_28 vdout0_28ck6 = 0 time = 70
* CHECK dout0_29 vdout0_29ck6 = 0 time = 70
* CHECK dout0_30 vdout0_30ck6 = 1.8 time = 70
* CHECK dout0_31 vdout0_31ck6 = 1.8 time = 70
* CHECK dout1_0 vdout1_0ck6 = 0 time = 70
* CHECK dout1_1 vdout1_1ck6 = 0 time = 70
* CHECK dout1_2 vdout1_2ck6 = 1.8 time = 70
* CHECK dout1_3 vdout1_3ck6 = 0 time = 70
* CHECK dout1_4 vdout1_4ck6 = 1.8 time = 70
* CHECK dout1_5 vdout1_5ck6 = 1.8 time = 70
* CHECK dout1_6 vdout1_6ck6 = 0 time = 70
* CHECK dout1_7 vdout1_7ck6 = 1.8 time = 70
* CHECK dout1_8 vdout1_8ck6 = 0 time = 70
* CHECK dout1_9 vdout1_9ck6 = 1.8 time = 70
* CHECK dout1_10 vdout1_10ck6 = 1.8 time = 70
* CHECK dout1_11 vdout1_11ck6 = 0 time = 70
* CHECK dout1_12 vdout1_12ck6 = 0 time = 70
* CHECK dout1_13 vdout1_13ck6 = 1.8 time = 70
* CHECK dout1_14 vdout1_14ck6 = 0 time = 70
* CHECK dout1_15 vdout1_15ck6 = 1.8 time = 70
* CHECK dout1_16 vdout1_16ck6 = 1.8 time = 70
* CHECK dout1_17 vdout1_17ck6 = 0 time = 70
* CHECK dout1_18 vdout1_18ck6 = 0 time = 70
* CHECK dout1_19 vdout1_19ck6 = 0 time = 70
* CHECK dout1_20 vdout1_20ck6 = 0 time = 70
* CHECK dout1_21 vdout1_21ck6 = 0 time = 70
* CHECK dout1_22 vdout1_22ck6 = 1.8 time = 70
* CHECK dout1_23 vdout1_23ck6 = 1.8 time = 70
* CHECK dout1_24 vdout1_24ck6 = 0 time = 70
* CHECK dout1_25 vdout1_25ck6 = 1.8 time = 70
* CHECK dout1_26 vdout1_26ck6 = 1.8 time = 70
* CHECK dout1_27 vdout1_27ck6 = 0 time = 70
* CHECK dout1_28 vdout1_28ck6 = 0 time = 70
* CHECK dout1_29 vdout1_29ck6 = 1.8 time = 70
* CHECK dout1_30 vdout1_30ck6 = 0 time = 70
* CHECK dout1_31 vdout1_31ck6 = 0 time = 70
* CHECK dout1_0 vdout1_0ck7 = 0 time = 80
* CHECK dout1_1 vdout1_1ck7 = 0 time = 80
* CHECK dout1_2 vdout1_2ck7 = 1.8 time = 80
* CHECK dout1_3 vdout1_3ck7 = 0 time = 80
* CHECK dout1_4 vdout1_4ck7 = 1.8 time = 80
* CHECK dout1_5 vdout1_5ck7 = 1.8 time = 80
* CHECK dout1_6 vdout1_6ck7 = 0 time = 80
* CHECK dout1_7 vdout1_7ck7 = 1.8 time = 80
* CHECK dout1_8 vdout1_8ck7 = 0 time = 80
* CHECK dout1_9 vdout1_9ck7 = 1.8 time = 80
* CHECK dout1_10 vdout1_10ck7 = 1.8 time = 80
* CHECK dout1_11 vdout1_11ck7 = 0 time = 80
* CHECK dout1_12 vdout1_12ck7 = 0 time = 80
* CHECK dout1_13 vdout1_13ck7 = 1.8 time = 80
* CHECK dout1_14 vdout1_14ck7 = 0 time = 80
* CHECK dout1_15 vdout1_15ck7 = 1.8 time = 80
* CHECK dout1_16 vdout1_16ck7 = 1.8 time = 80
* CHECK dout1_17 vdout1_17ck7 = 0 time = 80
* CHECK dout1_18 vdout1_18ck7 = 0 time = 80
* CHECK dout1_19 vdout1_19ck7 = 0 time = 80
* CHECK dout1_20 vdout1_20ck7 = 0 time = 80
* CHECK dout1_21 vdout1_21ck7 = 0 time = 80
* CHECK dout1_22 vdout1_22ck7 = 1.8 time = 80
* CHECK dout1_23 vdout1_23ck7 = 1.8 time = 80
* CHECK dout1_24 vdout1_24ck7 = 0 time = 80
* CHECK dout1_25 vdout1_25ck7 = 1.8 time = 80
* CHECK dout1_26 vdout1_26ck7 = 1.8 time = 80
* CHECK dout1_27 vdout1_27ck7 = 0 time = 80
* CHECK dout1_28 vdout1_28ck7 = 0 time = 80
* CHECK dout1_29 vdout1_29ck7 = 1.8 time = 80
* CHECK dout1_30 vdout1_30ck7 = 0 time = 80
* CHECK dout1_31 vdout1_31ck7 = 0 time = 80
* CHECK dout1_0 vdout1_0ck8 = 1.8 time = 90
* CHECK dout1_1 vdout1_1ck8 = 0 time = 90
* CHECK dout1_2 vdout1_2ck8 = 1.8 time = 90
* CHECK dout1_3 vdout1_3ck8 = 0 time = 90
* CHECK dout1_4 vdout1_4ck8 = 0 time = 90
* CHECK dout1_5 vdout1_5ck8 = 0 time = 90
* CHECK dout1_6 vdout1_6ck8 = 0 time = 90
* CHECK dout1_7 vdout1_7ck8 = 0 time = 90
* CHECK dout1_8 vdout1_8ck8 = 0 time = 90
* CHECK dout1_9 vdout1_9ck8 = 1.8 time = 90
* CHECK dout1_10 vdout1_10ck8 = 1.8 time = 90
* CHECK dout1_11 vdout1_11ck8 = 0 time = 90
* CHECK dout1_12 vdout1_12ck8 = 1.8 time = 90
* CHECK dout1_13 vdout1_13ck8 = 0 time = 90
* CHECK dout1_14 vdout1_14ck8 = 0 time = 90
* CHECK dout1_15 vdout1_15ck8 = 1.8 time = 90
* CHECK dout1_16 vdout1_16ck8 = 1.8 time = 90
* CHECK dout1_17 vdout1_17ck8 = 0 time = 90
* CHECK dout1_18 vdout1_18ck8 = 1.8 time = 90
* CHECK dout1_19 vdout1_19ck8 = 1.8 time = 90
* CHECK dout1_20 vdout1_20ck8 = 0 time = 90
* CHECK dout1_21 vdout1_21ck8 = 1.8 time = 90
* CHECK dout1_22 vdout1_22ck8 = 0 time = 90
* CHECK dout1_23 vdout1_23ck8 = 1.8 time = 90
* CHECK dout1_24 vdout1_24ck8 = 0 time = 90
* CHECK dout1_25 vdout1_25ck8 = 1.8 time = 90
* CHECK dout1_26 vdout1_26ck8 = 0 time = 90
* CHECK dout1_27 vdout1_27ck8 = 1.8 time = 90
* CHECK dout1_28 vdout1_28ck8 = 1.8 time = 90
* CHECK dout1_29 vdout1_29ck8 = 0 time = 90
* CHECK dout1_30 vdout1_30ck8 = 1.8 time = 90
* CHECK dout1_31 vdout1_31ck8 = 0 time = 90
* CHECK dout0_0 vdout0_0ck9 = 0 time = 100
* CHECK dout0_1 vdout0_1ck9 = 0 time = 100
* CHECK dout0_2 vdout0_2ck9 = 1.8 time = 100
* CHECK dout0_3 vdout0_3ck9 = 0 time = 100
* CHECK dout0_4 vdout0_4ck9 = 1.8 time = 100
* CHECK dout0_5 vdout0_5ck9 = 1.8 time = 100
* CHECK dout0_6 vdout0_6ck9 = 0 time = 100
* CHECK dout0_7 vdout0_7ck9 = 1.8 time = 100
* CHECK dout0_8 vdout0_8ck9 = 0 time = 100
* CHECK dout0_9 vdout0_9ck9 = 1.8 time = 100
* CHECK dout0_10 vdout0_10ck9 = 1.8 time = 100
* CHECK dout0_11 vdout0_11ck9 = 0 time = 100
* CHECK dout0_12 vdout0_12ck9 = 0 time = 100
* CHECK dout0_13 vdout0_13ck9 = 1.8 time = 100
* CHECK dout0_14 vdout0_14ck9 = 0 time = 100
* CHECK dout0_15 vdout0_15ck9 = 1.8 time = 100
* CHECK dout0_16 vdout0_16ck9 = 1.8 time = 100
* CHECK dout0_17 vdout0_17ck9 = 0 time = 100
* CHECK dout0_18 vdout0_18ck9 = 0 time = 100
* CHECK dout0_19 vdout0_19ck9 = 0 time = 100
* CHECK dout0_20 vdout0_20ck9 = 0 time = 100
* CHECK dout0_21 vdout0_21ck9 = 0 time = 100
* CHECK dout0_22 vdout0_22ck9 = 1.8 time = 100
* CHECK dout0_23 vdout0_23ck9 = 1.8 time = 100
* CHECK dout0_24 vdout0_24ck9 = 0 time = 100
* CHECK dout0_25 vdout0_25ck9 = 1.8 time = 100
* CHECK dout0_26 vdout0_26ck9 = 1.8 time = 100
* CHECK dout0_27 vdout0_27ck9 = 0 time = 100
* CHECK dout0_28 vdout0_28ck9 = 0 time = 100
* CHECK dout0_29 vdout0_29ck9 = 1.8 time = 100
* CHECK dout0_30 vdout0_30ck9 = 0 time = 100
* CHECK dout0_31 vdout0_31ck9 = 0 time = 100
* CHECK dout0_0 vdout0_0ck10 = 0 time = 110
* CHECK dout0_1 vdout0_1ck10 = 0 time = 110
* CHECK dout0_2 vdout0_2ck10 = 0 time = 110
* CHECK dout0_3 vdout0_3ck10 = 1.8 time = 110
* CHECK dout0_4 vdout0_4ck10 = 0 time = 110
* CHECK dout0_5 vdout0_5ck10 = 1.8 time = 110
* CHECK dout0_6 vdout0_6ck10 = 1.8 time = 110
* CHECK dout0_7 vdout0_7ck10 = 1.8 time = 110
* CHECK dout0_8 vdout0_8ck10 = 1.8 time = 110
* CHECK dout0_9 vdout0_9ck10 = 0 time = 110
* CHECK dout0_10 vdout0_10ck10 = 0 time = 110
* CHECK dout0_11 vdout0_11ck10 = 1.8 time = 110
* CHECK dout0_12 vdout0_12ck10 = 1.8 time = 110
* CHECK dout0_13 vdout0_13ck10 = 0 time = 110
* CHECK dout0_14 vdout0_14ck10 = 0 time = 110
* CHECK dout0_15 vdout0_15ck10 = 0 time = 110
* CHECK dout0_16 vdout0_16ck10 = 1.8 time = 110
* CHECK dout0_17 vdout0_17ck10 = 1.8 time = 110
* CHECK dout0_18 vdout0_18ck10 = 1.8 time = 110
* CHECK dout0_19 vdout0_19ck10 = 0 time = 110
* CHECK dout0_20 vdout0_20ck10 = 0 time = 110
* CHECK dout0_21 vdout0_21ck10 = 1.8 time = 110
* CHECK dout0_22 vdout0_22ck10 = 1.8 time = 110
* CHECK dout0_23 vdout0_23ck10 = 1.8 time = 110
* CHECK dout0_24 vdout0_24ck10 = 0 time = 110
* CHECK dout0_25 vdout0_25ck10 = 0 time = 110
* CHECK dout0_26 vdout0_26ck10 = 0 time = 110
* CHECK dout0_27 vdout0_27ck10 = 0 time = 110
* CHECK dout0_28 vdout0_28ck10 = 0 time = 110
* CHECK dout0_29 vdout0_29ck10 = 1.8 time = 110
* CHECK dout0_30 vdout0_30ck10 = 1.8 time = 110
* CHECK dout0_31 vdout0_31ck10 = 1.8 time = 110
* CHECK dout0_0 vdout0_0ck12 = 1.8 time = 130
* CHECK dout0_1 vdout0_1ck12 = 0 time = 130
* CHECK dout0_2 vdout0_2ck12 = 1.8 time = 130
* CHECK dout0_3 vdout0_3ck12 = 0 time = 130
* CHECK dout0_4 vdout0_4ck12 = 0 time = 130
* CHECK dout0_5 vdout0_5ck12 = 0 time = 130
* CHECK dout0_6 vdout0_6ck12 = 0 time = 130
* CHECK dout0_7 vdout0_7ck12 = 0 time = 130
* CHECK dout0_8 vdout0_8ck12 = 0 time = 130
* CHECK dout0_9 vdout0_9ck12 = 1.8 time = 130
* CHECK dout0_10 vdout0_10ck12 = 1.8 time = 130
* CHECK dout0_11 vdout0_11ck12 = 0 time = 130
* CHECK dout0_12 vdout0_12ck12 = 1.8 time = 130
* CHECK dout0_13 vdout0_13ck12 = 0 time = 130
* CHECK dout0_14 vdout0_14ck12 = 0 time = 130
* CHECK dout0_15 vdout0_15ck12 = 1.8 time = 130
* CHECK dout0_16 vdout0_16ck12 = 1.8 time = 130
* CHECK dout0_17 vdout0_17ck12 = 0 time = 130
* CHECK dout0_18 vdout0_18ck12 = 1.8 time = 130
* CHECK dout0_19 vdout0_19ck12 = 1.8 time = 130
* CHECK dout0_20 vdout0_20ck12 = 0 time = 130
* CHECK dout0_21 vdout0_21ck12 = 1.8 time = 130
* CHECK dout0_22 vdout0_22ck12 = 0 time = 130
* CHECK dout0_23 vdout0_23ck12 = 1.8 time = 130
* CHECK dout0_24 vdout0_24ck12 = 1.8 time = 130
* CHECK dout0_25 vdout0_25ck12 = 0 time = 130
* CHECK dout0_26 vdout0_26ck12 = 0 time = 130
* CHECK dout0_27 vdout0_27ck12 = 0 time = 130
* CHECK dout0_28 vdout0_28ck12 = 0 time = 130
* CHECK dout0_29 vdout0_29ck12 = 1.8 time = 130
* CHECK dout0_30 vdout0_30ck12 = 0 time = 130
* CHECK dout0_31 vdout0_31ck12 = 1.8 time = 130
* CHECK dout0_0 vdout0_0ck13 = 1.8 time = 140
* CHECK dout0_1 vdout0_1ck13 = 0 time = 140
* CHECK dout0_2 vdout0_2ck13 = 1.8 time = 140
* CHECK dout0_3 vdout0_3ck13 = 0 time = 140
* CHECK dout0_4 vdout0_4ck13 = 0 time = 140
* CHECK dout0_5 vdout0_5ck13 = 0 time = 140
* CHECK dout0_6 vdout0_6ck13 = 0 time = 140
* CHECK dout0_7 vdout0_7ck13 = 0 time = 140
* CHECK dout0_8 vdout0_8ck13 = 0 time = 140
* CHECK dout0_9 vdout0_9ck13 = 1.8 time = 140
* CHECK dout0_10 vdout0_10ck13 = 1.8 time = 140
* CHECK dout0_11 vdout0_11ck13 = 0 time = 140
* CHECK dout0_12 vdout0_12ck13 = 1.8 time = 140
* CHECK dout0_13 vdout0_13ck13 = 0 time = 140
* CHECK dout0_14 vdout0_14ck13 = 0 time = 140
* CHECK dout0_15 vdout0_15ck13 = 1.8 time = 140
* CHECK dout0_16 vdout0_16ck13 = 1.8 time = 140
* CHECK dout0_17 vdout0_17ck13 = 0 time = 140
* CHECK dout0_18 vdout0_18ck13 = 1.8 time = 140
* CHECK dout0_19 vdout0_19ck13 = 1.8 time = 140
* CHECK dout0_20 vdout0_20ck13 = 0 time = 140
* CHECK dout0_21 vdout0_21ck13 = 1.8 time = 140
* CHECK dout0_22 vdout0_22ck13 = 0 time = 140
* CHECK dout0_23 vdout0_23ck13 = 1.8 time = 140
* CHECK dout0_24 vdout0_24ck13 = 1.8 time = 140
* CHECK dout0_25 vdout0_25ck13 = 0 time = 140
* CHECK dout0_26 vdout0_26ck13 = 0 time = 140
* CHECK dout0_27 vdout0_27ck13 = 0 time = 140
* CHECK dout0_28 vdout0_28ck13 = 0 time = 140
* CHECK dout0_29 vdout0_29ck13 = 1.8 time = 140
* CHECK dout0_30 vdout0_30ck13 = 0 time = 140
* CHECK dout0_31 vdout0_31ck13 = 1.8 time = 140
* CHECK dout1_0 vdout1_0ck13 = 1.8 time = 140
* CHECK dout1_1 vdout1_1ck13 = 0 time = 140
* CHECK dout1_2 vdout1_2ck13 = 1.8 time = 140
* CHECK dout1_3 vdout1_3ck13 = 0 time = 140
* CHECK dout1_4 vdout1_4ck13 = 0 time = 140
* CHECK dout1_5 vdout1_5ck13 = 0 time = 140
* CHECK dout1_6 vdout1_6ck13 = 0 time = 140
* CHECK dout1_7 vdout1_7ck13 = 0 time = 140
* CHECK dout1_8 vdout1_8ck13 = 0 time = 140
* CHECK dout1_9 vdout1_9ck13 = 1.8 time = 140
* CHECK dout1_10 vdout1_10ck13 = 1.8 time = 140
* CHECK dout1_11 vdout1_11ck13 = 0 time = 140
* CHECK dout1_12 vdout1_12ck13 = 1.8 time = 140
* CHECK dout1_13 vdout1_13ck13 = 0 time = 140
* CHECK dout1_14 vdout1_14ck13 = 0 time = 140
* CHECK dout1_15 vdout1_15ck13 = 1.8 time = 140
* CHECK dout1_16 vdout1_16ck13 = 1.8 time = 140
* CHECK dout1_17 vdout1_17ck13 = 0 time = 140
* CHECK dout1_18 vdout1_18ck13 = 1.8 time = 140
* CHECK dout1_19 vdout1_19ck13 = 1.8 time = 140
* CHECK dout1_20 vdout1_20ck13 = 0 time = 140
* CHECK dout1_21 vdout1_21ck13 = 1.8 time = 140
* CHECK dout1_22 vdout1_22ck13 = 0 time = 140
* CHECK dout1_23 vdout1_23ck13 = 1.8 time = 140
* CHECK dout1_24 vdout1_24ck13 = 1.8 time = 140
* CHECK dout1_25 vdout1_25ck13 = 0 time = 140
* CHECK dout1_26 vdout1_26ck13 = 0 time = 140
* CHECK dout1_27 vdout1_27ck13 = 0 time = 140
* CHECK dout1_28 vdout1_28ck13 = 0 time = 140
* CHECK dout1_29 vdout1_29ck13 = 1.8 time = 140
* CHECK dout1_30 vdout1_30ck13 = 0 time = 140
* CHECK dout1_31 vdout1_31ck13 = 1.8 time = 140
* CHECK dout0_0 vdout0_0ck14 = 0 time = 150
* CHECK dout0_1 vdout0_1ck14 = 0 time = 150
* CHECK dout0_2 vdout0_2ck14 = 0 time = 150
* CHECK dout0_3 vdout0_3ck14 = 1.8 time = 150
* CHECK dout0_4 vdout0_4ck14 = 0 time = 150
* CHECK dout0_5 vdout0_5ck14 = 1.8 time = 150
* CHECK dout0_6 vdout0_6ck14 = 1.8 time = 150
* CHECK dout0_7 vdout0_7ck14 = 1.8 time = 150
* CHECK dout0_8 vdout0_8ck14 = 1.8 time = 150
* CHECK dout0_9 vdout0_9ck14 = 0 time = 150
* CHECK dout0_10 vdout0_10ck14 = 0 time = 150
* CHECK dout0_11 vdout0_11ck14 = 1.8 time = 150
* CHECK dout0_12 vdout0_12ck14 = 1.8 time = 150
* CHECK dout0_13 vdout0_13ck14 = 0 time = 150
* CHECK dout0_14 vdout0_14ck14 = 0 time = 150
* CHECK dout0_15 vdout0_15ck14 = 0 time = 150
* CHECK dout0_16 vdout0_16ck14 = 1.8 time = 150
* CHECK dout0_17 vdout0_17ck14 = 1.8 time = 150
* CHECK dout0_18 vdout0_18ck14 = 1.8 time = 150
* CHECK dout0_19 vdout0_19ck14 = 0 time = 150
* CHECK dout0_20 vdout0_20ck14 = 0 time = 150
* CHECK dout0_21 vdout0_21ck14 = 1.8 time = 150
* CHECK dout0_22 vdout0_22ck14 = 1.8 time = 150
* CHECK dout0_23 vdout0_23ck14 = 1.8 time = 150
* CHECK dout0_24 vdout0_24ck14 = 0 time = 150
* CHECK dout0_25 vdout0_25ck14 = 0 time = 150
* CHECK dout0_26 vdout0_26ck14 = 0 time = 150
* CHECK dout0_27 vdout0_27ck14 = 0 time = 150
* CHECK dout0_28 vdout0_28ck14 = 0 time = 150
* CHECK dout0_29 vdout0_29ck14 = 1.8 time = 150
* CHECK dout0_30 vdout0_30ck14 = 1.8 time = 150
* CHECK dout0_31 vdout0_31ck14 = 1.8 time = 150
* CHECK dout1_0 vdout1_0ck14 = 1.8 time = 150
* CHECK dout1_1 vdout1_1ck14 = 0 time = 150
* CHECK dout1_2 vdout1_2ck14 = 1.8 time = 150
* CHECK dout1_3 vdout1_3ck14 = 0 time = 150
* CHECK dout1_4 vdout1_4ck14 = 0 time = 150
* CHECK dout1_5 vdout1_5ck14 = 0 time = 150
* CHECK dout1_6 vdout1_6ck14 = 0 time = 150
* CHECK dout1_7 vdout1_7ck14 = 0 time = 150
* CHECK dout1_8 vdout1_8ck14 = 0 time = 150
* CHECK dout1_9 vdout1_9ck14 = 1.8 time = 150
* CHECK dout1_10 vdout1_10ck14 = 1.8 time = 150
* CHECK dout1_11 vdout1_11ck14 = 0 time = 150
* CHECK dout1_12 vdout1_12ck14 = 1.8 time = 150
* CHECK dout1_13 vdout1_13ck14 = 0 time = 150
* CHECK dout1_14 vdout1_14ck14 = 0 time = 150
* CHECK dout1_15 vdout1_15ck14 = 1.8 time = 150
* CHECK dout1_16 vdout1_16ck14 = 1.8 time = 150
* CHECK dout1_17 vdout1_17ck14 = 0 time = 150
* CHECK dout1_18 vdout1_18ck14 = 1.8 time = 150
* CHECK dout1_19 vdout1_19ck14 = 1.8 time = 150
* CHECK dout1_20 vdout1_20ck14 = 0 time = 150
* CHECK dout1_21 vdout1_21ck14 = 1.8 time = 150
* CHECK dout1_22 vdout1_22ck14 = 0 time = 150
* CHECK dout1_23 vdout1_23ck14 = 1.8 time = 150
* CHECK dout1_24 vdout1_24ck14 = 1.8 time = 150
* CHECK dout1_25 vdout1_25ck14 = 0 time = 150
* CHECK dout1_26 vdout1_26ck14 = 0 time = 150
* CHECK dout1_27 vdout1_27ck14 = 0 time = 150
* CHECK dout1_28 vdout1_28ck14 = 0 time = 150
* CHECK dout1_29 vdout1_29ck14 = 1.8 time = 150
* CHECK dout1_30 vdout1_30ck14 = 0 time = 150
* CHECK dout1_31 vdout1_31ck14 = 1.8 time = 150
* CHECK dout0_0 vdout0_0ck15 = 0 time = 160
* CHECK dout0_1 vdout0_1ck15 = 0 time = 160
* CHECK dout0_2 vdout0_2ck15 = 1.8 time = 160
* CHECK dout0_3 vdout0_3ck15 = 0 time = 160
* CHECK dout0_4 vdout0_4ck15 = 1.8 time = 160
* CHECK dout0_5 vdout0_5ck15 = 1.8 time = 160
* CHECK dout0_6 vdout0_6ck15 = 0 time = 160
* CHECK dout0_7 vdout0_7ck15 = 1.8 time = 160
* CHECK dout0_8 vdout0_8ck15 = 0 time = 160
* CHECK dout0_9 vdout0_9ck15 = 1.8 time = 160
* CHECK dout0_10 vdout0_10ck15 = 1.8 time = 160
* CHECK dout0_11 vdout0_11ck15 = 0 time = 160
* CHECK dout0_12 vdout0_12ck15 = 0 time = 160
* CHECK dout0_13 vdout0_13ck15 = 1.8 time = 160
* CHECK dout0_14 vdout0_14ck15 = 0 time = 160
* CHECK dout0_15 vdout0_15ck15 = 1.8 time = 160
* CHECK dout0_16 vdout0_16ck15 = 1.8 time = 160
* CHECK dout0_17 vdout0_17ck15 = 0 time = 160
* CHECK dout0_18 vdout0_18ck15 = 0 time = 160
* CHECK dout0_19 vdout0_19ck15 = 0 time = 160
* CHECK dout0_20 vdout0_20ck15 = 0 time = 160
* CHECK dout0_21 vdout0_21ck15 = 0 time = 160
* CHECK dout0_22 vdout0_22ck15 = 1.8 time = 160
* CHECK dout0_23 vdout0_23ck15 = 1.8 time = 160
* CHECK dout0_24 vdout0_24ck15 = 0 time = 160
* CHECK dout0_25 vdout0_25ck15 = 1.8 time = 160
* CHECK dout0_26 vdout0_26ck15 = 1.8 time = 160
* CHECK dout0_27 vdout0_27ck15 = 0 time = 160
* CHECK dout0_28 vdout0_28ck15 = 0 time = 160
* CHECK dout0_29 vdout0_29ck15 = 1.8 time = 160
* CHECK dout0_30 vdout0_30ck15 = 0 time = 160
* CHECK dout0_31 vdout0_31ck15 = 0 time = 160
* CHECK dout1_0 vdout1_0ck15 = 0 time = 160
* CHECK dout1_1 vdout1_1ck15 = 0 time = 160
* CHECK dout1_2 vdout1_2ck15 = 1.8 time = 160
* CHECK dout1_3 vdout1_3ck15 = 0 time = 160
* CHECK dout1_4 vdout1_4ck15 = 1.8 time = 160
* CHECK dout1_5 vdout1_5ck15 = 1.8 time = 160
* CHECK dout1_6 vdout1_6ck15 = 0 time = 160
* CHECK dout1_7 vdout1_7ck15 = 1.8 time = 160
* CHECK dout1_8 vdout1_8ck15 = 0 time = 160
* CHECK dout1_9 vdout1_9ck15 = 1.8 time = 160
* CHECK dout1_10 vdout1_10ck15 = 1.8 time = 160
* CHECK dout1_11 vdout1_11ck15 = 0 time = 160
* CHECK dout1_12 vdout1_12ck15 = 0 time = 160
* CHECK dout1_13 vdout1_13ck15 = 1.8 time = 160
* CHECK dout1_14 vdout1_14ck15 = 0 time = 160
* CHECK dout1_15 vdout1_15ck15 = 1.8 time = 160
* CHECK dout1_16 vdout1_16ck15 = 1.8 time = 160
* CHECK dout1_17 vdout1_17ck15 = 0 time = 160
* CHECK dout1_18 vdout1_18ck15 = 0 time = 160
* CHECK dout1_19 vdout1_19ck15 = 0 time = 160
* CHECK dout1_20 vdout1_20ck15 = 0 time = 160
* CHECK dout1_21 vdout1_21ck15 = 0 time = 160
* CHECK dout1_22 vdout1_22ck15 = 1.8 time = 160
* CHECK dout1_23 vdout1_23ck15 = 1.8 time = 160
* CHECK dout1_24 vdout1_24ck15 = 0 time = 160
* CHECK dout1_25 vdout1_25ck15 = 1.8 time = 160
* CHECK dout1_26 vdout1_26ck15 = 1.8 time = 160
* CHECK dout1_27 vdout1_27ck15 = 0 time = 160
* CHECK dout1_28 vdout1_28ck15 = 0 time = 160
* CHECK dout1_29 vdout1_29ck15 = 1.8 time = 160
* CHECK dout1_30 vdout1_30ck15 = 0 time = 160
* CHECK dout1_31 vdout1_31ck15 = 0 time = 160
* CHECK dout0_0 vdout0_0ck16 = 0 time = 170
* CHECK dout0_1 vdout0_1ck16 = 0 time = 170
* CHECK dout0_2 vdout0_2ck16 = 0 time = 170
* CHECK dout0_3 vdout0_3ck16 = 1.8 time = 170
* CHECK dout0_4 vdout0_4ck16 = 0 time = 170
* CHECK dout0_5 vdout0_5ck16 = 1.8 time = 170
* CHECK dout0_6 vdout0_6ck16 = 1.8 time = 170
* CHECK dout0_7 vdout0_7ck16 = 1.8 time = 170
* CHECK dout0_8 vdout0_8ck16 = 1.8 time = 170
* CHECK dout0_9 vdout0_9ck16 = 0 time = 170
* CHECK dout0_10 vdout0_10ck16 = 0 time = 170
* CHECK dout0_11 vdout0_11ck16 = 1.8 time = 170
* CHECK dout0_12 vdout0_12ck16 = 1.8 time = 170
* CHECK dout0_13 vdout0_13ck16 = 0 time = 170
* CHECK dout0_14 vdout0_14ck16 = 0 time = 170
* CHECK dout0_15 vdout0_15ck16 = 0 time = 170
* CHECK dout0_16 vdout0_16ck16 = 1.8 time = 170
* CHECK dout0_17 vdout0_17ck16 = 1.8 time = 170
* CHECK dout0_18 vdout0_18ck16 = 1.8 time = 170
* CHECK dout0_19 vdout0_19ck16 = 0 time = 170
* CHECK dout0_20 vdout0_20ck16 = 0 time = 170
* CHECK dout0_21 vdout0_21ck16 = 1.8 time = 170
* CHECK dout0_22 vdout0_22ck16 = 1.8 time = 170
* CHECK dout0_23 vdout0_23ck16 = 1.8 time = 170
* CHECK dout0_24 vdout0_24ck16 = 0 time = 170
* CHECK dout0_25 vdout0_25ck16 = 0 time = 170
* CHECK dout0_26 vdout0_26ck16 = 0 time = 170
* CHECK dout0_27 vdout0_27ck16 = 0 time = 170
* CHECK dout0_28 vdout0_28ck16 = 0 time = 170
* CHECK dout0_29 vdout0_29ck16 = 1.8 time = 170
* CHECK dout0_30 vdout0_30ck16 = 1.8 time = 170
* CHECK dout0_31 vdout0_31ck16 = 1.8 time = 170
* CHECK dout0_0 vdout0_0ck18 = 0 time = 190
* CHECK dout0_1 vdout0_1ck18 = 0 time = 190
* CHECK dout0_2 vdout0_2ck18 = 1.8 time = 190
* CHECK dout0_3 vdout0_3ck18 = 0 time = 190
* CHECK dout0_4 vdout0_4ck18 = 1.8 time = 190
* CHECK dout0_5 vdout0_5ck18 = 1.8 time = 190
* CHECK dout0_6 vdout0_6ck18 = 0 time = 190
* CHECK dout0_7 vdout0_7ck18 = 1.8 time = 190
* CHECK dout0_8 vdout0_8ck18 = 0 time = 190
* CHECK dout0_9 vdout0_9ck18 = 1.8 time = 190
* CHECK dout0_10 vdout0_10ck18 = 1.8 time = 190
* CHECK dout0_11 vdout0_11ck18 = 0 time = 190
* CHECK dout0_12 vdout0_12ck18 = 0 time = 190
* CHECK dout0_13 vdout0_13ck18 = 1.8 time = 190
* CHECK dout0_14 vdout0_14ck18 = 0 time = 190
* CHECK dout0_15 vdout0_15ck18 = 1.8 time = 190
* CHECK dout0_16 vdout0_16ck18 = 1.8 time = 190
* CHECK dout0_17 vdout0_17ck18 = 0 time = 190
* CHECK dout0_18 vdout0_18ck18 = 0 time = 190
* CHECK dout0_19 vdout0_19ck18 = 0 time = 190
* CHECK dout0_20 vdout0_20ck18 = 0 time = 190
* CHECK dout0_21 vdout0_21ck18 = 0 time = 190
* CHECK dout0_22 vdout0_22ck18 = 1.8 time = 190
* CHECK dout0_23 vdout0_23ck18 = 1.8 time = 190
* CHECK dout0_24 vdout0_24ck18 = 0 time = 190
* CHECK dout0_25 vdout0_25ck18 = 1.8 time = 190
* CHECK dout0_26 vdout0_26ck18 = 1.8 time = 190
* CHECK dout0_27 vdout0_27ck18 = 0 time = 190
* CHECK dout0_28 vdout0_28ck18 = 0 time = 190
* CHECK dout0_29 vdout0_29ck18 = 1.8 time = 190
* CHECK dout0_30 vdout0_30ck18 = 0 time = 190
* CHECK dout0_31 vdout0_31ck18 = 0 time = 190
* CHECK dout1_0 vdout1_0ck19 = 0 time = 200
* CHECK dout1_1 vdout1_1ck19 = 0 time = 200
* CHECK dout1_2 vdout1_2ck19 = 1.8 time = 200
* CHECK dout1_3 vdout1_3ck19 = 0 time = 200
* CHECK dout1_4 vdout1_4ck19 = 1.8 time = 200
* CHECK dout1_5 vdout1_5ck19 = 1.8 time = 200
* CHECK dout1_6 vdout1_6ck19 = 0 time = 200
* CHECK dout1_7 vdout1_7ck19 = 1.8 time = 200
* CHECK dout1_8 vdout1_8ck19 = 0 time = 200
* CHECK dout1_9 vdout1_9ck19 = 1.8 time = 200
* CHECK dout1_10 vdout1_10ck19 = 1.8 time = 200
* CHECK dout1_11 vdout1_11ck19 = 0 time = 200
* CHECK dout1_12 vdout1_12ck19 = 0 time = 200
* CHECK dout1_13 vdout1_13ck19 = 1.8 time = 200
* CHECK dout1_14 vdout1_14ck19 = 0 time = 200
* CHECK dout1_15 vdout1_15ck19 = 1.8 time = 200
* CHECK dout1_16 vdout1_16ck19 = 1.8 time = 200
* CHECK dout1_17 vdout1_17ck19 = 0 time = 200
* CHECK dout1_18 vdout1_18ck19 = 0 time = 200
* CHECK dout1_19 vdout1_19ck19 = 0 time = 200
* CHECK dout1_20 vdout1_20ck19 = 0 time = 200
* CHECK dout1_21 vdout1_21ck19 = 0 time = 200
* CHECK dout1_22 vdout1_22ck19 = 1.8 time = 200
* CHECK dout1_23 vdout1_23ck19 = 1.8 time = 200
* CHECK dout1_24 vdout1_24ck19 = 0 time = 200
* CHECK dout1_25 vdout1_25ck19 = 1.8 time = 200
* CHECK dout1_26 vdout1_26ck19 = 1.8 time = 200
* CHECK dout1_27 vdout1_27ck19 = 0 time = 200
* CHECK dout1_28 vdout1_28ck19 = 0 time = 200
* CHECK dout1_29 vdout1_29ck19 = 1.8 time = 200
* CHECK dout1_30 vdout1_30ck19 = 0 time = 200
* CHECK dout1_31 vdout1_31ck19 = 0 time = 200
* CHECK dout0_0 vdout0_0ck22 = 0 time = 230
* CHECK dout0_1 vdout0_1ck22 = 0 time = 230
* CHECK dout0_2 vdout0_2ck22 = 0 time = 230
* CHECK dout0_3 vdout0_3ck22 = 1.8 time = 230
* CHECK dout0_4 vdout0_4ck22 = 0 time = 230
* CHECK dout0_5 vdout0_5ck22 = 1.8 time = 230
* CHECK dout0_6 vdout0_6ck22 = 1.8 time = 230
* CHECK dout0_7 vdout0_7ck22 = 1.8 time = 230
* CHECK dout0_8 vdout0_8ck22 = 1.8 time = 230
* CHECK dout0_9 vdout0_9ck22 = 0 time = 230
* CHECK dout0_10 vdout0_10ck22 = 0 time = 230
* CHECK dout0_11 vdout0_11ck22 = 1.8 time = 230
* CHECK dout0_12 vdout0_12ck22 = 1.8 time = 230
* CHECK dout0_13 vdout0_13ck22 = 0 time = 230
* CHECK dout0_14 vdout0_14ck22 = 0 time = 230
* CHECK dout0_15 vdout0_15ck22 = 0 time = 230
* CHECK dout0_16 vdout0_16ck22 = 1.8 time = 230
* CHECK dout0_17 vdout0_17ck22 = 0 time = 230
* CHECK dout0_18 vdout0_18ck22 = 0 time = 230
* CHECK dout0_19 vdout0_19ck22 = 0 time = 230
* CHECK dout0_20 vdout0_20ck22 = 1.8 time = 230
* CHECK dout0_21 vdout0_21ck22 = 0 time = 230
* CHECK dout0_22 vdout0_22ck22 = 1.8 time = 230
* CHECK dout0_23 vdout0_23ck22 = 0 time = 230
* CHECK dout0_24 vdout0_24ck22 = 0 time = 230
* CHECK dout0_25 vdout0_25ck22 = 0 time = 230
* CHECK dout0_26 vdout0_26ck22 = 0 time = 230
* CHECK dout0_27 vdout0_27ck22 = 0 time = 230
* CHECK dout0_28 vdout0_28ck22 = 0 time = 230
* CHECK dout0_29 vdout0_29ck22 = 1.8 time = 230
* CHECK dout0_30 vdout0_30ck22 = 1.8 time = 230
* CHECK dout0_31 vdout0_31ck22 = 1.8 time = 230
* CHECK dout1_0 vdout1_0ck22 = 0 time = 230
* CHECK dout1_1 vdout1_1ck22 = 0 time = 230
* CHECK dout1_2 vdout1_2ck22 = 1.8 time = 230
* CHECK dout1_3 vdout1_3ck22 = 0 time = 230
* CHECK dout1_4 vdout1_4ck22 = 1.8 time = 230
* CHECK dout1_5 vdout1_5ck22 = 1.8 time = 230
* CHECK dout1_6 vdout1_6ck22 = 0 time = 230
* CHECK dout1_7 vdout1_7ck22 = 1.8 time = 230
* CHECK dout1_8 vdout1_8ck22 = 0 time = 230
* CHECK dout1_9 vdout1_9ck22 = 1.8 time = 230
* CHECK dout1_10 vdout1_10ck22 = 1.8 time = 230
* CHECK dout1_11 vdout1_11ck22 = 0 time = 230
* CHECK dout1_12 vdout1_12ck22 = 0 time = 230
* CHECK dout1_13 vdout1_13ck22 = 1.8 time = 230
* CHECK dout1_14 vdout1_14ck22 = 0 time = 230
* CHECK dout1_15 vdout1_15ck22 = 1.8 time = 230
* CHECK dout1_16 vdout1_16ck22 = 1.8 time = 230
* CHECK dout1_17 vdout1_17ck22 = 0 time = 230
* CHECK dout1_18 vdout1_18ck22 = 0 time = 230
* CHECK dout1_19 vdout1_19ck22 = 0 time = 230
* CHECK dout1_20 vdout1_20ck22 = 0 time = 230
* CHECK dout1_21 vdout1_21ck22 = 0 time = 230
* CHECK dout1_22 vdout1_22ck22 = 1.8 time = 230
* CHECK dout1_23 vdout1_23ck22 = 1.8 time = 230
* CHECK dout1_24 vdout1_24ck22 = 0 time = 230
* CHECK dout1_25 vdout1_25ck22 = 1.8 time = 230
* CHECK dout1_26 vdout1_26ck22 = 1.8 time = 230
* CHECK dout1_27 vdout1_27ck22 = 0 time = 230
* CHECK dout1_28 vdout1_28ck22 = 0 time = 230
* CHECK dout1_29 vdout1_29ck22 = 1.8 time = 230
* CHECK dout1_30 vdout1_30ck22 = 0 time = 230
* CHECK dout1_31 vdout1_31ck22 = 0 time = 230
* CHECK dout0_0 vdout0_0ck23 = 0 time = 240
* CHECK dout0_1 vdout0_1ck23 = 0 time = 240
* CHECK dout0_2 vdout0_2ck23 = 0 time = 240
* CHECK dout0_3 vdout0_3ck23 = 1.8 time = 240
* CHECK dout0_4 vdout0_4ck23 = 0 time = 240
* CHECK dout0_5 vdout0_5ck23 = 1.8 time = 240
* CHECK dout0_6 vdout0_6ck23 = 1.8 time = 240
* CHECK dout0_7 vdout0_7ck23 = 1.8 time = 240
* CHECK dout0_8 vdout0_8ck23 = 1.8 time = 240
* CHECK dout0_9 vdout0_9ck23 = 0 time = 240
* CHECK dout0_10 vdout0_10ck23 = 0 time = 240
* CHECK dout0_11 vdout0_11ck23 = 1.8 time = 240
* CHECK dout0_12 vdout0_12ck23 = 1.8 time = 240
* CHECK dout0_13 vdout0_13ck23 = 0 time = 240
* CHECK dout0_14 vdout0_14ck23 = 0 time = 240
* CHECK dout0_15 vdout0_15ck23 = 0 time = 240
* CHECK dout0_16 vdout0_16ck23 = 1.8 time = 240
* CHECK dout0_17 vdout0_17ck23 = 0 time = 240
* CHECK dout0_18 vdout0_18ck23 = 0 time = 240
* CHECK dout0_19 vdout0_19ck23 = 0 time = 240
* CHECK dout0_20 vdout0_20ck23 = 1.8 time = 240
* CHECK dout0_21 vdout0_21ck23 = 0 time = 240
* CHECK dout0_22 vdout0_22ck23 = 1.8 time = 240
* CHECK dout0_23 vdout0_23ck23 = 0 time = 240
* CHECK dout0_24 vdout0_24ck23 = 0 time = 240
* CHECK dout0_25 vdout0_25ck23 = 0 time = 240
* CHECK dout0_26 vdout0_26ck23 = 0 time = 240
* CHECK dout0_27 vdout0_27ck23 = 0 time = 240
* CHECK dout0_28 vdout0_28ck23 = 0 time = 240
* CHECK dout0_29 vdout0_29ck23 = 1.8 time = 240
* CHECK dout0_30 vdout0_30ck23 = 1.8 time = 240
* CHECK dout0_31 vdout0_31ck23 = 1.8 time = 240
* CHECK dout1_0 vdout1_0ck24 = 0 time = 250
* CHECK dout1_1 vdout1_1ck24 = 0 time = 250
* CHECK dout1_2 vdout1_2ck24 = 1.8 time = 250
* CHECK dout1_3 vdout1_3ck24 = 0 time = 250
* CHECK dout1_4 vdout1_4ck24 = 1.8 time = 250
* CHECK dout1_5 vdout1_5ck24 = 1.8 time = 250
* CHECK dout1_6 vdout1_6ck24 = 0 time = 250
* CHECK dout1_7 vdout1_7ck24 = 1.8 time = 250
* CHECK dout1_8 vdout1_8ck24 = 0 time = 250
* CHECK dout1_9 vdout1_9ck24 = 1.8 time = 250
* CHECK dout1_10 vdout1_10ck24 = 1.8 time = 250
* CHECK dout1_11 vdout1_11ck24 = 0 time = 250
* CHECK dout1_12 vdout1_12ck24 = 0 time = 250
* CHECK dout1_13 vdout1_13ck24 = 1.8 time = 250
* CHECK dout1_14 vdout1_14ck24 = 0 time = 250
* CHECK dout1_15 vdout1_15ck24 = 1.8 time = 250
* CHECK dout1_16 vdout1_16ck24 = 1.8 time = 250
* CHECK dout1_17 vdout1_17ck24 = 0 time = 250
* CHECK dout1_18 vdout1_18ck24 = 0 time = 250
* CHECK dout1_19 vdout1_19ck24 = 0 time = 250
* CHECK dout1_20 vdout1_20ck24 = 0 time = 250
* CHECK dout1_21 vdout1_21ck24 = 0 time = 250
* CHECK dout1_22 vdout1_22ck24 = 1.8 time = 250
* CHECK dout1_23 vdout1_23ck24 = 1.8 time = 250
* CHECK dout1_24 vdout1_24ck24 = 0 time = 250
* CHECK dout1_25 vdout1_25ck24 = 1.8 time = 250
* CHECK dout1_26 vdout1_26ck24 = 1.8 time = 250
* CHECK dout1_27 vdout1_27ck24 = 0 time = 250
* CHECK dout1_28 vdout1_28ck24 = 0 time = 250
* CHECK dout1_29 vdout1_29ck24 = 1.8 time = 250
* CHECK dout1_30 vdout1_30ck24 = 0 time = 250
* CHECK dout1_31 vdout1_31ck24 = 0 time = 250
* CHECK dout0_0 vdout0_0ck25 = 1.8 time = 260
* CHECK dout0_1 vdout0_1ck25 = 1.8 time = 260
* CHECK dout0_2 vdout0_2ck25 = 0 time = 260
* CHECK dout0_3 vdout0_3ck25 = 0 time = 260
* CHECK dout0_4 vdout0_4ck25 = 0 time = 260
* CHECK dout0_5 vdout0_5ck25 = 0 time = 260
* CHECK dout0_6 vdout0_6ck25 = 0 time = 260
* CHECK dout0_7 vdout0_7ck25 = 1.8 time = 260
* CHECK dout0_8 vdout0_8ck25 = 1.8 time = 260
* CHECK dout0_9 vdout0_9ck25 = 0 time = 260
* CHECK dout0_10 vdout0_10ck25 = 0 time = 260
* CHECK dout0_11 vdout0_11ck25 = 0 time = 260
* CHECK dout0_12 vdout0_12ck25 = 1.8 time = 260
* CHECK dout0_13 vdout0_13ck25 = 0 time = 260
* CHECK dout0_14 vdout0_14ck25 = 0 time = 260
* CHECK dout0_15 vdout0_15ck25 = 0 time = 260
* CHECK dout0_16 vdout0_16ck25 = 1.8 time = 260
* CHECK dout0_17 vdout0_17ck25 = 1.8 time = 260
* CHECK dout0_18 vdout0_18ck25 = 1.8 time = 260
* CHECK dout0_19 vdout0_19ck25 = 0 time = 260
* CHECK dout0_20 vdout0_20ck25 = 0 time = 260
* CHECK dout0_21 vdout0_21ck25 = 0 time = 260
* CHECK dout0_22 vdout0_22ck25 = 0 time = 260
* CHECK dout0_23 vdout0_23ck25 = 1.8 time = 260
* CHECK dout0_24 vdout0_24ck25 = 0 time = 260
* CHECK dout0_25 vdout0_25ck25 = 1.8 time = 260
* CHECK dout0_26 vdout0_26ck25 = 0 time = 260
* CHECK dout0_27 vdout0_27ck25 = 1.8 time = 260
* CHECK dout0_28 vdout0_28ck25 = 0 time = 260
* CHECK dout0_29 vdout0_29ck25 = 0 time = 260
* CHECK dout0_30 vdout0_30ck25 = 0 time = 260
* CHECK dout0_31 vdout0_31ck25 = 0 time = 260
* CHECK dout1_0 vdout1_0ck25 = 0 time = 260
* CHECK dout1_1 vdout1_1ck25 = 0 time = 260
* CHECK dout1_2 vdout1_2ck25 = 0 time = 260
* CHECK dout1_3 vdout1_3ck25 = 1.8 time = 260
* CHECK dout1_4 vdout1_4ck25 = 0 time = 260
* CHECK dout1_5 vdout1_5ck25 = 1.8 time = 260
* CHECK dout1_6 vdout1_6ck25 = 1.8 time = 260
* CHECK dout1_7 vdout1_7ck25 = 1.8 time = 260
* CHECK dout1_8 vdout1_8ck25 = 1.8 time = 260
* CHECK dout1_9 vdout1_9ck25 = 0 time = 260
* CHECK dout1_10 vdout1_10ck25 = 0 time = 260
* CHECK dout1_11 vdout1_11ck25 = 1.8 time = 260
* CHECK dout1_12 vdout1_12ck25 = 1.8 time = 260
* CHECK dout1_13 vdout1_13ck25 = 0 time = 260
* CHECK dout1_14 vdout1_14ck25 = 0 time = 260
* CHECK dout1_15 vdout1_15ck25 = 0 time = 260
* CHECK dout1_16 vdout1_16ck25 = 1.8 time = 260
* CHECK dout1_17 vdout1_17ck25 = 0 time = 260
* CHECK dout1_18 vdout1_18ck25 = 0 time = 260
* CHECK dout1_19 vdout1_19ck25 = 0 time = 260
* CHECK dout1_20 vdout1_20ck25 = 1.8 time = 260
* CHECK dout1_21 vdout1_21ck25 = 0 time = 260
* CHECK dout1_22 vdout1_22ck25 = 1.8 time = 260
* CHECK dout1_23 vdout1_23ck25 = 0 time = 260
* CHECK dout1_24 vdout1_24ck25 = 0 time = 260
* CHECK dout1_25 vdout1_25ck25 = 0 time = 260
* CHECK dout1_26 vdout1_26ck25 = 0 time = 260
* CHECK dout1_27 vdout1_27ck25 = 0 time = 260
* CHECK dout1_28 vdout1_28ck25 = 0 time = 260
* CHECK dout1_29 vdout1_29ck25 = 1.8 time = 260
* CHECK dout1_30 vdout1_30ck25 = 1.8 time = 260
* CHECK dout1_31 vdout1_31ck25 = 1.8 time = 260
* CHECK dout0_0 vdout0_0ck26 = 1.8 time = 270
* CHECK dout0_1 vdout0_1ck26 = 1.8 time = 270
* CHECK dout0_2 vdout0_2ck26 = 0 time = 270
* CHECK dout0_3 vdout0_3ck26 = 0 time = 270
* CHECK dout0_4 vdout0_4ck26 = 0 time = 270
* CHECK dout0_5 vdout0_5ck26 = 0 time = 270
* CHECK dout0_6 vdout0_6ck26 = 0 time = 270
* CHECK dout0_7 vdout0_7ck26 = 1.8 time = 270
* CHECK dout0_8 vdout0_8ck26 = 1.8 time = 270
* CHECK dout0_9 vdout0_9ck26 = 0 time = 270
* CHECK dout0_10 vdout0_10ck26 = 0 time = 270
* CHECK dout0_11 vdout0_11ck26 = 0 time = 270
* CHECK dout0_12 vdout0_12ck26 = 1.8 time = 270
* CHECK dout0_13 vdout0_13ck26 = 0 time = 270
* CHECK dout0_14 vdout0_14ck26 = 0 time = 270
* CHECK dout0_15 vdout0_15ck26 = 0 time = 270
* CHECK dout0_16 vdout0_16ck26 = 1.8 time = 270
* CHECK dout0_17 vdout0_17ck26 = 1.8 time = 270
* CHECK dout0_18 vdout0_18ck26 = 1.8 time = 270
* CHECK dout0_19 vdout0_19ck26 = 0 time = 270
* CHECK dout0_20 vdout0_20ck26 = 0 time = 270
* CHECK dout0_21 vdout0_21ck26 = 0 time = 270
* CHECK dout0_22 vdout0_22ck26 = 0 time = 270
* CHECK dout0_23 vdout0_23ck26 = 1.8 time = 270
* CHECK dout0_24 vdout0_24ck26 = 0 time = 270
* CHECK dout0_25 vdout0_25ck26 = 1.8 time = 270
* CHECK dout0_26 vdout0_26ck26 = 0 time = 270
* CHECK dout0_27 vdout0_27ck26 = 1.8 time = 270
* CHECK dout0_28 vdout0_28ck26 = 0 time = 270
* CHECK dout0_29 vdout0_29ck26 = 0 time = 270
* CHECK dout0_30 vdout0_30ck26 = 0 time = 270
* CHECK dout0_31 vdout0_31ck26 = 0 time = 270
* CHECK dout1_0 vdout1_0ck28 = 1.8 time = 290
* CHECK dout1_1 vdout1_1ck28 = 1.8 time = 290
* CHECK dout1_2 vdout1_2ck28 = 0 time = 290
* CHECK dout1_3 vdout1_3ck28 = 0 time = 290
* CHECK dout1_4 vdout1_4ck28 = 0 time = 290
* CHECK dout1_5 vdout1_5ck28 = 0 time = 290
* CHECK dout1_6 vdout1_6ck28 = 0 time = 290
* CHECK dout1_7 vdout1_7ck28 = 1.8 time = 290
* CHECK dout1_8 vdout1_8ck28 = 1.8 time = 290
* CHECK dout1_9 vdout1_9ck28 = 0 time = 290
* CHECK dout1_10 vdout1_10ck28 = 0 time = 290
* CHECK dout1_11 vdout1_11ck28 = 0 time = 290
* CHECK dout1_12 vdout1_12ck28 = 1.8 time = 290
* CHECK dout1_13 vdout1_13ck28 = 0 time = 290
* CHECK dout1_14 vdout1_14ck28 = 0 time = 290
* CHECK dout1_15 vdout1_15ck28 = 0 time = 290
* CHECK dout1_16 vdout1_16ck28 = 1.8 time = 290
* CHECK dout1_17 vdout1_17ck28 = 1.8 time = 290
* CHECK dout1_18 vdout1_18ck28 = 1.8 time = 290
* CHECK dout1_19 vdout1_19ck28 = 0 time = 290
* CHECK dout1_20 vdout1_20ck28 = 0 time = 290
* CHECK dout1_21 vdout1_21ck28 = 0 time = 290
* CHECK dout1_22 vdout1_22ck28 = 0 time = 290
* CHECK dout1_23 vdout1_23ck28 = 1.8 time = 290
* CHECK dout1_24 vdout1_24ck28 = 0 time = 290
* CHECK dout1_25 vdout1_25ck28 = 1.8 time = 290
* CHECK dout1_26 vdout1_26ck28 = 0 time = 290
* CHECK dout1_27 vdout1_27ck28 = 1.8 time = 290
* CHECK dout1_28 vdout1_28ck28 = 0 time = 290
* CHECK dout1_29 vdout1_29ck28 = 0 time = 290
* CHECK dout1_30 vdout1_30ck28 = 0 time = 290
* CHECK dout1_31 vdout1_31ck28 = 0 time = 290
* CHECK dout0_0 vdout0_0ck29 = 1.8 time = 300
* CHECK dout0_1 vdout0_1ck29 = 0 time = 300
* CHECK dout0_2 vdout0_2ck29 = 0 time = 300
* CHECK dout0_3 vdout0_3ck29 = 0 time = 300
* CHECK dout0_4 vdout0_4ck29 = 0 time = 300
* CHECK dout0_5 vdout0_5ck29 = 0 time = 300
* CHECK dout0_6 vdout0_6ck29 = 1.8 time = 300
* CHECK dout0_7 vdout0_7ck29 = 1.8 time = 300
* CHECK dout0_8 vdout0_8ck29 = 0 time = 300
* CHECK dout0_9 vdout0_9ck29 = 0 time = 300
* CHECK dout0_10 vdout0_10ck29 = 0 time = 300
* CHECK dout0_11 vdout0_11ck29 = 0 time = 300
* CHECK dout0_12 vdout0_12ck29 = 0 time = 300
* CHECK dout0_13 vdout0_13ck29 = 1.8 time = 300
* CHECK dout0_14 vdout0_14ck29 = 0 time = 300
* CHECK dout0_15 vdout0_15ck29 = 0 time = 300
* CHECK dout0_16 vdout0_16ck29 = 1.8 time = 300
* CHECK dout0_17 vdout0_17ck29 = 0 time = 300
* CHECK dout0_18 vdout0_18ck29 = 1.8 time = 300
* CHECK dout0_19 vdout0_19ck29 = 1.8 time = 300
* CHECK dout0_20 vdout0_20ck29 = 0 time = 300
* CHECK dout0_21 vdout0_21ck29 = 0 time = 300
* CHECK dout0_22 vdout0_22ck29 = 0 time = 300
* CHECK dout0_23 vdout0_23ck29 = 0 time = 300
* CHECK dout0_24 vdout0_24ck29 = 0 time = 300
* CHECK dout0_25 vdout0_25ck29 = 1.8 time = 300
* CHECK dout0_26 vdout0_26ck29 = 0 time = 300
* CHECK dout0_27 vdout0_27ck29 = 1.8 time = 300
* CHECK dout0_28 vdout0_28ck29 = 1.8 time = 300
* CHECK dout0_29 vdout0_29ck29 = 0 time = 300
* CHECK dout0_30 vdout0_30ck29 = 1.8 time = 300
* CHECK dout0_31 vdout0_31ck29 = 1.8 time = 300
* CHECK dout0_0 vdout0_0ck30 = 1.8 time = 310
* CHECK dout0_1 vdout0_1ck30 = 1.8 time = 310
* CHECK dout0_2 vdout0_2ck30 = 0 time = 310
* CHECK dout0_3 vdout0_3ck30 = 0 time = 310
* CHECK dout0_4 vdout0_4ck30 = 0 time = 310
* CHECK dout0_5 vdout0_5ck30 = 0 time = 310
* CHECK dout0_6 vdout0_6ck30 = 0 time = 310
* CHECK dout0_7 vdout0_7ck30 = 1.8 time = 310
* CHECK dout0_8 vdout0_8ck30 = 1.8 time = 310
* CHECK dout0_9 vdout0_9ck30 = 0 time = 310
* CHECK dout0_10 vdout0_10ck30 = 0 time = 310
* CHECK dout0_11 vdout0_11ck30 = 0 time = 310
* CHECK dout0_12 vdout0_12ck30 = 1.8 time = 310
* CHECK dout0_13 vdout0_13ck30 = 0 time = 310
* CHECK dout0_14 vdout0_14ck30 = 0 time = 310
* CHECK dout0_15 vdout0_15ck30 = 0 time = 310
* CHECK dout0_16 vdout0_16ck30 = 1.8 time = 310
* CHECK dout0_17 vdout0_17ck30 = 1.8 time = 310
* CHECK dout0_18 vdout0_18ck30 = 1.8 time = 310
* CHECK dout0_19 vdout0_19ck30 = 0 time = 310
* CHECK dout0_20 vdout0_20ck30 = 0 time = 310
* CHECK dout0_21 vdout0_21ck30 = 0 time = 310
* CHECK dout0_22 vdout0_22ck30 = 0 time = 310
* CHECK dout0_23 vdout0_23ck30 = 1.8 time = 310
* CHECK dout0_24 vdout0_24ck30 = 0 time = 310
* CHECK dout0_25 vdout0_25ck30 = 1.8 time = 310
* CHECK dout0_26 vdout0_26ck30 = 0 time = 310
* CHECK dout0_27 vdout0_27ck30 = 1.8 time = 310
* CHECK dout0_28 vdout0_28ck30 = 0 time = 310
* CHECK dout0_29 vdout0_29ck30 = 0 time = 310
* CHECK dout0_30 vdout0_30ck30 = 0 time = 310
* CHECK dout0_31 vdout0_31ck30 = 0 time = 310
* CHECK dout1_0 vdout1_0ck30 = 1.8 time = 310
* CHECK dout1_1 vdout1_1ck30 = 1.8 time = 310
* CHECK dout1_2 vdout1_2ck30 = 0 time = 310
* CHECK dout1_3 vdout1_3ck30 = 0 time = 310
* CHECK dout1_4 vdout1_4ck30 = 1.8 time = 310
* CHECK dout1_5 vdout1_5ck30 = 1.8 time = 310
* CHECK dout1_6 vdout1_6ck30 = 1.8 time = 310
* CHECK dout1_7 vdout1_7ck30 = 0 time = 310
* CHECK dout1_8 vdout1_8ck30 = 1.8 time = 310
* CHECK dout1_9 vdout1_9ck30 = 0 time = 310
* CHECK dout1_10 vdout1_10ck30 = 0 time = 310
* CHECK dout1_11 vdout1_11ck30 = 0 time = 310
* CHECK dout1_12 vdout1_12ck30 = 0 time = 310
* CHECK dout1_13 vdout1_13ck30 = 0 time = 310
* CHECK dout1_14 vdout1_14ck30 = 0 time = 310
* CHECK dout1_15 vdout1_15ck30 = 1.8 time = 310
* CHECK dout1_16 vdout1_16ck30 = 1.8 time = 310
* CHECK dout1_17 vdout1_17ck30 = 0 time = 310
* CHECK dout1_18 vdout1_18ck30 = 1.8 time = 310
* CHECK dout1_19 vdout1_19ck30 = 0 time = 310
* CHECK dout1_20 vdout1_20ck30 = 1.8 time = 310
* CHECK dout1_21 vdout1_21ck30 = 1.8 time = 310
* CHECK dout1_22 vdout1_22ck30 = 0 time = 310
* CHECK dout1_23 vdout1_23ck30 = 0 time = 310
* CHECK dout1_24 vdout1_24ck30 = 0 time = 310
* CHECK dout1_25 vdout1_25ck30 = 1.8 time = 310
* CHECK dout1_26 vdout1_26ck30 = 1.8 time = 310
* CHECK dout1_27 vdout1_27ck30 = 0 time = 310
* CHECK dout1_28 vdout1_28ck30 = 0 time = 310
* CHECK dout1_29 vdout1_29ck30 = 0 time = 310
* CHECK dout1_30 vdout1_30ck30 = 1.8 time = 310
* CHECK dout1_31 vdout1_31ck30 = 0 time = 310
* CHECK dout1_0 vdout1_0ck32 = 1.8 time = 330
* CHECK dout1_1 vdout1_1ck32 = 0 time = 330
* CHECK dout1_2 vdout1_2ck32 = 1.8 time = 330
* CHECK dout1_3 vdout1_3ck32 = 0 time = 330
* CHECK dout1_4 vdout1_4ck32 = 0 time = 330
* CHECK dout1_5 vdout1_5ck32 = 0 time = 330
* CHECK dout1_6 vdout1_6ck32 = 0 time = 330
* CHECK dout1_7 vdout1_7ck32 = 1.8 time = 330
* CHECK dout1_8 vdout1_8ck32 = 0 time = 330
* CHECK dout1_9 vdout1_9ck32 = 1.8 time = 330
* CHECK dout1_10 vdout1_10ck32 = 0 time = 330
* CHECK dout1_11 vdout1_11ck32 = 0 time = 330
* CHECK dout1_12 vdout1_12ck32 = 1.8 time = 330
* CHECK dout1_13 vdout1_13ck32 = 0 time = 330
* CHECK dout1_14 vdout1_14ck32 = 1.8 time = 330
* CHECK dout1_15 vdout1_15ck32 = 0 time = 330
* CHECK dout1_16 vdout1_16ck32 = 1.8 time = 330
* CHECK dout1_17 vdout1_17ck32 = 1.8 time = 330
* CHECK dout1_18 vdout1_18ck32 = 0 time = 330
* CHECK dout1_19 vdout1_19ck32 = 1.8 time = 330
* CHECK dout1_20 vdout1_20ck32 = 1.8 time = 330
* CHECK dout1_21 vdout1_21ck32 = 1.8 time = 330
* CHECK dout1_22 vdout1_22ck32 = 0 time = 330
* CHECK dout1_23 vdout1_23ck32 = 1.8 time = 330
* CHECK dout1_24 vdout1_24ck32 = 1.8 time = 330
* CHECK dout1_25 vdout1_25ck32 = 1.8 time = 330
* CHECK dout1_26 vdout1_26ck32 = 0 time = 330
* CHECK dout1_27 vdout1_27ck32 = 0 time = 330
* CHECK dout1_28 vdout1_28ck32 = 1.8 time = 330
* CHECK dout1_29 vdout1_29ck32 = 0 time = 330
* CHECK dout1_30 vdout1_30ck32 = 1.8 time = 330
* CHECK dout1_31 vdout1_31ck32 = 0 time = 330
* CHECK dout0_0 vdout0_0ck33 = 1.8 time = 340
* CHECK dout0_1 vdout0_1ck33 = 0 time = 340
* CHECK dout0_2 vdout0_2ck33 = 1.8 time = 340
* CHECK dout0_3 vdout0_3ck33 = 0 time = 340
* CHECK dout0_4 vdout0_4ck33 = 0 time = 340
* CHECK dout0_5 vdout0_5ck33 = 0 time = 340
* CHECK dout0_6 vdout0_6ck33 = 0 time = 340
* CHECK dout0_7 vdout0_7ck33 = 1.8 time = 340
* CHECK dout0_8 vdout0_8ck33 = 0 time = 340
* CHECK dout0_9 vdout0_9ck33 = 1.8 time = 340
* CHECK dout0_10 vdout0_10ck33 = 0 time = 340
* CHECK dout0_11 vdout0_11ck33 = 0 time = 340
* CHECK dout0_12 vdout0_12ck33 = 1.8 time = 340
* CHECK dout0_13 vdout0_13ck33 = 0 time = 340
* CHECK dout0_14 vdout0_14ck33 = 1.8 time = 340
* CHECK dout0_15 vdout0_15ck33 = 0 time = 340
* CHECK dout0_16 vdout0_16ck33 = 1.8 time = 340
* CHECK dout0_17 vdout0_17ck33 = 1.8 time = 340
* CHECK dout0_18 vdout0_18ck33 = 0 time = 340
* CHECK dout0_19 vdout0_19ck33 = 1.8 time = 340
* CHECK dout0_20 vdout0_20ck33 = 1.8 time = 340
* CHECK dout0_21 vdout0_21ck33 = 1.8 time = 340
* CHECK dout0_22 vdout0_22ck33 = 0 time = 340
* CHECK dout0_23 vdout0_23ck33 = 1.8 time = 340
* CHECK dout0_24 vdout0_24ck33 = 1.8 time = 340
* CHECK dout0_25 vdout0_25ck33 = 1.8 time = 340
* CHECK dout0_26 vdout0_26ck33 = 0 time = 340
* CHECK dout0_27 vdout0_27ck33 = 0 time = 340
* CHECK dout0_28 vdout0_28ck33 = 1.8 time = 340
* CHECK dout0_29 vdout0_29ck33 = 0 time = 340
* CHECK dout0_30 vdout0_30ck33 = 1.8 time = 340
* CHECK dout0_31 vdout0_31ck33 = 0 time = 340
* CHECK dout1_0 vdout1_0ck33 = 1.8 time = 340
* CHECK dout1_1 vdout1_1ck33 = 0 time = 340
* CHECK dout1_2 vdout1_2ck33 = 1.8 time = 340
* CHECK dout1_3 vdout1_3ck33 = 0 time = 340
* CHECK dout1_4 vdout1_4ck33 = 0 time = 340
* CHECK dout1_5 vdout1_5ck33 = 0 time = 340
* CHECK dout1_6 vdout1_6ck33 = 0 time = 340
* CHECK dout1_7 vdout1_7ck33 = 1.8 time = 340
* CHECK dout1_8 vdout1_8ck33 = 0 time = 340
* CHECK dout1_9 vdout1_9ck33 = 1.8 time = 340
* CHECK dout1_10 vdout1_10ck33 = 0 time = 340
* CHECK dout1_11 vdout1_11ck33 = 0 time = 340
* CHECK dout1_12 vdout1_12ck33 = 1.8 time = 340
* CHECK dout1_13 vdout1_13ck33 = 0 time = 340
* CHECK dout1_14 vdout1_14ck33 = 1.8 time = 340
* CHECK dout1_15 vdout1_15ck33 = 0 time = 340
* CHECK dout1_16 vdout1_16ck33 = 1.8 time = 340
* CHECK dout1_17 vdout1_17ck33 = 1.8 time = 340
* CHECK dout1_18 vdout1_18ck33 = 0 time = 340
* CHECK dout1_19 vdout1_19ck33 = 1.8 time = 340
* CHECK dout1_20 vdout1_20ck33 = 1.8 time = 340
* CHECK dout1_21 vdout1_21ck33 = 1.8 time = 340
* CHECK dout1_22 vdout1_22ck33 = 0 time = 340
* CHECK dout1_23 vdout1_23ck33 = 1.8 time = 340
* CHECK dout1_24 vdout1_24ck33 = 1.8 time = 340
* CHECK dout1_25 vdout1_25ck33 = 1.8 time = 340
* CHECK dout1_26 vdout1_26ck33 = 0 time = 340
* CHECK dout1_27 vdout1_27ck33 = 0 time = 340
* CHECK dout1_28 vdout1_28ck33 = 1.8 time = 340
* CHECK dout1_29 vdout1_29ck33 = 0 time = 340
* CHECK dout1_30 vdout1_30ck33 = 1.8 time = 340
* CHECK dout1_31 vdout1_31ck33 = 0 time = 340
* CHECK dout0_0 vdout0_0ck35 = 1.8 time = 360
* CHECK dout0_1 vdout0_1ck35 = 0 time = 360
* CHECK dout0_2 vdout0_2ck35 = 0 time = 360
* CHECK dout0_3 vdout0_3ck35 = 0 time = 360
* CHECK dout0_4 vdout0_4ck35 = 0 time = 360
* CHECK dout0_5 vdout0_5ck35 = 0 time = 360
* CHECK dout0_6 vdout0_6ck35 = 1.8 time = 360
* CHECK dout0_7 vdout0_7ck35 = 1.8 time = 360
* CHECK dout0_8 vdout0_8ck35 = 0 time = 360
* CHECK dout0_9 vdout0_9ck35 = 0 time = 360
* CHECK dout0_10 vdout0_10ck35 = 0 time = 360
* CHECK dout0_11 vdout0_11ck35 = 0 time = 360
* CHECK dout0_12 vdout0_12ck35 = 0 time = 360
* CHECK dout0_13 vdout0_13ck35 = 1.8 time = 360
* CHECK dout0_14 vdout0_14ck35 = 0 time = 360
* CHECK dout0_15 vdout0_15ck35 = 0 time = 360
* CHECK dout0_16 vdout0_16ck35 = 1.8 time = 360
* CHECK dout0_17 vdout0_17ck35 = 0 time = 360
* CHECK dout0_18 vdout0_18ck35 = 1.8 time = 360
* CHECK dout0_19 vdout0_19ck35 = 1.8 time = 360
* CHECK dout0_20 vdout0_20ck35 = 0 time = 360
* CHECK dout0_21 vdout0_21ck35 = 0 time = 360
* CHECK dout0_22 vdout0_22ck35 = 0 time = 360
* CHECK dout0_23 vdout0_23ck35 = 0 time = 360
* CHECK dout0_24 vdout0_24ck35 = 0 time = 360
* CHECK dout0_25 vdout0_25ck35 = 1.8 time = 360
* CHECK dout0_26 vdout0_26ck35 = 0 time = 360
* CHECK dout0_27 vdout0_27ck35 = 1.8 time = 360
* CHECK dout0_28 vdout0_28ck35 = 1.8 time = 360
* CHECK dout0_29 vdout0_29ck35 = 0 time = 360
* CHECK dout0_30 vdout0_30ck35 = 1.8 time = 360
* CHECK dout0_31 vdout0_31ck35 = 1.8 time = 360
* CHECK dout0_0 vdout0_0ck36 = 1.8 time = 370
* CHECK dout0_1 vdout0_1ck36 = 1.8 time = 370
* CHECK dout0_2 vdout0_2ck36 = 0 time = 370
* CHECK dout0_3 vdout0_3ck36 = 0 time = 370
* CHECK dout0_4 vdout0_4ck36 = 0 time = 370
* CHECK dout0_5 vdout0_5ck36 = 0 time = 370
* CHECK dout0_6 vdout0_6ck36 = 0 time = 370
* CHECK dout0_7 vdout0_7ck36 = 1.8 time = 370
* CHECK dout0_8 vdout0_8ck36 = 1.8 time = 370
* CHECK dout0_9 vdout0_9ck36 = 0 time = 370
* CHECK dout0_10 vdout0_10ck36 = 0 time = 370
* CHECK dout0_11 vdout0_11ck36 = 0 time = 370
* CHECK dout0_12 vdout0_12ck36 = 1.8 time = 370
* CHECK dout0_13 vdout0_13ck36 = 0 time = 370
* CHECK dout0_14 vdout0_14ck36 = 0 time = 370
* CHECK dout0_15 vdout0_15ck36 = 0 time = 370
* CHECK dout0_16 vdout0_16ck36 = 1.8 time = 370
* CHECK dout0_17 vdout0_17ck36 = 1.8 time = 370
* CHECK dout0_18 vdout0_18ck36 = 1.8 time = 370
* CHECK dout0_19 vdout0_19ck36 = 0 time = 370
* CHECK dout0_20 vdout0_20ck36 = 1.8 time = 370
* CHECK dout0_21 vdout0_21ck36 = 0 time = 370
* CHECK dout0_22 vdout0_22ck36 = 1.8 time = 370
* CHECK dout0_23 vdout0_23ck36 = 1.8 time = 370
* CHECK dout0_24 vdout0_24ck36 = 0 time = 370
* CHECK dout0_25 vdout0_25ck36 = 0 time = 370
* CHECK dout0_26 vdout0_26ck36 = 0 time = 370
* CHECK dout0_27 vdout0_27ck36 = 0 time = 370
* CHECK dout0_28 vdout0_28ck36 = 0 time = 370
* CHECK dout0_29 vdout0_29ck36 = 0 time = 370
* CHECK dout0_30 vdout0_30ck36 = 0 time = 370
* CHECK dout0_31 vdout0_31ck36 = 0 time = 370
* CHECK dout1_0 vdout1_0ck36 = 1.8 time = 370
* CHECK dout1_1 vdout1_1ck36 = 1.8 time = 370
* CHECK dout1_2 vdout1_2ck36 = 0 time = 370
* CHECK dout1_3 vdout1_3ck36 = 0 time = 370
* CHECK dout1_4 vdout1_4ck36 = 0 time = 370
* CHECK dout1_5 vdout1_5ck36 = 0 time = 370
* CHECK dout1_6 vdout1_6ck36 = 0 time = 370
* CHECK dout1_7 vdout1_7ck36 = 1.8 time = 370
* CHECK dout1_8 vdout1_8ck36 = 1.8 time = 370
* CHECK dout1_9 vdout1_9ck36 = 0 time = 370
* CHECK dout1_10 vdout1_10ck36 = 0 time = 370
* CHECK dout1_11 vdout1_11ck36 = 0 time = 370
* CHECK dout1_12 vdout1_12ck36 = 1.8 time = 370
* CHECK dout1_13 vdout1_13ck36 = 0 time = 370
* CHECK dout1_14 vdout1_14ck36 = 0 time = 370
* CHECK dout1_15 vdout1_15ck36 = 0 time = 370
* CHECK dout1_16 vdout1_16ck36 = 1.8 time = 370
* CHECK dout1_17 vdout1_17ck36 = 1.8 time = 370
* CHECK dout1_18 vdout1_18ck36 = 1.8 time = 370
* CHECK dout1_19 vdout1_19ck36 = 0 time = 370
* CHECK dout1_20 vdout1_20ck36 = 1.8 time = 370
* CHECK dout1_21 vdout1_21ck36 = 0 time = 370
* CHECK dout1_22 vdout1_22ck36 = 1.8 time = 370
* CHECK dout1_23 vdout1_23ck36 = 1.8 time = 370
* CHECK dout1_24 vdout1_24ck36 = 0 time = 370
* CHECK dout1_25 vdout1_25ck36 = 0 time = 370
* CHECK dout1_26 vdout1_26ck36 = 0 time = 370
* CHECK dout1_27 vdout1_27ck36 = 0 time = 370
* CHECK dout1_28 vdout1_28ck36 = 0 time = 370
* CHECK dout1_29 vdout1_29ck36 = 0 time = 370
* CHECK dout1_30 vdout1_30ck36 = 0 time = 370
* CHECK dout1_31 vdout1_31ck36 = 0 time = 370
* CHECK dout0_0 vdout0_0ck37 = 1.8 time = 380
* CHECK dout0_1 vdout0_1ck37 = 1.8 time = 380
* CHECK dout0_2 vdout0_2ck37 = 0 time = 380
* CHECK dout0_3 vdout0_3ck37 = 0 time = 380
* CHECK dout0_4 vdout0_4ck37 = 1.8 time = 380
* CHECK dout0_5 vdout0_5ck37 = 1.8 time = 380
* CHECK dout0_6 vdout0_6ck37 = 1.8 time = 380
* CHECK dout0_7 vdout0_7ck37 = 0 time = 380
* CHECK dout0_8 vdout0_8ck37 = 1.8 time = 380
* CHECK dout0_9 vdout0_9ck37 = 0 time = 380
* CHECK dout0_10 vdout0_10ck37 = 0 time = 380
* CHECK dout0_11 vdout0_11ck37 = 0 time = 380
* CHECK dout0_12 vdout0_12ck37 = 0 time = 380
* CHECK dout0_13 vdout0_13ck37 = 0 time = 380
* CHECK dout0_14 vdout0_14ck37 = 0 time = 380
* CHECK dout0_15 vdout0_15ck37 = 1.8 time = 380
* CHECK dout0_16 vdout0_16ck37 = 1.8 time = 380
* CHECK dout0_17 vdout0_17ck37 = 0 time = 380
* CHECK dout0_18 vdout0_18ck37 = 1.8 time = 380
* CHECK dout0_19 vdout0_19ck37 = 0 time = 380
* CHECK dout0_20 vdout0_20ck37 = 1.8 time = 380
* CHECK dout0_21 vdout0_21ck37 = 1.8 time = 380
* CHECK dout0_22 vdout0_22ck37 = 0 time = 380
* CHECK dout0_23 vdout0_23ck37 = 0 time = 380
* CHECK dout0_24 vdout0_24ck37 = 0 time = 380
* CHECK dout0_25 vdout0_25ck37 = 1.8 time = 380
* CHECK dout0_26 vdout0_26ck37 = 1.8 time = 380
* CHECK dout0_27 vdout0_27ck37 = 0 time = 380
* CHECK dout0_28 vdout0_28ck37 = 0 time = 380
* CHECK dout0_29 vdout0_29ck37 = 0 time = 380
* CHECK dout0_30 vdout0_30ck37 = 1.8 time = 380
* CHECK dout0_31 vdout0_31ck37 = 0 time = 380
* CHECK dout1_0 vdout1_0ck37 = 1.8 time = 380
* CHECK dout1_1 vdout1_1ck37 = 1.8 time = 380
* CHECK dout1_2 vdout1_2ck37 = 0 time = 380
* CHECK dout1_3 vdout1_3ck37 = 0 time = 380
* CHECK dout1_4 vdout1_4ck37 = 1.8 time = 380
* CHECK dout1_5 vdout1_5ck37 = 1.8 time = 380
* CHECK dout1_6 vdout1_6ck37 = 1.8 time = 380
* CHECK dout1_7 vdout1_7ck37 = 0 time = 380
* CHECK dout1_8 vdout1_8ck37 = 1.8 time = 380
* CHECK dout1_9 vdout1_9ck37 = 0 time = 380
* CHECK dout1_10 vdout1_10ck37 = 0 time = 380
* CHECK dout1_11 vdout1_11ck37 = 0 time = 380
* CHECK dout1_12 vdout1_12ck37 = 0 time = 380
* CHECK dout1_13 vdout1_13ck37 = 0 time = 380
* CHECK dout1_14 vdout1_14ck37 = 0 time = 380
* CHECK dout1_15 vdout1_15ck37 = 1.8 time = 380
* CHECK dout1_16 vdout1_16ck37 = 1.8 time = 380
* CHECK dout1_17 vdout1_17ck37 = 0 time = 380
* CHECK dout1_18 vdout1_18ck37 = 1.8 time = 380
* CHECK dout1_19 vdout1_19ck37 = 0 time = 380
* CHECK dout1_20 vdout1_20ck37 = 1.8 time = 380
* CHECK dout1_21 vdout1_21ck37 = 1.8 time = 380
* CHECK dout1_22 vdout1_22ck37 = 0 time = 380
* CHECK dout1_23 vdout1_23ck37 = 0 time = 380
* CHECK dout1_24 vdout1_24ck37 = 0 time = 380
* CHECK dout1_25 vdout1_25ck37 = 1.8 time = 380
* CHECK dout1_26 vdout1_26ck37 = 1.8 time = 380
* CHECK dout1_27 vdout1_27ck37 = 0 time = 380
* CHECK dout1_28 vdout1_28ck37 = 0 time = 380
* CHECK dout1_29 vdout1_29ck37 = 0 time = 380
* CHECK dout1_30 vdout1_30ck37 = 1.8 time = 380
* CHECK dout1_31 vdout1_31ck37 = 0 time = 380
* CHECK dout1_0 vdout1_0ck40 = 1.8 time = 410
* CHECK dout1_1 vdout1_1ck40 = 0 time = 410
* CHECK dout1_2 vdout1_2ck40 = 0 time = 410
* CHECK dout1_3 vdout1_3ck40 = 0 time = 410
* CHECK dout1_4 vdout1_4ck40 = 0 time = 410
* CHECK dout1_5 vdout1_5ck40 = 0 time = 410
* CHECK dout1_6 vdout1_6ck40 = 1.8 time = 410
* CHECK dout1_7 vdout1_7ck40 = 1.8 time = 410
* CHECK dout1_8 vdout1_8ck40 = 0 time = 410
* CHECK dout1_9 vdout1_9ck40 = 0 time = 410
* CHECK dout1_10 vdout1_10ck40 = 0 time = 410
* CHECK dout1_11 vdout1_11ck40 = 0 time = 410
* CHECK dout1_12 vdout1_12ck40 = 0 time = 410
* CHECK dout1_13 vdout1_13ck40 = 1.8 time = 410
* CHECK dout1_14 vdout1_14ck40 = 0 time = 410
* CHECK dout1_15 vdout1_15ck40 = 0 time = 410
* CHECK dout1_16 vdout1_16ck40 = 1.8 time = 410
* CHECK dout1_17 vdout1_17ck40 = 0 time = 410
* CHECK dout1_18 vdout1_18ck40 = 1.8 time = 410
* CHECK dout1_19 vdout1_19ck40 = 1.8 time = 410
* CHECK dout1_20 vdout1_20ck40 = 0 time = 410
* CHECK dout1_21 vdout1_21ck40 = 0 time = 410
* CHECK dout1_22 vdout1_22ck40 = 0 time = 410
* CHECK dout1_23 vdout1_23ck40 = 0 time = 410
* CHECK dout1_24 vdout1_24ck40 = 0 time = 410
* CHECK dout1_25 vdout1_25ck40 = 1.8 time = 410
* CHECK dout1_26 vdout1_26ck40 = 0 time = 410
* CHECK dout1_27 vdout1_27ck40 = 1.8 time = 410
* CHECK dout1_28 vdout1_28ck40 = 1.8 time = 410
* CHECK dout1_29 vdout1_29ck40 = 0 time = 410
* CHECK dout1_30 vdout1_30ck40 = 1.8 time = 410
* CHECK dout1_31 vdout1_31ck40 = 1.8 time = 410
* CHECK dout1_0 vdout1_0ck41 = 0 time = 420
* CHECK dout1_1 vdout1_1ck41 = 0 time = 420
* CHECK dout1_2 vdout1_2ck41 = 0 time = 420
* CHECK dout1_3 vdout1_3ck41 = 0 time = 420
* CHECK dout1_4 vdout1_4ck41 = 1.8 time = 420
* CHECK dout1_5 vdout1_5ck41 = 1.8 time = 420
* CHECK dout1_6 vdout1_6ck41 = 1.8 time = 420
* CHECK dout1_7 vdout1_7ck41 = 0 time = 420
* CHECK dout1_8 vdout1_8ck41 = 1.8 time = 420
* CHECK dout1_9 vdout1_9ck41 = 0 time = 420
* CHECK dout1_10 vdout1_10ck41 = 0 time = 420
* CHECK dout1_11 vdout1_11ck41 = 1.8 time = 420
* CHECK dout1_12 vdout1_12ck41 = 1.8 time = 420
* CHECK dout1_13 vdout1_13ck41 = 0 time = 420
* CHECK dout1_14 vdout1_14ck41 = 1.8 time = 420
* CHECK dout1_15 vdout1_15ck41 = 0 time = 420
* CHECK dout1_16 vdout1_16ck41 = 1.8 time = 420
* CHECK dout1_17 vdout1_17ck41 = 0 time = 420
* CHECK dout1_18 vdout1_18ck41 = 0 time = 420
* CHECK dout1_19 vdout1_19ck41 = 1.8 time = 420
* CHECK dout1_20 vdout1_20ck41 = 0 time = 420
* CHECK dout1_21 vdout1_21ck41 = 1.8 time = 420
* CHECK dout1_22 vdout1_22ck41 = 0 time = 420
* CHECK dout1_23 vdout1_23ck41 = 0 time = 420
* CHECK dout1_24 vdout1_24ck41 = 1.8 time = 420
* CHECK dout1_25 vdout1_25ck41 = 0 time = 420
* CHECK dout1_26 vdout1_26ck41 = 1.8 time = 420
* CHECK dout1_27 vdout1_27ck41 = 0 time = 420
* CHECK dout1_28 vdout1_28ck41 = 1.8 time = 420
* CHECK dout1_29 vdout1_29ck41 = 1.8 time = 420
* CHECK dout1_30 vdout1_30ck41 = 1.8 time = 420
* CHECK dout1_31 vdout1_31ck41 = 1.8 time = 420
* CHECK dout1_0 vdout1_0ck43 = 1.8 time = 440
* CHECK dout1_1 vdout1_1ck43 = 0 time = 440
* CHECK dout1_2 vdout1_2ck43 = 1.8 time = 440
* CHECK dout1_3 vdout1_3ck43 = 0 time = 440
* CHECK dout1_4 vdout1_4ck43 = 0 time = 440
* CHECK dout1_5 vdout1_5ck43 = 0 time = 440
* CHECK dout1_6 vdout1_6ck43 = 0 time = 440
* CHECK dout1_7 vdout1_7ck43 = 1.8 time = 440
* CHECK dout1_8 vdout1_8ck43 = 0 time = 440
* CHECK dout1_9 vdout1_9ck43 = 1.8 time = 440
* CHECK dout1_10 vdout1_10ck43 = 0 time = 440
* CHECK dout1_11 vdout1_11ck43 = 0 time = 440
* CHECK dout1_12 vdout1_12ck43 = 1.8 time = 440
* CHECK dout1_13 vdout1_13ck43 = 0 time = 440
* CHECK dout1_14 vdout1_14ck43 = 1.8 time = 440
* CHECK dout1_15 vdout1_15ck43 = 0 time = 440
* CHECK dout1_16 vdout1_16ck43 = 1.8 time = 440
* CHECK dout1_17 vdout1_17ck43 = 1.8 time = 440
* CHECK dout1_18 vdout1_18ck43 = 0 time = 440
* CHECK dout1_19 vdout1_19ck43 = 1.8 time = 440
* CHECK dout1_20 vdout1_20ck43 = 1.8 time = 440
* CHECK dout1_21 vdout1_21ck43 = 1.8 time = 440
* CHECK dout1_22 vdout1_22ck43 = 0 time = 440
* CHECK dout1_23 vdout1_23ck43 = 1.8 time = 440
* CHECK dout1_24 vdout1_24ck43 = 1.8 time = 440
* CHECK dout1_25 vdout1_25ck43 = 1.8 time = 440
* CHECK dout1_26 vdout1_26ck43 = 0 time = 440
* CHECK dout1_27 vdout1_27ck43 = 0 time = 440
* CHECK dout1_28 vdout1_28ck43 = 1.8 time = 440
* CHECK dout1_29 vdout1_29ck43 = 0 time = 440
* CHECK dout1_30 vdout1_30ck43 = 1.8 time = 440
* CHECK dout1_31 vdout1_31ck43 = 0 time = 440
* CHECK dout0_0 vdout0_0ck45 = 1.8 time = 460
* CHECK dout0_1 vdout0_1ck45 = 0 time = 460
* CHECK dout0_2 vdout0_2ck45 = 1.8 time = 460
* CHECK dout0_3 vdout0_3ck45 = 0 time = 460
* CHECK dout0_4 vdout0_4ck45 = 0 time = 460
* CHECK dout0_5 vdout0_5ck45 = 0 time = 460
* CHECK dout0_6 vdout0_6ck45 = 0 time = 460
* CHECK dout0_7 vdout0_7ck45 = 1.8 time = 460
* CHECK dout0_8 vdout0_8ck45 = 0 time = 460
* CHECK dout0_9 vdout0_9ck45 = 1.8 time = 460
* CHECK dout0_10 vdout0_10ck45 = 0 time = 460
* CHECK dout0_11 vdout0_11ck45 = 0 time = 460
* CHECK dout0_12 vdout0_12ck45 = 1.8 time = 460
* CHECK dout0_13 vdout0_13ck45 = 0 time = 460
* CHECK dout0_14 vdout0_14ck45 = 1.8 time = 460
* CHECK dout0_15 vdout0_15ck45 = 0 time = 460
* CHECK dout0_16 vdout0_16ck45 = 1.8 time = 460
* CHECK dout0_17 vdout0_17ck45 = 1.8 time = 460
* CHECK dout0_18 vdout0_18ck45 = 0 time = 460
* CHECK dout0_19 vdout0_19ck45 = 1.8 time = 460
* CHECK dout0_20 vdout0_20ck45 = 1.8 time = 460
* CHECK dout0_21 vdout0_21ck45 = 1.8 time = 460
* CHECK dout0_22 vdout0_22ck45 = 0 time = 460
* CHECK dout0_23 vdout0_23ck45 = 1.8 time = 460
* CHECK dout0_24 vdout0_24ck45 = 1.8 time = 460
* CHECK dout0_25 vdout0_25ck45 = 1.8 time = 460
* CHECK dout0_26 vdout0_26ck45 = 0 time = 460
* CHECK dout0_27 vdout0_27ck45 = 0 time = 460
* CHECK dout0_28 vdout0_28ck45 = 1.8 time = 460
* CHECK dout0_29 vdout0_29ck45 = 0 time = 460
* CHECK dout0_30 vdout0_30ck45 = 1.8 time = 460
* CHECK dout0_31 vdout0_31ck45 = 0 time = 460
* CHECK dout1_0 vdout1_0ck45 = 0 time = 460
* CHECK dout1_1 vdout1_1ck45 = 0 time = 460
* CHECK dout1_2 vdout1_2ck45 = 0 time = 460
* CHECK dout1_3 vdout1_3ck45 = 0 time = 460
* CHECK dout1_4 vdout1_4ck45 = 1.8 time = 460
* CHECK dout1_5 vdout1_5ck45 = 1.8 time = 460
* CHECK dout1_6 vdout1_6ck45 = 1.8 time = 460
* CHECK dout1_7 vdout1_7ck45 = 0 time = 460
* CHECK dout1_8 vdout1_8ck45 = 1.8 time = 460
* CHECK dout1_9 vdout1_9ck45 = 0 time = 460
* CHECK dout1_10 vdout1_10ck45 = 0 time = 460
* CHECK dout1_11 vdout1_11ck45 = 1.8 time = 460
* CHECK dout1_12 vdout1_12ck45 = 1.8 time = 460
* CHECK dout1_13 vdout1_13ck45 = 0 time = 460
* CHECK dout1_14 vdout1_14ck45 = 1.8 time = 460
* CHECK dout1_15 vdout1_15ck45 = 0 time = 460
* CHECK dout1_16 vdout1_16ck45 = 1.8 time = 460
* CHECK dout1_17 vdout1_17ck45 = 0 time = 460
* CHECK dout1_18 vdout1_18ck45 = 0 time = 460
* CHECK dout1_19 vdout1_19ck45 = 1.8 time = 460
* CHECK dout1_20 vdout1_20ck45 = 0 time = 460
* CHECK dout1_21 vdout1_21ck45 = 1.8 time = 460
* CHECK dout1_22 vdout1_22ck45 = 0 time = 460
* CHECK dout1_23 vdout1_23ck45 = 0 time = 460
* CHECK dout1_24 vdout1_24ck45 = 1.8 time = 460
* CHECK dout1_25 vdout1_25ck45 = 0 time = 460
* CHECK dout1_26 vdout1_26ck45 = 1.8 time = 460
* CHECK dout1_27 vdout1_27ck45 = 0 time = 460
* CHECK dout1_28 vdout1_28ck45 = 1.8 time = 460
* CHECK dout1_29 vdout1_29ck45 = 1.8 time = 460
* CHECK dout1_30 vdout1_30ck45 = 1.8 time = 460
* CHECK dout1_31 vdout1_31ck45 = 1.8 time = 460
* CHECK dout0_0 vdout0_0ck47 = 0 time = 480
* CHECK dout0_1 vdout0_1ck47 = 0 time = 480
* CHECK dout0_2 vdout0_2ck47 = 0 time = 480
* CHECK dout0_3 vdout0_3ck47 = 0 time = 480
* CHECK dout0_4 vdout0_4ck47 = 1.8 time = 480
* CHECK dout0_5 vdout0_5ck47 = 1.8 time = 480
* CHECK dout0_6 vdout0_6ck47 = 1.8 time = 480
* CHECK dout0_7 vdout0_7ck47 = 0 time = 480
* CHECK dout0_8 vdout0_8ck47 = 1.8 time = 480
* CHECK dout0_9 vdout0_9ck47 = 0 time = 480
* CHECK dout0_10 vdout0_10ck47 = 0 time = 480
* CHECK dout0_11 vdout0_11ck47 = 1.8 time = 480
* CHECK dout0_12 vdout0_12ck47 = 1.8 time = 480
* CHECK dout0_13 vdout0_13ck47 = 0 time = 480
* CHECK dout0_14 vdout0_14ck47 = 1.8 time = 480
* CHECK dout0_15 vdout0_15ck47 = 0 time = 480
* CHECK dout0_16 vdout0_16ck47 = 1.8 time = 480
* CHECK dout0_17 vdout0_17ck47 = 0 time = 480
* CHECK dout0_18 vdout0_18ck47 = 0 time = 480
* CHECK dout0_19 vdout0_19ck47 = 1.8 time = 480
* CHECK dout0_20 vdout0_20ck47 = 0 time = 480
* CHECK dout0_21 vdout0_21ck47 = 1.8 time = 480
* CHECK dout0_22 vdout0_22ck47 = 0 time = 480
* CHECK dout0_23 vdout0_23ck47 = 0 time = 480
* CHECK dout0_24 vdout0_24ck47 = 1.8 time = 480
* CHECK dout0_25 vdout0_25ck47 = 0 time = 480
* CHECK dout0_26 vdout0_26ck47 = 1.8 time = 480
* CHECK dout0_27 vdout0_27ck47 = 0 time = 480
* CHECK dout0_28 vdout0_28ck47 = 1.8 time = 480
* CHECK dout0_29 vdout0_29ck47 = 1.8 time = 480
* CHECK dout0_30 vdout0_30ck47 = 1.8 time = 480
* CHECK dout0_31 vdout0_31ck47 = 1.8 time = 480
* CHECK dout1_0 vdout1_0ck47 = 1.8 time = 480
* CHECK dout1_1 vdout1_1ck47 = 0 time = 480
* CHECK dout1_2 vdout1_2ck47 = 1.8 time = 480
* CHECK dout1_3 vdout1_3ck47 = 0 time = 480
* CHECK dout1_4 vdout1_4ck47 = 0 time = 480
* CHECK dout1_5 vdout1_5ck47 = 0 time = 480
* CHECK dout1_6 vdout1_6ck47 = 0 time = 480
* CHECK dout1_7 vdout1_7ck47 = 1.8 time = 480
* CHECK dout1_8 vdout1_8ck47 = 0 time = 480
* CHECK dout1_9 vdout1_9ck47 = 1.8 time = 480
* CHECK dout1_10 vdout1_10ck47 = 0 time = 480
* CHECK dout1_11 vdout1_11ck47 = 0 time = 480
* CHECK dout1_12 vdout1_12ck47 = 1.8 time = 480
* CHECK dout1_13 vdout1_13ck47 = 0 time = 480
* CHECK dout1_14 vdout1_14ck47 = 1.8 time = 480
* CHECK dout1_15 vdout1_15ck47 = 0 time = 480
* CHECK dout1_16 vdout1_16ck47 = 1.8 time = 480
* CHECK dout1_17 vdout1_17ck47 = 1.8 time = 480
* CHECK dout1_18 vdout1_18ck47 = 0 time = 480
* CHECK dout1_19 vdout1_19ck47 = 1.8 time = 480
* CHECK dout1_20 vdout1_20ck47 = 1.8 time = 480
* CHECK dout1_21 vdout1_21ck47 = 1.8 time = 480
* CHECK dout1_22 vdout1_22ck47 = 0 time = 480
* CHECK dout1_23 vdout1_23ck47 = 1.8 time = 480
* CHECK dout1_24 vdout1_24ck47 = 1.8 time = 480
* CHECK dout1_25 vdout1_25ck47 = 1.8 time = 480
* CHECK dout1_26 vdout1_26ck47 = 0 time = 480
* CHECK dout1_27 vdout1_27ck47 = 0 time = 480
* CHECK dout1_28 vdout1_28ck47 = 1.8 time = 480
* CHECK dout1_29 vdout1_29ck47 = 0 time = 480
* CHECK dout1_30 vdout1_30ck47 = 1.8 time = 480
* CHECK dout1_31 vdout1_31ck47 = 0 time = 480
* CHECK dout0_0 vdout0_0ck48 = 1.8 time = 490
* CHECK dout0_1 vdout0_1ck48 = 0 time = 490
* CHECK dout0_2 vdout0_2ck48 = 1.8 time = 490
* CHECK dout0_3 vdout0_3ck48 = 0 time = 490
* CHECK dout0_4 vdout0_4ck48 = 0 time = 490
* CHECK dout0_5 vdout0_5ck48 = 0 time = 490
* CHECK dout0_6 vdout0_6ck48 = 0 time = 490
* CHECK dout0_7 vdout0_7ck48 = 1.8 time = 490
* CHECK dout0_8 vdout0_8ck48 = 0 time = 490
* CHECK dout0_9 vdout0_9ck48 = 1.8 time = 490
* CHECK dout0_10 vdout0_10ck48 = 0 time = 490
* CHECK dout0_11 vdout0_11ck48 = 0 time = 490
* CHECK dout0_12 vdout0_12ck48 = 1.8 time = 490
* CHECK dout0_13 vdout0_13ck48 = 0 time = 490
* CHECK dout0_14 vdout0_14ck48 = 1.8 time = 490
* CHECK dout0_15 vdout0_15ck48 = 0 time = 490
* CHECK dout0_16 vdout0_16ck48 = 1.8 time = 490
* CHECK dout0_17 vdout0_17ck48 = 1.8 time = 490
* CHECK dout0_18 vdout0_18ck48 = 0 time = 490
* CHECK dout0_19 vdout0_19ck48 = 1.8 time = 490
* CHECK dout0_20 vdout0_20ck48 = 1.8 time = 490
* CHECK dout0_21 vdout0_21ck48 = 1.8 time = 490
* CHECK dout0_22 vdout0_22ck48 = 0 time = 490
* CHECK dout0_23 vdout0_23ck48 = 1.8 time = 490
* CHECK dout0_24 vdout0_24ck48 = 1.8 time = 490
* CHECK dout0_25 vdout0_25ck48 = 1.8 time = 490
* CHECK dout0_26 vdout0_26ck48 = 0 time = 490
* CHECK dout0_27 vdout0_27ck48 = 0 time = 490
* CHECK dout0_28 vdout0_28ck48 = 1.8 time = 490
* CHECK dout0_29 vdout0_29ck48 = 0 time = 490
* CHECK dout0_30 vdout0_30ck48 = 1.8 time = 490
* CHECK dout0_31 vdout0_31ck48 = 0 time = 490
* CHECK dout0_0 vdout0_0ck49 = 1.8 time = 500
* CHECK dout0_1 vdout0_1ck49 = 1.8 time = 500
* CHECK dout0_2 vdout0_2ck49 = 0 time = 500
* CHECK dout0_3 vdout0_3ck49 = 0 time = 500
* CHECK dout0_4 vdout0_4ck49 = 1.8 time = 500
* CHECK dout0_5 vdout0_5ck49 = 0 time = 500
* CHECK dout0_6 vdout0_6ck49 = 0 time = 500
* CHECK dout0_7 vdout0_7ck49 = 1.8 time = 500
* CHECK dout0_8 vdout0_8ck49 = 0 time = 500
* CHECK dout0_9 vdout0_9ck49 = 0 time = 500
* CHECK dout0_10 vdout0_10ck49 = 0 time = 500
* CHECK dout0_11 vdout0_11ck49 = 0 time = 500
* CHECK dout0_12 vdout0_12ck49 = 0 time = 500
* CHECK dout0_13 vdout0_13ck49 = 1.8 time = 500
* CHECK dout0_14 vdout0_14ck49 = 0 time = 500
* CHECK dout0_15 vdout0_15ck49 = 0 time = 500
* CHECK dout0_16 vdout0_16ck49 = 1.8 time = 500
* CHECK dout0_17 vdout0_17ck49 = 1.8 time = 500
* CHECK dout0_18 vdout0_18ck49 = 0 time = 500
* CHECK dout0_19 vdout0_19ck49 = 0 time = 500
* CHECK dout0_20 vdout0_20ck49 = 1.8 time = 500
* CHECK dout0_21 vdout0_21ck49 = 0 time = 500
* CHECK dout0_22 vdout0_22ck49 = 1.8 time = 500
* CHECK dout0_23 vdout0_23ck49 = 1.8 time = 500
* CHECK dout0_24 vdout0_24ck49 = 1.8 time = 500
* CHECK dout0_25 vdout0_25ck49 = 0 time = 500
* CHECK dout0_26 vdout0_26ck49 = 0 time = 500
* CHECK dout0_27 vdout0_27ck49 = 1.8 time = 500
* CHECK dout0_28 vdout0_28ck49 = 1.8 time = 500
* CHECK dout0_29 vdout0_29ck49 = 1.8 time = 500
* CHECK dout0_30 vdout0_30ck49 = 1.8 time = 500
* CHECK dout0_31 vdout0_31ck49 = 1.8 time = 500
* CHECK dout1_0 vdout1_0ck49 = 1.8 time = 500
* CHECK dout1_1 vdout1_1ck49 = 0 time = 500
* CHECK dout1_2 vdout1_2ck49 = 1.8 time = 500
* CHECK dout1_3 vdout1_3ck49 = 0 time = 500
* CHECK dout1_4 vdout1_4ck49 = 0 time = 500
* CHECK dout1_5 vdout1_5ck49 = 0 time = 500
* CHECK dout1_6 vdout1_6ck49 = 0 time = 500
* CHECK dout1_7 vdout1_7ck49 = 1.8 time = 500
* CHECK dout1_8 vdout1_8ck49 = 0 time = 500
* CHECK dout1_9 vdout1_9ck49 = 1.8 time = 500
* CHECK dout1_10 vdout1_10ck49 = 0 time = 500
* CHECK dout1_11 vdout1_11ck49 = 0 time = 500
* CHECK dout1_12 vdout1_12ck49 = 1.8 time = 500
* CHECK dout1_13 vdout1_13ck49 = 0 time = 500
* CHECK dout1_14 vdout1_14ck49 = 1.8 time = 500
* CHECK dout1_15 vdout1_15ck49 = 0 time = 500
* CHECK dout1_16 vdout1_16ck49 = 1.8 time = 500
* CHECK dout1_17 vdout1_17ck49 = 1.8 time = 500
* CHECK dout1_18 vdout1_18ck49 = 0 time = 500
* CHECK dout1_19 vdout1_19ck49 = 1.8 time = 500
* CHECK dout1_20 vdout1_20ck49 = 1.8 time = 500
* CHECK dout1_21 vdout1_21ck49 = 1.8 time = 500
* CHECK dout1_22 vdout1_22ck49 = 0 time = 500
* CHECK dout1_23 vdout1_23ck49 = 1.8 time = 500
* CHECK dout1_24 vdout1_24ck49 = 1.8 time = 500
* CHECK dout1_25 vdout1_25ck49 = 1.8 time = 500
* CHECK dout1_26 vdout1_26ck49 = 0 time = 500
* CHECK dout1_27 vdout1_27ck49 = 0 time = 500
* CHECK dout1_28 vdout1_28ck49 = 1.8 time = 500
* CHECK dout1_29 vdout1_29ck49 = 0 time = 500
* CHECK dout1_30 vdout1_30ck49 = 1.8 time = 500
* CHECK dout1_31 vdout1_31ck49 = 0 time = 500
* CHECK dout0_0 vdout0_0ck52 = 0 time = 530
* CHECK dout0_1 vdout0_1ck52 = 0 time = 530
* CHECK dout0_2 vdout0_2ck52 = 1.8 time = 530
* CHECK dout0_3 vdout0_3ck52 = 1.8 time = 530
* CHECK dout0_4 vdout0_4ck52 = 0 time = 530
* CHECK dout0_5 vdout0_5ck52 = 0 time = 530
* CHECK dout0_6 vdout0_6ck52 = 0 time = 530
* CHECK dout0_7 vdout0_7ck52 = 0 time = 530
* CHECK dout0_8 vdout0_8ck52 = 0 time = 530
* CHECK dout0_9 vdout0_9ck52 = 0 time = 530
* CHECK dout0_10 vdout0_10ck52 = 0 time = 530
* CHECK dout0_11 vdout0_11ck52 = 0 time = 530
* CHECK dout0_12 vdout0_12ck52 = 0 time = 530
* CHECK dout0_13 vdout0_13ck52 = 0 time = 530
* CHECK dout0_14 vdout0_14ck52 = 1.8 time = 530
* CHECK dout0_15 vdout0_15ck52 = 1.8 time = 530
* CHECK dout0_16 vdout0_16ck52 = 1.8 time = 530
* CHECK dout0_17 vdout0_17ck52 = 1.8 time = 530
* CHECK dout0_18 vdout0_18ck52 = 1.8 time = 530
* CHECK dout0_19 vdout0_19ck52 = 1.8 time = 530
* CHECK dout0_20 vdout0_20ck52 = 0 time = 530
* CHECK dout0_21 vdout0_21ck52 = 0 time = 530
* CHECK dout0_22 vdout0_22ck52 = 1.8 time = 530
* CHECK dout0_23 vdout0_23ck52 = 1.8 time = 530
* CHECK dout0_24 vdout0_24ck52 = 1.8 time = 530
* CHECK dout0_25 vdout0_25ck52 = 0 time = 530
* CHECK dout0_26 vdout0_26ck52 = 0 time = 530
* CHECK dout0_27 vdout0_27ck52 = 1.8 time = 530
* CHECK dout0_28 vdout0_28ck52 = 1.8 time = 530
* CHECK dout0_29 vdout0_29ck52 = 1.8 time = 530
* CHECK dout0_30 vdout0_30ck52 = 1.8 time = 530
* CHECK dout0_31 vdout0_31ck52 = 1.8 time = 530
* CHECK dout1_0 vdout1_0ck52 = 1.8 time = 530
* CHECK dout1_1 vdout1_1ck52 = 0 time = 530
* CHECK dout1_2 vdout1_2ck52 = 1.8 time = 530
* CHECK dout1_3 vdout1_3ck52 = 0 time = 530
* CHECK dout1_4 vdout1_4ck52 = 0 time = 530
* CHECK dout1_5 vdout1_5ck52 = 0 time = 530
* CHECK dout1_6 vdout1_6ck52 = 0 time = 530
* CHECK dout1_7 vdout1_7ck52 = 1.8 time = 530
* CHECK dout1_8 vdout1_8ck52 = 0 time = 530
* CHECK dout1_9 vdout1_9ck52 = 1.8 time = 530
* CHECK dout1_10 vdout1_10ck52 = 0 time = 530
* CHECK dout1_11 vdout1_11ck52 = 0 time = 530
* CHECK dout1_12 vdout1_12ck52 = 1.8 time = 530
* CHECK dout1_13 vdout1_13ck52 = 0 time = 530
* CHECK dout1_14 vdout1_14ck52 = 1.8 time = 530
* CHECK dout1_15 vdout1_15ck52 = 0 time = 530
* CHECK dout1_16 vdout1_16ck52 = 1.8 time = 530
* CHECK dout1_17 vdout1_17ck52 = 1.8 time = 530
* CHECK dout1_18 vdout1_18ck52 = 0 time = 530
* CHECK dout1_19 vdout1_19ck52 = 1.8 time = 530
* CHECK dout1_20 vdout1_20ck52 = 1.8 time = 530
* CHECK dout1_21 vdout1_21ck52 = 1.8 time = 530
* CHECK dout1_22 vdout1_22ck52 = 0 time = 530
* CHECK dout1_23 vdout1_23ck52 = 1.8 time = 530
* CHECK dout1_24 vdout1_24ck52 = 1.8 time = 530
* CHECK dout1_25 vdout1_25ck52 = 1.8 time = 530
* CHECK dout1_26 vdout1_26ck52 = 0 time = 530
* CHECK dout1_27 vdout1_27ck52 = 0 time = 530
* CHECK dout1_28 vdout1_28ck52 = 1.8 time = 530
* CHECK dout1_29 vdout1_29ck52 = 0 time = 530
* CHECK dout1_30 vdout1_30ck52 = 1.8 time = 530
* CHECK dout1_31 vdout1_31ck52 = 0 time = 530
* CHECK dout1_0 vdout1_0ck54 = 0 time = 550
* CHECK dout1_1 vdout1_1ck54 = 0 time = 550
* CHECK dout1_2 vdout1_2ck54 = 1.8 time = 550
* CHECK dout1_3 vdout1_3ck54 = 1.8 time = 550
* CHECK dout1_4 vdout1_4ck54 = 0 time = 550
* CHECK dout1_5 vdout1_5ck54 = 0 time = 550
* CHECK dout1_6 vdout1_6ck54 = 0 time = 550
* CHECK dout1_7 vdout1_7ck54 = 0 time = 550
* CHECK dout1_8 vdout1_8ck54 = 0 time = 550
* CHECK dout1_9 vdout1_9ck54 = 0 time = 550
* CHECK dout1_10 vdout1_10ck54 = 0 time = 550
* CHECK dout1_11 vdout1_11ck54 = 0 time = 550
* CHECK dout1_12 vdout1_12ck54 = 0 time = 550
* CHECK dout1_13 vdout1_13ck54 = 0 time = 550
* CHECK dout1_14 vdout1_14ck54 = 1.8 time = 550
* CHECK dout1_15 vdout1_15ck54 = 1.8 time = 550
* CHECK dout1_16 vdout1_16ck54 = 1.8 time = 550
* CHECK dout1_17 vdout1_17ck54 = 1.8 time = 550
* CHECK dout1_18 vdout1_18ck54 = 1.8 time = 550
* CHECK dout1_19 vdout1_19ck54 = 1.8 time = 550
* CHECK dout1_20 vdout1_20ck54 = 0 time = 550
* CHECK dout1_21 vdout1_21ck54 = 0 time = 550
* CHECK dout1_22 vdout1_22ck54 = 1.8 time = 550
* CHECK dout1_23 vdout1_23ck54 = 1.8 time = 550
* CHECK dout1_24 vdout1_24ck54 = 1.8 time = 550
* CHECK dout1_25 vdout1_25ck54 = 0 time = 550
* CHECK dout1_26 vdout1_26ck54 = 0 time = 550
* CHECK dout1_27 vdout1_27ck54 = 1.8 time = 550
* CHECK dout1_28 vdout1_28ck54 = 1.8 time = 550
* CHECK dout1_29 vdout1_29ck54 = 1.8 time = 550
* CHECK dout1_30 vdout1_30ck54 = 1.8 time = 550
* CHECK dout1_31 vdout1_31ck54 = 1.8 time = 550
* CHECK dout0_0 vdout0_0ck55 = 0 time = 560
* CHECK dout0_1 vdout0_1ck55 = 1.8 time = 560
* CHECK dout0_2 vdout0_2ck55 = 1.8 time = 560
* CHECK dout0_3 vdout0_3ck55 = 1.8 time = 560
* CHECK dout0_4 vdout0_4ck55 = 1.8 time = 560
* CHECK dout0_5 vdout0_5ck55 = 0 time = 560
* CHECK dout0_6 vdout0_6ck55 = 0 time = 560
* CHECK dout0_7 vdout0_7ck55 = 1.8 time = 560
* CHECK dout0_8 vdout0_8ck55 = 1.8 time = 560
* CHECK dout0_9 vdout0_9ck55 = 0 time = 560
* CHECK dout0_10 vdout0_10ck55 = 0 time = 560
* CHECK dout0_11 vdout0_11ck55 = 1.8 time = 560
* CHECK dout0_12 vdout0_12ck55 = 1.8 time = 560
* CHECK dout0_13 vdout0_13ck55 = 1.8 time = 560
* CHECK dout0_14 vdout0_14ck55 = 0 time = 560
* CHECK dout0_15 vdout0_15ck55 = 1.8 time = 560
* CHECK dout0_16 vdout0_16ck55 = 0 time = 560
* CHECK dout0_17 vdout0_17ck55 = 0 time = 560
* CHECK dout0_18 vdout0_18ck55 = 1.8 time = 560
* CHECK dout0_19 vdout0_19ck55 = 0 time = 560
* CHECK dout0_20 vdout0_20ck55 = 0 time = 560
* CHECK dout0_21 vdout0_21ck55 = 0 time = 560
* CHECK dout0_22 vdout0_22ck55 = 1.8 time = 560
* CHECK dout0_23 vdout0_23ck55 = 0 time = 560
* CHECK dout0_24 vdout0_24ck55 = 1.8 time = 560
* CHECK dout0_25 vdout0_25ck55 = 1.8 time = 560
* CHECK dout0_26 vdout0_26ck55 = 0 time = 560
* CHECK dout0_27 vdout0_27ck55 = 1.8 time = 560
* CHECK dout0_28 vdout0_28ck55 = 0 time = 560
* CHECK dout0_29 vdout0_29ck55 = 0 time = 560
* CHECK dout0_30 vdout0_30ck55 = 1.8 time = 560
* CHECK dout0_31 vdout0_31ck55 = 1.8 time = 560
* CHECK dout0_0 vdout0_0ck56 = 0 time = 570
* CHECK dout0_1 vdout0_1ck56 = 0 time = 570
* CHECK dout0_2 vdout0_2ck56 = 1.8 time = 570
* CHECK dout0_3 vdout0_3ck56 = 1.8 time = 570
* CHECK dout0_4 vdout0_4ck56 = 0 time = 570
* CHECK dout0_5 vdout0_5ck56 = 0 time = 570
* CHECK dout0_6 vdout0_6ck56 = 0 time = 570
* CHECK dout0_7 vdout0_7ck56 = 0 time = 570
* CHECK dout0_8 vdout0_8ck56 = 0 time = 570
* CHECK dout0_9 vdout0_9ck56 = 0 time = 570
* CHECK dout0_10 vdout0_10ck56 = 0 time = 570
* CHECK dout0_11 vdout0_11ck56 = 0 time = 570
* CHECK dout0_12 vdout0_12ck56 = 0 time = 570
* CHECK dout0_13 vdout0_13ck56 = 0 time = 570
* CHECK dout0_14 vdout0_14ck56 = 1.8 time = 570
* CHECK dout0_15 vdout0_15ck56 = 1.8 time = 570
* CHECK dout0_16 vdout0_16ck56 = 1.8 time = 570
* CHECK dout0_17 vdout0_17ck56 = 1.8 time = 570
* CHECK dout0_18 vdout0_18ck56 = 1.8 time = 570
* CHECK dout0_19 vdout0_19ck56 = 1.8 time = 570
* CHECK dout0_20 vdout0_20ck56 = 0 time = 570
* CHECK dout0_21 vdout0_21ck56 = 0 time = 570
* CHECK dout0_22 vdout0_22ck56 = 1.8 time = 570
* CHECK dout0_23 vdout0_23ck56 = 1.8 time = 570
* CHECK dout0_24 vdout0_24ck56 = 1.8 time = 570
* CHECK dout0_25 vdout0_25ck56 = 0 time = 570
* CHECK dout0_26 vdout0_26ck56 = 0 time = 570
* CHECK dout0_27 vdout0_27ck56 = 1.8 time = 570
* CHECK dout0_28 vdout0_28ck56 = 1.8 time = 570
* CHECK dout0_29 vdout0_29ck56 = 1.8 time = 570
* CHECK dout0_30 vdout0_30ck56 = 1.8 time = 570
* CHECK dout0_31 vdout0_31ck56 = 1.8 time = 570
* CHECK dout0_0 vdout0_0ck57 = 0 time = 580
* CHECK dout0_1 vdout0_1ck57 = 1.8 time = 580
* CHECK dout0_2 vdout0_2ck57 = 1.8 time = 580
* CHECK dout0_3 vdout0_3ck57 = 1.8 time = 580
* CHECK dout0_4 vdout0_4ck57 = 1.8 time = 580
* CHECK dout0_5 vdout0_5ck57 = 0 time = 580
* CHECK dout0_6 vdout0_6ck57 = 0 time = 580
* CHECK dout0_7 vdout0_7ck57 = 1.8 time = 580
* CHECK dout0_8 vdout0_8ck57 = 1.8 time = 580
* CHECK dout0_9 vdout0_9ck57 = 0 time = 580
* CHECK dout0_10 vdout0_10ck57 = 0 time = 580
* CHECK dout0_11 vdout0_11ck57 = 1.8 time = 580
* CHECK dout0_12 vdout0_12ck57 = 1.8 time = 580
* CHECK dout0_13 vdout0_13ck57 = 1.8 time = 580
* CHECK dout0_14 vdout0_14ck57 = 0 time = 580
* CHECK dout0_15 vdout0_15ck57 = 1.8 time = 580
* CHECK dout0_16 vdout0_16ck57 = 0 time = 580
* CHECK dout0_17 vdout0_17ck57 = 0 time = 580
* CHECK dout0_18 vdout0_18ck57 = 1.8 time = 580
* CHECK dout0_19 vdout0_19ck57 = 0 time = 580
* CHECK dout0_20 vdout0_20ck57 = 0 time = 580
* CHECK dout0_21 vdout0_21ck57 = 0 time = 580
* CHECK dout0_22 vdout0_22ck57 = 1.8 time = 580
* CHECK dout0_23 vdout0_23ck57 = 0 time = 580
* CHECK dout0_24 vdout0_24ck57 = 1.8 time = 580
* CHECK dout0_25 vdout0_25ck57 = 1.8 time = 580
* CHECK dout0_26 vdout0_26ck57 = 0 time = 580
* CHECK dout0_27 vdout0_27ck57 = 1.8 time = 580
* CHECK dout0_28 vdout0_28ck57 = 0 time = 580
* CHECK dout0_29 vdout0_29ck57 = 0 time = 580
* CHECK dout0_30 vdout0_30ck57 = 1.8 time = 580
* CHECK dout0_31 vdout0_31ck57 = 1.8 time = 580
* CHECK dout1_0 vdout1_0ck57 = 0 time = 580
* CHECK dout1_1 vdout1_1ck57 = 1.8 time = 580
* CHECK dout1_2 vdout1_2ck57 = 1.8 time = 580
* CHECK dout1_3 vdout1_3ck57 = 1.8 time = 580
* CHECK dout1_4 vdout1_4ck57 = 1.8 time = 580
* CHECK dout1_5 vdout1_5ck57 = 0 time = 580
* CHECK dout1_6 vdout1_6ck57 = 0 time = 580
* CHECK dout1_7 vdout1_7ck57 = 1.8 time = 580
* CHECK dout1_8 vdout1_8ck57 = 1.8 time = 580
* CHECK dout1_9 vdout1_9ck57 = 0 time = 580
* CHECK dout1_10 vdout1_10ck57 = 0 time = 580
* CHECK dout1_11 vdout1_11ck57 = 1.8 time = 580
* CHECK dout1_12 vdout1_12ck57 = 1.8 time = 580
* CHECK dout1_13 vdout1_13ck57 = 1.8 time = 580
* CHECK dout1_14 vdout1_14ck57 = 0 time = 580
* CHECK dout1_15 vdout1_15ck57 = 1.8 time = 580
* CHECK dout1_16 vdout1_16ck57 = 0 time = 580
* CHECK dout1_17 vdout1_17ck57 = 0 time = 580
* CHECK dout1_18 vdout1_18ck57 = 1.8 time = 580
* CHECK dout1_19 vdout1_19ck57 = 0 time = 580
* CHECK dout1_20 vdout1_20ck57 = 0 time = 580
* CHECK dout1_21 vdout1_21ck57 = 0 time = 580
* CHECK dout1_22 vdout1_22ck57 = 1.8 time = 580
* CHECK dout1_23 vdout1_23ck57 = 0 time = 580
* CHECK dout1_24 vdout1_24ck57 = 1.8 time = 580
* CHECK dout1_25 vdout1_25ck57 = 1.8 time = 580
* CHECK dout1_26 vdout1_26ck57 = 0 time = 580
* CHECK dout1_27 vdout1_27ck57 = 1.8 time = 580
* CHECK dout1_28 vdout1_28ck57 = 0 time = 580
* CHECK dout1_29 vdout1_29ck57 = 0 time = 580
* CHECK dout1_30 vdout1_30ck57 = 1.8 time = 580
* CHECK dout1_31 vdout1_31ck57 = 1.8 time = 580
* CHECK dout0_0 vdout0_0ck58 = 0 time = 590
* CHECK dout0_1 vdout0_1ck58 = 0 time = 590
* CHECK dout0_2 vdout0_2ck58 = 1.8 time = 590
* CHECK dout0_3 vdout0_3ck58 = 1.8 time = 590
* CHECK dout0_4 vdout0_4ck58 = 0 time = 590
* CHECK dout0_5 vdout0_5ck58 = 0 time = 590
* CHECK dout0_6 vdout0_6ck58 = 0 time = 590
* CHECK dout0_7 vdout0_7ck58 = 0 time = 590
* CHECK dout0_8 vdout0_8ck58 = 0 time = 590
* CHECK dout0_9 vdout0_9ck58 = 0 time = 590
* CHECK dout0_10 vdout0_10ck58 = 0 time = 590
* CHECK dout0_11 vdout0_11ck58 = 0 time = 590
* CHECK dout0_12 vdout0_12ck58 = 0 time = 590
* CHECK dout0_13 vdout0_13ck58 = 0 time = 590
* CHECK dout0_14 vdout0_14ck58 = 1.8 time = 590
* CHECK dout0_15 vdout0_15ck58 = 1.8 time = 590
* CHECK dout0_16 vdout0_16ck58 = 1.8 time = 590
* CHECK dout0_17 vdout0_17ck58 = 1.8 time = 590
* CHECK dout0_18 vdout0_18ck58 = 1.8 time = 590
* CHECK dout0_19 vdout0_19ck58 = 1.8 time = 590
* CHECK dout0_20 vdout0_20ck58 = 0 time = 590
* CHECK dout0_21 vdout0_21ck58 = 0 time = 590
* CHECK dout0_22 vdout0_22ck58 = 1.8 time = 590
* CHECK dout0_23 vdout0_23ck58 = 1.8 time = 590
* CHECK dout0_24 vdout0_24ck58 = 1.8 time = 590
* CHECK dout0_25 vdout0_25ck58 = 0 time = 590
* CHECK dout0_26 vdout0_26ck58 = 0 time = 590
* CHECK dout0_27 vdout0_27ck58 = 1.8 time = 590
* CHECK dout0_28 vdout0_28ck58 = 1.8 time = 590
* CHECK dout0_29 vdout0_29ck58 = 1.8 time = 590
* CHECK dout0_30 vdout0_30ck58 = 1.8 time = 590
* CHECK dout0_31 vdout0_31ck58 = 1.8 time = 590
* CHECK dout0_0 vdout0_0ck59 = 0 time = 600
* CHECK dout0_1 vdout0_1ck59 = 1.8 time = 600
* CHECK dout0_2 vdout0_2ck59 = 1.8 time = 600
* CHECK dout0_3 vdout0_3ck59 = 1.8 time = 600
* CHECK dout0_4 vdout0_4ck59 = 1.8 time = 600
* CHECK dout0_5 vdout0_5ck59 = 0 time = 600
* CHECK dout0_6 vdout0_6ck59 = 0 time = 600
* CHECK dout0_7 vdout0_7ck59 = 1.8 time = 600
* CHECK dout0_8 vdout0_8ck59 = 1.8 time = 600
* CHECK dout0_9 vdout0_9ck59 = 0 time = 600
* CHECK dout0_10 vdout0_10ck59 = 0 time = 600
* CHECK dout0_11 vdout0_11ck59 = 1.8 time = 600
* CHECK dout0_12 vdout0_12ck59 = 1.8 time = 600
* CHECK dout0_13 vdout0_13ck59 = 1.8 time = 600
* CHECK dout0_14 vdout0_14ck59 = 0 time = 600
* CHECK dout0_15 vdout0_15ck59 = 1.8 time = 600
* CHECK dout0_16 vdout0_16ck59 = 0 time = 600
* CHECK dout0_17 vdout0_17ck59 = 0 time = 600
* CHECK dout0_18 vdout0_18ck59 = 1.8 time = 600
* CHECK dout0_19 vdout0_19ck59 = 0 time = 600
* CHECK dout0_20 vdout0_20ck59 = 0 time = 600
* CHECK dout0_21 vdout0_21ck59 = 0 time = 600
* CHECK dout0_22 vdout0_22ck59 = 1.8 time = 600
* CHECK dout0_23 vdout0_23ck59 = 0 time = 600
* CHECK dout0_24 vdout0_24ck59 = 1.8 time = 600
* CHECK dout0_25 vdout0_25ck59 = 1.8 time = 600
* CHECK dout0_26 vdout0_26ck59 = 0 time = 600
* CHECK dout0_27 vdout0_27ck59 = 1.8 time = 600
* CHECK dout0_28 vdout0_28ck59 = 0 time = 600
* CHECK dout0_29 vdout0_29ck59 = 0 time = 600
* CHECK dout0_30 vdout0_30ck59 = 1.8 time = 600
* CHECK dout0_31 vdout0_31ck59 = 1.8 time = 600
* CHECK dout1_0 vdout1_0ck60 = 0 time = 610
* CHECK dout1_1 vdout1_1ck60 = 1.8 time = 610
* CHECK dout1_2 vdout1_2ck60 = 1.8 time = 610
* CHECK dout1_3 vdout1_3ck60 = 1.8 time = 610
* CHECK dout1_4 vdout1_4ck60 = 1.8 time = 610
* CHECK dout1_5 vdout1_5ck60 = 0 time = 610
* CHECK dout1_6 vdout1_6ck60 = 0 time = 610
* CHECK dout1_7 vdout1_7ck60 = 1.8 time = 610
* CHECK dout1_8 vdout1_8ck60 = 1.8 time = 610
* CHECK dout1_9 vdout1_9ck60 = 0 time = 610
* CHECK dout1_10 vdout1_10ck60 = 0 time = 610
* CHECK dout1_11 vdout1_11ck60 = 1.8 time = 610
* CHECK dout1_12 vdout1_12ck60 = 1.8 time = 610
* CHECK dout1_13 vdout1_13ck60 = 1.8 time = 610
* CHECK dout1_14 vdout1_14ck60 = 0 time = 610
* CHECK dout1_15 vdout1_15ck60 = 1.8 time = 610
* CHECK dout1_16 vdout1_16ck60 = 0 time = 610
* CHECK dout1_17 vdout1_17ck60 = 0 time = 610
* CHECK dout1_18 vdout1_18ck60 = 1.8 time = 610
* CHECK dout1_19 vdout1_19ck60 = 0 time = 610
* CHECK dout1_20 vdout1_20ck60 = 0 time = 610
* CHECK dout1_21 vdout1_21ck60 = 0 time = 610
* CHECK dout1_22 vdout1_22ck60 = 1.8 time = 610
* CHECK dout1_23 vdout1_23ck60 = 0 time = 610
* CHECK dout1_24 vdout1_24ck60 = 1.8 time = 610
* CHECK dout1_25 vdout1_25ck60 = 1.8 time = 610
* CHECK dout1_26 vdout1_26ck60 = 0 time = 610
* CHECK dout1_27 vdout1_27ck60 = 1.8 time = 610
* CHECK dout1_28 vdout1_28ck60 = 0 time = 610
* CHECK dout1_29 vdout1_29ck60 = 0 time = 610
* CHECK dout1_30 vdout1_30ck60 = 1.8 time = 610
* CHECK dout1_31 vdout1_31ck60 = 1.8 time = 610
* CHECK dout0_0 vdout0_0ck61 = 1.8 time = 620
* CHECK dout0_1 vdout0_1ck61 = 1.8 time = 620
* CHECK dout0_2 vdout0_2ck61 = 0 time = 620
* CHECK dout0_3 vdout0_3ck61 = 0 time = 620
* CHECK dout0_4 vdout0_4ck61 = 1.8 time = 620
* CHECK dout0_5 vdout0_5ck61 = 1.8 time = 620
* CHECK dout0_6 vdout0_6ck61 = 0 time = 620
* CHECK dout0_7 vdout0_7ck61 = 0 time = 620
* CHECK dout0_8 vdout0_8ck61 = 1.8 time = 620
* CHECK dout0_9 vdout0_9ck61 = 0 time = 620
* CHECK dout0_10 vdout0_10ck61 = 0 time = 620
* CHECK dout0_11 vdout0_11ck61 = 1.8 time = 620
* CHECK dout0_12 vdout0_12ck61 = 1.8 time = 620
* CHECK dout0_13 vdout0_13ck61 = 1.8 time = 620
* CHECK dout0_14 vdout0_14ck61 = 0 time = 620
* CHECK dout0_15 vdout0_15ck61 = 0 time = 620
* CHECK dout0_16 vdout0_16ck61 = 0 time = 620
* CHECK dout0_17 vdout0_17ck61 = 0 time = 620
* CHECK dout0_18 vdout0_18ck61 = 0 time = 620
* CHECK dout0_19 vdout0_19ck61 = 0 time = 620
* CHECK dout0_20 vdout0_20ck61 = 0 time = 620
* CHECK dout0_21 vdout0_21ck61 = 1.8 time = 620
* CHECK dout0_22 vdout0_22ck61 = 1.8 time = 620
* CHECK dout0_23 vdout0_23ck61 = 1.8 time = 620
* CHECK dout0_24 vdout0_24ck61 = 0 time = 620
* CHECK dout0_25 vdout0_25ck61 = 0 time = 620
* CHECK dout0_26 vdout0_26ck61 = 0 time = 620
* CHECK dout0_27 vdout0_27ck61 = 1.8 time = 620
* CHECK dout0_28 vdout0_28ck61 = 0 time = 620
* CHECK dout0_29 vdout0_29ck61 = 1.8 time = 620
* CHECK dout0_30 vdout0_30ck61 = 1.8 time = 620
* CHECK dout0_31 vdout0_31ck61 = 1.8 time = 620
* CHECK dout0_0 vdout0_0ck63 = 1.8 time = 640
* CHECK dout0_1 vdout0_1ck63 = 0 time = 640
* CHECK dout0_2 vdout0_2ck63 = 1.8 time = 640
* CHECK dout0_3 vdout0_3ck63 = 0 time = 640
* CHECK dout0_4 vdout0_4ck63 = 0 time = 640
* CHECK dout0_5 vdout0_5ck63 = 0 time = 640
* CHECK dout0_6 vdout0_6ck63 = 0 time = 640
* CHECK dout0_7 vdout0_7ck63 = 1.8 time = 640
* CHECK dout0_8 vdout0_8ck63 = 0 time = 640
* CHECK dout0_9 vdout0_9ck63 = 1.8 time = 640
* CHECK dout0_10 vdout0_10ck63 = 0 time = 640
* CHECK dout0_11 vdout0_11ck63 = 0 time = 640
* CHECK dout0_12 vdout0_12ck63 = 1.8 time = 640
* CHECK dout0_13 vdout0_13ck63 = 0 time = 640
* CHECK dout0_14 vdout0_14ck63 = 1.8 time = 640
* CHECK dout0_15 vdout0_15ck63 = 0 time = 640
* CHECK dout0_16 vdout0_16ck63 = 1.8 time = 640
* CHECK dout0_17 vdout0_17ck63 = 1.8 time = 640
* CHECK dout0_18 vdout0_18ck63 = 0 time = 640
* CHECK dout0_19 vdout0_19ck63 = 1.8 time = 640
* CHECK dout0_20 vdout0_20ck63 = 1.8 time = 640
* CHECK dout0_21 vdout0_21ck63 = 1.8 time = 640
* CHECK dout0_22 vdout0_22ck63 = 0 time = 640
* CHECK dout0_23 vdout0_23ck63 = 1.8 time = 640
* CHECK dout0_24 vdout0_24ck63 = 1.8 time = 640
* CHECK dout0_25 vdout0_25ck63 = 1.8 time = 640
* CHECK dout0_26 vdout0_26ck63 = 0 time = 640
* CHECK dout0_27 vdout0_27ck63 = 0 time = 640
* CHECK dout0_28 vdout0_28ck63 = 1.8 time = 640
* CHECK dout0_29 vdout0_29ck63 = 0 time = 640
* CHECK dout0_30 vdout0_30ck63 = 1.8 time = 640
* CHECK dout0_31 vdout0_31ck63 = 0 time = 640
* CHECK dout1_0 vdout1_0ck64 = 1.8 time = 650
* CHECK dout1_1 vdout1_1ck64 = 0 time = 650
* CHECK dout1_2 vdout1_2ck64 = 1.8 time = 650
* CHECK dout1_3 vdout1_3ck64 = 0 time = 650
* CHECK dout1_4 vdout1_4ck64 = 0 time = 650
* CHECK dout1_5 vdout1_5ck64 = 0 time = 650
* CHECK dout1_6 vdout1_6ck64 = 0 time = 650
* CHECK dout1_7 vdout1_7ck64 = 1.8 time = 650
* CHECK dout1_8 vdout1_8ck64 = 0 time = 650
* CHECK dout1_9 vdout1_9ck64 = 1.8 time = 650
* CHECK dout1_10 vdout1_10ck64 = 0 time = 650
* CHECK dout1_11 vdout1_11ck64 = 0 time = 650
* CHECK dout1_12 vdout1_12ck64 = 1.8 time = 650
* CHECK dout1_13 vdout1_13ck64 = 0 time = 650
* CHECK dout1_14 vdout1_14ck64 = 1.8 time = 650
* CHECK dout1_15 vdout1_15ck64 = 0 time = 650
* CHECK dout1_16 vdout1_16ck64 = 1.8 time = 650
* CHECK dout1_17 vdout1_17ck64 = 1.8 time = 650
* CHECK dout1_18 vdout1_18ck64 = 0 time = 650
* CHECK dout1_19 vdout1_19ck64 = 1.8 time = 650
* CHECK dout1_20 vdout1_20ck64 = 1.8 time = 650
* CHECK dout1_21 vdout1_21ck64 = 1.8 time = 650
* CHECK dout1_22 vdout1_22ck64 = 0 time = 650
* CHECK dout1_23 vdout1_23ck64 = 1.8 time = 650
* CHECK dout1_24 vdout1_24ck64 = 1.8 time = 650
* CHECK dout1_25 vdout1_25ck64 = 1.8 time = 650
* CHECK dout1_26 vdout1_26ck64 = 0 time = 650
* CHECK dout1_27 vdout1_27ck64 = 0 time = 650
* CHECK dout1_28 vdout1_28ck64 = 1.8 time = 650
* CHECK dout1_29 vdout1_29ck64 = 0 time = 650
* CHECK dout1_30 vdout1_30ck64 = 1.8 time = 650
* CHECK dout1_31 vdout1_31ck64 = 0 time = 650
* CHECK dout1_0 vdout1_0ck65 = 1.8 time = 660
* CHECK dout1_1 vdout1_1ck65 = 1.8 time = 660
* CHECK dout1_2 vdout1_2ck65 = 0 time = 660
* CHECK dout1_3 vdout1_3ck65 = 0 time = 660
* CHECK dout1_4 vdout1_4ck65 = 1.8 time = 660
* CHECK dout1_5 vdout1_5ck65 = 1.8 time = 660
* CHECK dout1_6 vdout1_6ck65 = 0 time = 660
* CHECK dout1_7 vdout1_7ck65 = 0 time = 660
* CHECK dout1_8 vdout1_8ck65 = 1.8 time = 660
* CHECK dout1_9 vdout1_9ck65 = 0 time = 660
* CHECK dout1_10 vdout1_10ck65 = 0 time = 660
* CHECK dout1_11 vdout1_11ck65 = 1.8 time = 660
* CHECK dout1_12 vdout1_12ck65 = 1.8 time = 660
* CHECK dout1_13 vdout1_13ck65 = 1.8 time = 660
* CHECK dout1_14 vdout1_14ck65 = 0 time = 660
* CHECK dout1_15 vdout1_15ck65 = 0 time = 660
* CHECK dout1_16 vdout1_16ck65 = 0 time = 660
* CHECK dout1_17 vdout1_17ck65 = 0 time = 660
* CHECK dout1_18 vdout1_18ck65 = 0 time = 660
* CHECK dout1_19 vdout1_19ck65 = 0 time = 660
* CHECK dout1_20 vdout1_20ck65 = 0 time = 660
* CHECK dout1_21 vdout1_21ck65 = 1.8 time = 660
* CHECK dout1_22 vdout1_22ck65 = 1.8 time = 660
* CHECK dout1_23 vdout1_23ck65 = 1.8 time = 660
* CHECK dout1_24 vdout1_24ck65 = 0 time = 660
* CHECK dout1_25 vdout1_25ck65 = 0 time = 660
* CHECK dout1_26 vdout1_26ck65 = 0 time = 660
* CHECK dout1_27 vdout1_27ck65 = 1.8 time = 660
* CHECK dout1_28 vdout1_28ck65 = 0 time = 660
* CHECK dout1_29 vdout1_29ck65 = 1.8 time = 660
* CHECK dout1_30 vdout1_30ck65 = 1.8 time = 660
* CHECK dout1_31 vdout1_31ck65 = 1.8 time = 660
* CHECK dout1_0 vdout1_0ck66 = 1.8 time = 670
* CHECK dout1_1 vdout1_1ck66 = 1.8 time = 670
* CHECK dout1_2 vdout1_2ck66 = 0 time = 670
* CHECK dout1_3 vdout1_3ck66 = 0 time = 670
* CHECK dout1_4 vdout1_4ck66 = 1.8 time = 670
* CHECK dout1_5 vdout1_5ck66 = 1.8 time = 670
* CHECK dout1_6 vdout1_6ck66 = 0 time = 670
* CHECK dout1_7 vdout1_7ck66 = 0 time = 670
* CHECK dout1_8 vdout1_8ck66 = 1.8 time = 670
* CHECK dout1_9 vdout1_9ck66 = 0 time = 670
* CHECK dout1_10 vdout1_10ck66 = 0 time = 670
* CHECK dout1_11 vdout1_11ck66 = 1.8 time = 670
* CHECK dout1_12 vdout1_12ck66 = 1.8 time = 670
* CHECK dout1_13 vdout1_13ck66 = 1.8 time = 670
* CHECK dout1_14 vdout1_14ck66 = 0 time = 670
* CHECK dout1_15 vdout1_15ck66 = 0 time = 670
* CHECK dout1_16 vdout1_16ck66 = 0 time = 670
* CHECK dout1_17 vdout1_17ck66 = 0 time = 670
* CHECK dout1_18 vdout1_18ck66 = 0 time = 670
* CHECK dout1_19 vdout1_19ck66 = 0 time = 670
* CHECK dout1_20 vdout1_20ck66 = 0 time = 670
* CHECK dout1_21 vdout1_21ck66 = 1.8 time = 670
* CHECK dout1_22 vdout1_22ck66 = 1.8 time = 670
* CHECK dout1_23 vdout1_23ck66 = 1.8 time = 670
* CHECK dout1_24 vdout1_24ck66 = 0 time = 670
* CHECK dout1_25 vdout1_25ck66 = 0 time = 670
* CHECK dout1_26 vdout1_26ck66 = 0 time = 670
* CHECK dout1_27 vdout1_27ck66 = 1.8 time = 670
* CHECK dout1_28 vdout1_28ck66 = 0 time = 670
* CHECK dout1_29 vdout1_29ck66 = 1.8 time = 670
* CHECK dout1_30 vdout1_30ck66 = 1.8 time = 670
* CHECK dout1_31 vdout1_31ck66 = 1.8 time = 670
* CHECK dout1_0 vdout1_0ck67 = 1.8 time = 680
* CHECK dout1_1 vdout1_1ck67 = 1.8 time = 680
* CHECK dout1_2 vdout1_2ck67 = 0 time = 680
* CHECK dout1_3 vdout1_3ck67 = 0 time = 680
* CHECK dout1_4 vdout1_4ck67 = 1.8 time = 680
* CHECK dout1_5 vdout1_5ck67 = 1.8 time = 680
* CHECK dout1_6 vdout1_6ck67 = 0 time = 680
* CHECK dout1_7 vdout1_7ck67 = 0 time = 680
* CHECK dout1_8 vdout1_8ck67 = 1.8 time = 680
* CHECK dout1_9 vdout1_9ck67 = 0 time = 680
* CHECK dout1_10 vdout1_10ck67 = 0 time = 680
* CHECK dout1_11 vdout1_11ck67 = 1.8 time = 680
* CHECK dout1_12 vdout1_12ck67 = 1.8 time = 680
* CHECK dout1_13 vdout1_13ck67 = 1.8 time = 680
* CHECK dout1_14 vdout1_14ck67 = 0 time = 680
* CHECK dout1_15 vdout1_15ck67 = 0 time = 680
* CHECK dout1_16 vdout1_16ck67 = 0 time = 680
* CHECK dout1_17 vdout1_17ck67 = 0 time = 680
* CHECK dout1_18 vdout1_18ck67 = 0 time = 680
* CHECK dout1_19 vdout1_19ck67 = 0 time = 680
* CHECK dout1_20 vdout1_20ck67 = 0 time = 680
* CHECK dout1_21 vdout1_21ck67 = 1.8 time = 680
* CHECK dout1_22 vdout1_22ck67 = 1.8 time = 680
* CHECK dout1_23 vdout1_23ck67 = 1.8 time = 680
* CHECK dout1_24 vdout1_24ck67 = 0 time = 680
* CHECK dout1_25 vdout1_25ck67 = 0 time = 680
* CHECK dout1_26 vdout1_26ck67 = 0 time = 680
* CHECK dout1_27 vdout1_27ck67 = 1.8 time = 680
* CHECK dout1_28 vdout1_28ck67 = 0 time = 680
* CHECK dout1_29 vdout1_29ck67 = 1.8 time = 680
* CHECK dout1_30 vdout1_30ck67 = 1.8 time = 680
* CHECK dout1_31 vdout1_31ck67 = 1.8 time = 680
* CHECK dout0_0 vdout0_0ck69 = 0 time = 700
* CHECK dout0_1 vdout0_1ck69 = 0 time = 700
* CHECK dout0_2 vdout0_2ck69 = 0 time = 700
* CHECK dout0_3 vdout0_3ck69 = 0 time = 700
* CHECK dout0_4 vdout0_4ck69 = 0 time = 700
* CHECK dout0_5 vdout0_5ck69 = 1.8 time = 700
* CHECK dout0_6 vdout0_6ck69 = 0 time = 700
* CHECK dout0_7 vdout0_7ck69 = 0 time = 700
* CHECK dout0_8 vdout0_8ck69 = 0 time = 700
* CHECK dout0_9 vdout0_9ck69 = 1.8 time = 700
* CHECK dout0_10 vdout0_10ck69 = 0 time = 700
* CHECK dout0_11 vdout0_11ck69 = 0 time = 700
* CHECK dout0_12 vdout0_12ck69 = 0 time = 700
* CHECK dout0_13 vdout0_13ck69 = 1.8 time = 700
* CHECK dout0_14 vdout0_14ck69 = 0 time = 700
* CHECK dout0_15 vdout0_15ck69 = 0 time = 700
* CHECK dout0_16 vdout0_16ck69 = 1.8 time = 700
* CHECK dout0_17 vdout0_17ck69 = 1.8 time = 700
* CHECK dout0_18 vdout0_18ck69 = 1.8 time = 700
* CHECK dout0_19 vdout0_19ck69 = 1.8 time = 700
* CHECK dout0_20 vdout0_20ck69 = 0 time = 700
* CHECK dout0_21 vdout0_21ck69 = 0 time = 700
* CHECK dout0_22 vdout0_22ck69 = 1.8 time = 700
* CHECK dout0_23 vdout0_23ck69 = 1.8 time = 700
* CHECK dout0_24 vdout0_24ck69 = 1.8 time = 700
* CHECK dout0_25 vdout0_25ck69 = 1.8 time = 700
* CHECK dout0_26 vdout0_26ck69 = 0 time = 700
* CHECK dout0_27 vdout0_27ck69 = 0 time = 700
* CHECK dout0_28 vdout0_28ck69 = 0 time = 700
* CHECK dout0_29 vdout0_29ck69 = 1.8 time = 700
* CHECK dout0_30 vdout0_30ck69 = 1.8 time = 700
* CHECK dout0_31 vdout0_31ck69 = 1.8 time = 700
* CHECK dout1_0 vdout1_0ck69 = 0 time = 700
* CHECK dout1_1 vdout1_1ck69 = 0 time = 700
* CHECK dout1_2 vdout1_2ck69 = 0 time = 700
* CHECK dout1_3 vdout1_3ck69 = 0 time = 700
* CHECK dout1_4 vdout1_4ck69 = 0 time = 700
* CHECK dout1_5 vdout1_5ck69 = 1.8 time = 700
* CHECK dout1_6 vdout1_6ck69 = 0 time = 700
* CHECK dout1_7 vdout1_7ck69 = 0 time = 700
* CHECK dout1_8 vdout1_8ck69 = 0 time = 700
* CHECK dout1_9 vdout1_9ck69 = 1.8 time = 700
* CHECK dout1_10 vdout1_10ck69 = 0 time = 700
* CHECK dout1_11 vdout1_11ck69 = 0 time = 700
* CHECK dout1_12 vdout1_12ck69 = 0 time = 700
* CHECK dout1_13 vdout1_13ck69 = 1.8 time = 700
* CHECK dout1_14 vdout1_14ck69 = 0 time = 700
* CHECK dout1_15 vdout1_15ck69 = 0 time = 700
* CHECK dout1_16 vdout1_16ck69 = 1.8 time = 700
* CHECK dout1_17 vdout1_17ck69 = 1.8 time = 700
* CHECK dout1_18 vdout1_18ck69 = 1.8 time = 700
* CHECK dout1_19 vdout1_19ck69 = 1.8 time = 700
* CHECK dout1_20 vdout1_20ck69 = 0 time = 700
* CHECK dout1_21 vdout1_21ck69 = 0 time = 700
* CHECK dout1_22 vdout1_22ck69 = 1.8 time = 700
* CHECK dout1_23 vdout1_23ck69 = 1.8 time = 700
* CHECK dout1_24 vdout1_24ck69 = 1.8 time = 700
* CHECK dout1_25 vdout1_25ck69 = 1.8 time = 700
* CHECK dout1_26 vdout1_26ck69 = 0 time = 700
* CHECK dout1_27 vdout1_27ck69 = 0 time = 700
* CHECK dout1_28 vdout1_28ck69 = 0 time = 700
* CHECK dout1_29 vdout1_29ck69 = 1.8 time = 700
* CHECK dout1_30 vdout1_30ck69 = 1.8 time = 700
* CHECK dout1_31 vdout1_31ck69 = 1.8 time = 700
* CHECK dout0_0 vdout0_0ck70 = 0 time = 710
* CHECK dout0_1 vdout0_1ck70 = 0 time = 710
* CHECK dout0_2 vdout0_2ck70 = 1.8 time = 710
* CHECK dout0_3 vdout0_3ck70 = 1.8 time = 710
* CHECK dout0_4 vdout0_4ck70 = 0 time = 710
* CHECK dout0_5 vdout0_5ck70 = 0 time = 710
* CHECK dout0_6 vdout0_6ck70 = 0 time = 710
* CHECK dout0_7 vdout0_7ck70 = 0 time = 710
* CHECK dout0_8 vdout0_8ck70 = 1.8 time = 710
* CHECK dout0_9 vdout0_9ck70 = 0 time = 710
* CHECK dout0_10 vdout0_10ck70 = 1.8 time = 710
* CHECK dout0_11 vdout0_11ck70 = 1.8 time = 710
* CHECK dout0_12 vdout0_12ck70 = 1.8 time = 710
* CHECK dout0_13 vdout0_13ck70 = 0 time = 710
* CHECK dout0_14 vdout0_14ck70 = 1.8 time = 710
* CHECK dout0_15 vdout0_15ck70 = 1.8 time = 710
* CHECK dout0_16 vdout0_16ck70 = 0 time = 710
* CHECK dout0_17 vdout0_17ck70 = 1.8 time = 710
* CHECK dout0_18 vdout0_18ck70 = 0 time = 710
* CHECK dout0_19 vdout0_19ck70 = 1.8 time = 710
* CHECK dout0_20 vdout0_20ck70 = 1.8 time = 710
* CHECK dout0_21 vdout0_21ck70 = 0 time = 710
* CHECK dout0_22 vdout0_22ck70 = 0 time = 710
* CHECK dout0_23 vdout0_23ck70 = 0 time = 710
* CHECK dout0_24 vdout0_24ck70 = 0 time = 710
* CHECK dout0_25 vdout0_25ck70 = 0 time = 710
* CHECK dout0_26 vdout0_26ck70 = 0 time = 710
* CHECK dout0_27 vdout0_27ck70 = 1.8 time = 710
* CHECK dout0_28 vdout0_28ck70 = 1.8 time = 710
* CHECK dout0_29 vdout0_29ck70 = 1.8 time = 710
* CHECK dout0_30 vdout0_30ck70 = 0 time = 710
* CHECK dout0_31 vdout0_31ck70 = 1.8 time = 710
* CHECK dout0_0 vdout0_0ck71 = 0 time = 720
* CHECK dout0_1 vdout0_1ck71 = 1.8 time = 720
* CHECK dout0_2 vdout0_2ck71 = 0 time = 720
* CHECK dout0_3 vdout0_3ck71 = 1.8 time = 720
* CHECK dout0_4 vdout0_4ck71 = 0 time = 720
* CHECK dout0_5 vdout0_5ck71 = 1.8 time = 720
* CHECK dout0_6 vdout0_6ck71 = 0 time = 720
* CHECK dout0_7 vdout0_7ck71 = 1.8 time = 720
* CHECK dout0_8 vdout0_8ck71 = 0 time = 720
* CHECK dout0_9 vdout0_9ck71 = 1.8 time = 720
* CHECK dout0_10 vdout0_10ck71 = 0 time = 720
* CHECK dout0_11 vdout0_11ck71 = 1.8 time = 720
* CHECK dout0_12 vdout0_12ck71 = 0 time = 720
* CHECK dout0_13 vdout0_13ck71 = 1.8 time = 720
* CHECK dout0_14 vdout0_14ck71 = 0 time = 720
* CHECK dout0_15 vdout0_15ck71 = 0 time = 720
* CHECK dout0_16 vdout0_16ck71 = 1.8 time = 720
* CHECK dout0_17 vdout0_17ck71 = 1.8 time = 720
* CHECK dout0_18 vdout0_18ck71 = 0 time = 720
* CHECK dout0_19 vdout0_19ck71 = 0 time = 720
* CHECK dout0_20 vdout0_20ck71 = 1.8 time = 720
* CHECK dout0_21 vdout0_21ck71 = 1.8 time = 720
* CHECK dout0_22 vdout0_22ck71 = 0 time = 720
* CHECK dout0_23 vdout0_23ck71 = 0 time = 720
* CHECK dout0_24 vdout0_24ck71 = 0 time = 720
* CHECK dout0_25 vdout0_25ck71 = 0 time = 720
* CHECK dout0_26 vdout0_26ck71 = 1.8 time = 720
* CHECK dout0_27 vdout0_27ck71 = 1.8 time = 720
* CHECK dout0_28 vdout0_28ck71 = 1.8 time = 720
* CHECK dout0_29 vdout0_29ck71 = 0 time = 720
* CHECK dout0_30 vdout0_30ck71 = 0 time = 720
* CHECK dout0_31 vdout0_31ck71 = 0 time = 720
* CHECK dout1_0 vdout1_0ck71 = 0 time = 720
* CHECK dout1_1 vdout1_1ck71 = 0 time = 720
* CHECK dout1_2 vdout1_2ck71 = 0 time = 720
* CHECK dout1_3 vdout1_3ck71 = 0 time = 720
* CHECK dout1_4 vdout1_4ck71 = 0 time = 720
* CHECK dout1_5 vdout1_5ck71 = 1.8 time = 720
* CHECK dout1_6 vdout1_6ck71 = 0 time = 720
* CHECK dout1_7 vdout1_7ck71 = 0 time = 720
* CHECK dout1_8 vdout1_8ck71 = 0 time = 720
* CHECK dout1_9 vdout1_9ck71 = 1.8 time = 720
* CHECK dout1_10 vdout1_10ck71 = 0 time = 720
* CHECK dout1_11 vdout1_11ck71 = 0 time = 720
* CHECK dout1_12 vdout1_12ck71 = 0 time = 720
* CHECK dout1_13 vdout1_13ck71 = 1.8 time = 720
* CHECK dout1_14 vdout1_14ck71 = 0 time = 720
* CHECK dout1_15 vdout1_15ck71 = 0 time = 720
* CHECK dout1_16 vdout1_16ck71 = 1.8 time = 720
* CHECK dout1_17 vdout1_17ck71 = 1.8 time = 720
* CHECK dout1_18 vdout1_18ck71 = 1.8 time = 720
* CHECK dout1_19 vdout1_19ck71 = 1.8 time = 720
* CHECK dout1_20 vdout1_20ck71 = 0 time = 720
* CHECK dout1_21 vdout1_21ck71 = 0 time = 720
* CHECK dout1_22 vdout1_22ck71 = 1.8 time = 720
* CHECK dout1_23 vdout1_23ck71 = 1.8 time = 720
* CHECK dout1_24 vdout1_24ck71 = 1.8 time = 720
* CHECK dout1_25 vdout1_25ck71 = 1.8 time = 720
* CHECK dout1_26 vdout1_26ck71 = 0 time = 720
* CHECK dout1_27 vdout1_27ck71 = 0 time = 720
* CHECK dout1_28 vdout1_28ck71 = 0 time = 720
* CHECK dout1_29 vdout1_29ck71 = 1.8 time = 720
* CHECK dout1_30 vdout1_30ck71 = 1.8 time = 720
* CHECK dout1_31 vdout1_31ck71 = 1.8 time = 720
* CHECK dout0_0 vdout0_0ck72 = 1.8 time = 730
* CHECK dout0_1 vdout0_1ck72 = 1.8 time = 730
* CHECK dout0_2 vdout0_2ck72 = 0 time = 730
* CHECK dout0_3 vdout0_3ck72 = 0 time = 730
* CHECK dout0_4 vdout0_4ck72 = 1.8 time = 730
* CHECK dout0_5 vdout0_5ck72 = 1.8 time = 730
* CHECK dout0_6 vdout0_6ck72 = 0 time = 730
* CHECK dout0_7 vdout0_7ck72 = 0 time = 730
* CHECK dout0_8 vdout0_8ck72 = 1.8 time = 730
* CHECK dout0_9 vdout0_9ck72 = 0 time = 730
* CHECK dout0_10 vdout0_10ck72 = 0 time = 730
* CHECK dout0_11 vdout0_11ck72 = 1.8 time = 730
* CHECK dout0_12 vdout0_12ck72 = 1.8 time = 730
* CHECK dout0_13 vdout0_13ck72 = 1.8 time = 730
* CHECK dout0_14 vdout0_14ck72 = 0 time = 730
* CHECK dout0_15 vdout0_15ck72 = 0 time = 730
* CHECK dout0_16 vdout0_16ck72 = 0 time = 730
* CHECK dout0_17 vdout0_17ck72 = 0 time = 730
* CHECK dout0_18 vdout0_18ck72 = 0 time = 730
* CHECK dout0_19 vdout0_19ck72 = 0 time = 730
* CHECK dout0_20 vdout0_20ck72 = 0 time = 730
* CHECK dout0_21 vdout0_21ck72 = 1.8 time = 730
* CHECK dout0_22 vdout0_22ck72 = 1.8 time = 730
* CHECK dout0_23 vdout0_23ck72 = 1.8 time = 730
* CHECK dout0_24 vdout0_24ck72 = 0 time = 730
* CHECK dout0_25 vdout0_25ck72 = 0 time = 730
* CHECK dout0_26 vdout0_26ck72 = 0 time = 730
* CHECK dout0_27 vdout0_27ck72 = 1.8 time = 730
* CHECK dout0_28 vdout0_28ck72 = 0 time = 730
* CHECK dout0_29 vdout0_29ck72 = 1.8 time = 730
* CHECK dout0_30 vdout0_30ck72 = 1.8 time = 730
* CHECK dout0_31 vdout0_31ck72 = 1.8 time = 730
* CHECK dout0_0 vdout0_0ck73 = 1.8 time = 740
* CHECK dout0_1 vdout0_1ck73 = 1.8 time = 740
* CHECK dout0_2 vdout0_2ck73 = 0 time = 740
* CHECK dout0_3 vdout0_3ck73 = 0 time = 740
* CHECK dout0_4 vdout0_4ck73 = 1.8 time = 740
* CHECK dout0_5 vdout0_5ck73 = 1.8 time = 740
* CHECK dout0_6 vdout0_6ck73 = 0 time = 740
* CHECK dout0_7 vdout0_7ck73 = 0 time = 740
* CHECK dout0_8 vdout0_8ck73 = 1.8 time = 740
* CHECK dout0_9 vdout0_9ck73 = 0 time = 740
* CHECK dout0_10 vdout0_10ck73 = 0 time = 740
* CHECK dout0_11 vdout0_11ck73 = 1.8 time = 740
* CHECK dout0_12 vdout0_12ck73 = 1.8 time = 740
* CHECK dout0_13 vdout0_13ck73 = 1.8 time = 740
* CHECK dout0_14 vdout0_14ck73 = 0 time = 740
* CHECK dout0_15 vdout0_15ck73 = 0 time = 740
* CHECK dout0_16 vdout0_16ck73 = 0 time = 740
* CHECK dout0_17 vdout0_17ck73 = 0 time = 740
* CHECK dout0_18 vdout0_18ck73 = 0 time = 740
* CHECK dout0_19 vdout0_19ck73 = 0 time = 740
* CHECK dout0_20 vdout0_20ck73 = 0 time = 740
* CHECK dout0_21 vdout0_21ck73 = 1.8 time = 740
* CHECK dout0_22 vdout0_22ck73 = 1.8 time = 740
* CHECK dout0_23 vdout0_23ck73 = 1.8 time = 740
* CHECK dout0_24 vdout0_24ck73 = 0 time = 740
* CHECK dout0_25 vdout0_25ck73 = 0 time = 740
* CHECK dout0_26 vdout0_26ck73 = 0 time = 740
* CHECK dout0_27 vdout0_27ck73 = 1.8 time = 740
* CHECK dout0_28 vdout0_28ck73 = 0 time = 740
* CHECK dout0_29 vdout0_29ck73 = 1.8 time = 740
* CHECK dout0_30 vdout0_30ck73 = 1.8 time = 740
* CHECK dout0_31 vdout0_31ck73 = 1.8 time = 740
* CHECK dout1_0 vdout1_0ck73 = 0 time = 740
* CHECK dout1_1 vdout1_1ck73 = 0 time = 740
* CHECK dout1_2 vdout1_2ck73 = 1.8 time = 740
* CHECK dout1_3 vdout1_3ck73 = 1.8 time = 740
* CHECK dout1_4 vdout1_4ck73 = 0 time = 740
* CHECK dout1_5 vdout1_5ck73 = 0 time = 740
* CHECK dout1_6 vdout1_6ck73 = 0 time = 740
* CHECK dout1_7 vdout1_7ck73 = 0 time = 740
* CHECK dout1_8 vdout1_8ck73 = 1.8 time = 740
* CHECK dout1_9 vdout1_9ck73 = 0 time = 740
* CHECK dout1_10 vdout1_10ck73 = 1.8 time = 740
* CHECK dout1_11 vdout1_11ck73 = 1.8 time = 740
* CHECK dout1_12 vdout1_12ck73 = 1.8 time = 740
* CHECK dout1_13 vdout1_13ck73 = 0 time = 740
* CHECK dout1_14 vdout1_14ck73 = 1.8 time = 740
* CHECK dout1_15 vdout1_15ck73 = 1.8 time = 740
* CHECK dout1_16 vdout1_16ck73 = 0 time = 740
* CHECK dout1_17 vdout1_17ck73 = 1.8 time = 740
* CHECK dout1_18 vdout1_18ck73 = 0 time = 740
* CHECK dout1_19 vdout1_19ck73 = 1.8 time = 740
* CHECK dout1_20 vdout1_20ck73 = 1.8 time = 740
* CHECK dout1_21 vdout1_21ck73 = 0 time = 740
* CHECK dout1_22 vdout1_22ck73 = 0 time = 740
* CHECK dout1_23 vdout1_23ck73 = 0 time = 740
* CHECK dout1_24 vdout1_24ck73 = 0 time = 740
* CHECK dout1_25 vdout1_25ck73 = 0 time = 740
* CHECK dout1_26 vdout1_26ck73 = 0 time = 740
* CHECK dout1_27 vdout1_27ck73 = 1.8 time = 740
* CHECK dout1_28 vdout1_28ck73 = 1.8 time = 740
* CHECK dout1_29 vdout1_29ck73 = 1.8 time = 740
* CHECK dout1_30 vdout1_30ck73 = 0 time = 740
* CHECK dout1_31 vdout1_31ck73 = 1.8 time = 740
* CHECK dout1_0 vdout1_0ck74 = 1.8 time = 750
* CHECK dout1_1 vdout1_1ck74 = 1.8 time = 750
* CHECK dout1_2 vdout1_2ck74 = 0 time = 750
* CHECK dout1_3 vdout1_3ck74 = 0 time = 750
* CHECK dout1_4 vdout1_4ck74 = 1.8 time = 750
* CHECK dout1_5 vdout1_5ck74 = 1.8 time = 750
* CHECK dout1_6 vdout1_6ck74 = 0 time = 750
* CHECK dout1_7 vdout1_7ck74 = 0 time = 750
* CHECK dout1_8 vdout1_8ck74 = 1.8 time = 750
* CHECK dout1_9 vdout1_9ck74 = 0 time = 750
* CHECK dout1_10 vdout1_10ck74 = 0 time = 750
* CHECK dout1_11 vdout1_11ck74 = 1.8 time = 750
* CHECK dout1_12 vdout1_12ck74 = 1.8 time = 750
* CHECK dout1_13 vdout1_13ck74 = 1.8 time = 750
* CHECK dout1_14 vdout1_14ck74 = 0 time = 750
* CHECK dout1_15 vdout1_15ck74 = 0 time = 750
* CHECK dout1_16 vdout1_16ck74 = 0 time = 750
* CHECK dout1_17 vdout1_17ck74 = 0 time = 750
* CHECK dout1_18 vdout1_18ck74 = 0 time = 750
* CHECK dout1_19 vdout1_19ck74 = 0 time = 750
* CHECK dout1_20 vdout1_20ck74 = 0 time = 750
* CHECK dout1_21 vdout1_21ck74 = 1.8 time = 750
* CHECK dout1_22 vdout1_22ck74 = 1.8 time = 750
* CHECK dout1_23 vdout1_23ck74 = 1.8 time = 750
* CHECK dout1_24 vdout1_24ck74 = 0 time = 750
* CHECK dout1_25 vdout1_25ck74 = 0 time = 750
* CHECK dout1_26 vdout1_26ck74 = 0 time = 750
* CHECK dout1_27 vdout1_27ck74 = 1.8 time = 750
* CHECK dout1_28 vdout1_28ck74 = 0 time = 750
* CHECK dout1_29 vdout1_29ck74 = 1.8 time = 750
* CHECK dout1_30 vdout1_30ck74 = 1.8 time = 750
* CHECK dout1_31 vdout1_31ck74 = 1.8 time = 750
* CHECK dout1_0 vdout1_0ck77 = 1.8 time = 780
* CHECK dout1_1 vdout1_1ck77 = 1.8 time = 780
* CHECK dout1_2 vdout1_2ck77 = 0 time = 780
* CHECK dout1_3 vdout1_3ck77 = 1.8 time = 780
* CHECK dout1_4 vdout1_4ck77 = 0 time = 780
* CHECK dout1_5 vdout1_5ck77 = 0 time = 780
* CHECK dout1_6 vdout1_6ck77 = 1.8 time = 780
* CHECK dout1_7 vdout1_7ck77 = 0 time = 780
* CHECK dout1_8 vdout1_8ck77 = 1.8 time = 780
* CHECK dout1_9 vdout1_9ck77 = 0 time = 780
* CHECK dout1_10 vdout1_10ck77 = 0 time = 780
* CHECK dout1_11 vdout1_11ck77 = 1.8 time = 780
* CHECK dout1_12 vdout1_12ck77 = 1.8 time = 780
* CHECK dout1_13 vdout1_13ck77 = 0 time = 780
* CHECK dout1_14 vdout1_14ck77 = 1.8 time = 780
* CHECK dout1_15 vdout1_15ck77 = 0 time = 780
* CHECK dout1_16 vdout1_16ck77 = 1.8 time = 780
* CHECK dout1_17 vdout1_17ck77 = 1.8 time = 780
* CHECK dout1_18 vdout1_18ck77 = 1.8 time = 780
* CHECK dout1_19 vdout1_19ck77 = 0 time = 780
* CHECK dout1_20 vdout1_20ck77 = 0 time = 780
* CHECK dout1_21 vdout1_21ck77 = 1.8 time = 780
* CHECK dout1_22 vdout1_22ck77 = 0 time = 780
* CHECK dout1_23 vdout1_23ck77 = 0 time = 780
* CHECK dout1_24 vdout1_24ck77 = 0 time = 780
* CHECK dout1_25 vdout1_25ck77 = 1.8 time = 780
* CHECK dout1_26 vdout1_26ck77 = 1.8 time = 780
* CHECK dout1_27 vdout1_27ck77 = 1.8 time = 780
* CHECK dout1_28 vdout1_28ck77 = 0 time = 780
* CHECK dout1_29 vdout1_29ck77 = 0 time = 780
* CHECK dout1_30 vdout1_30ck77 = 1.8 time = 780
* CHECK dout1_31 vdout1_31ck77 = 0 time = 780
* CHECK dout0_0 vdout0_0ck78 = 0 time = 790
* CHECK dout0_1 vdout0_1ck78 = 1.8 time = 790
* CHECK dout0_2 vdout0_2ck78 = 0 time = 790
* CHECK dout0_3 vdout0_3ck78 = 1.8 time = 790
* CHECK dout0_4 vdout0_4ck78 = 0 time = 790
* CHECK dout0_5 vdout0_5ck78 = 1.8 time = 790
* CHECK dout0_6 vdout0_6ck78 = 0 time = 790
* CHECK dout0_7 vdout0_7ck78 = 1.8 time = 790
* CHECK dout0_8 vdout0_8ck78 = 0 time = 790
* CHECK dout0_9 vdout0_9ck78 = 1.8 time = 790
* CHECK dout0_10 vdout0_10ck78 = 0 time = 790
* CHECK dout0_11 vdout0_11ck78 = 1.8 time = 790
* CHECK dout0_12 vdout0_12ck78 = 0 time = 790
* CHECK dout0_13 vdout0_13ck78 = 1.8 time = 790
* CHECK dout0_14 vdout0_14ck78 = 0 time = 790
* CHECK dout0_15 vdout0_15ck78 = 0 time = 790
* CHECK dout0_16 vdout0_16ck78 = 1.8 time = 790
* CHECK dout0_17 vdout0_17ck78 = 1.8 time = 790
* CHECK dout0_18 vdout0_18ck78 = 0 time = 790
* CHECK dout0_19 vdout0_19ck78 = 0 time = 790
* CHECK dout0_20 vdout0_20ck78 = 1.8 time = 790
* CHECK dout0_21 vdout0_21ck78 = 1.8 time = 790
* CHECK dout0_22 vdout0_22ck78 = 0 time = 790
* CHECK dout0_23 vdout0_23ck78 = 0 time = 790
* CHECK dout0_24 vdout0_24ck78 = 0 time = 790
* CHECK dout0_25 vdout0_25ck78 = 0 time = 790
* CHECK dout0_26 vdout0_26ck78 = 1.8 time = 790
* CHECK dout0_27 vdout0_27ck78 = 1.8 time = 790
* CHECK dout0_28 vdout0_28ck78 = 1.8 time = 790
* CHECK dout0_29 vdout0_29ck78 = 0 time = 790
* CHECK dout0_30 vdout0_30ck78 = 0 time = 790
* CHECK dout0_31 vdout0_31ck78 = 0 time = 790
* CHECK dout0_0 vdout0_0ck79 = 1.8 time = 800
* CHECK dout0_1 vdout0_1ck79 = 1.8 time = 800
* CHECK dout0_2 vdout0_2ck79 = 0 time = 800
* CHECK dout0_3 vdout0_3ck79 = 1.8 time = 800
* CHECK dout0_4 vdout0_4ck79 = 0 time = 800
* CHECK dout0_5 vdout0_5ck79 = 0 time = 800
* CHECK dout0_6 vdout0_6ck79 = 1.8 time = 800
* CHECK dout0_7 vdout0_7ck79 = 0 time = 800
* CHECK dout0_8 vdout0_8ck79 = 1.8 time = 800
* CHECK dout0_9 vdout0_9ck79 = 0 time = 800
* CHECK dout0_10 vdout0_10ck79 = 0 time = 800
* CHECK dout0_11 vdout0_11ck79 = 1.8 time = 800
* CHECK dout0_12 vdout0_12ck79 = 1.8 time = 800
* CHECK dout0_13 vdout0_13ck79 = 0 time = 800
* CHECK dout0_14 vdout0_14ck79 = 1.8 time = 800
* CHECK dout0_15 vdout0_15ck79 = 0 time = 800
* CHECK dout0_16 vdout0_16ck79 = 1.8 time = 800
* CHECK dout0_17 vdout0_17ck79 = 1.8 time = 800
* CHECK dout0_18 vdout0_18ck79 = 1.8 time = 800
* CHECK dout0_19 vdout0_19ck79 = 0 time = 800
* CHECK dout0_20 vdout0_20ck79 = 0 time = 800
* CHECK dout0_21 vdout0_21ck79 = 1.8 time = 800
* CHECK dout0_22 vdout0_22ck79 = 0 time = 800
* CHECK dout0_23 vdout0_23ck79 = 0 time = 800
* CHECK dout0_24 vdout0_24ck79 = 0 time = 800
* CHECK dout0_25 vdout0_25ck79 = 1.8 time = 800
* CHECK dout0_26 vdout0_26ck79 = 1.8 time = 800
* CHECK dout0_27 vdout0_27ck79 = 1.8 time = 800
* CHECK dout0_28 vdout0_28ck79 = 0 time = 800
* CHECK dout0_29 vdout0_29ck79 = 0 time = 800
* CHECK dout0_30 vdout0_30ck79 = 1.8 time = 800
* CHECK dout0_31 vdout0_31ck79 = 0 time = 800
* CHECK dout1_0 vdout1_0ck80 = 1.8 time = 810
* CHECK dout1_1 vdout1_1ck80 = 1.8 time = 810
* CHECK dout1_2 vdout1_2ck80 = 0 time = 810
* CHECK dout1_3 vdout1_3ck80 = 0 time = 810
* CHECK dout1_4 vdout1_4ck80 = 0 time = 810
* CHECK dout1_5 vdout1_5ck80 = 1.8 time = 810
* CHECK dout1_6 vdout1_6ck80 = 1.8 time = 810
* CHECK dout1_7 vdout1_7ck80 = 1.8 time = 810
* CHECK dout1_8 vdout1_8ck80 = 0 time = 810
* CHECK dout1_9 vdout1_9ck80 = 1.8 time = 810
* CHECK dout1_10 vdout1_10ck80 = 0 time = 810
* CHECK dout1_11 vdout1_11ck80 = 0 time = 810
* CHECK dout1_12 vdout1_12ck80 = 0 time = 810
* CHECK dout1_13 vdout1_13ck80 = 1.8 time = 810
* CHECK dout1_14 vdout1_14ck80 = 0 time = 810
* CHECK dout1_15 vdout1_15ck80 = 0 time = 810
* CHECK dout1_16 vdout1_16ck80 = 1.8 time = 810
* CHECK dout1_17 vdout1_17ck80 = 1.8 time = 810
* CHECK dout1_18 vdout1_18ck80 = 1.8 time = 810
* CHECK dout1_19 vdout1_19ck80 = 1.8 time = 810
* CHECK dout1_20 vdout1_20ck80 = 0 time = 810
* CHECK dout1_21 vdout1_21ck80 = 0 time = 810
* CHECK dout1_22 vdout1_22ck80 = 1.8 time = 810
* CHECK dout1_23 vdout1_23ck80 = 1.8 time = 810
* CHECK dout1_24 vdout1_24ck80 = 1.8 time = 810
* CHECK dout1_25 vdout1_25ck80 = 1.8 time = 810
* CHECK dout1_26 vdout1_26ck80 = 0 time = 810
* CHECK dout1_27 vdout1_27ck80 = 0 time = 810
* CHECK dout1_28 vdout1_28ck80 = 0 time = 810
* CHECK dout1_29 vdout1_29ck80 = 1.8 time = 810
* CHECK dout1_30 vdout1_30ck80 = 1.8 time = 810
* CHECK dout1_31 vdout1_31ck80 = 1.8 time = 810
* CHECK dout0_0 vdout0_0ck81 = 1.8 time = 820
* CHECK dout0_1 vdout0_1ck81 = 1.8 time = 820
* CHECK dout0_2 vdout0_2ck81 = 0 time = 820
* CHECK dout0_3 vdout0_3ck81 = 1.8 time = 820
* CHECK dout0_4 vdout0_4ck81 = 0 time = 820
* CHECK dout0_5 vdout0_5ck81 = 0 time = 820
* CHECK dout0_6 vdout0_6ck81 = 1.8 time = 820
* CHECK dout0_7 vdout0_7ck81 = 0 time = 820
* CHECK dout0_8 vdout0_8ck81 = 1.8 time = 820
* CHECK dout0_9 vdout0_9ck81 = 0 time = 820
* CHECK dout0_10 vdout0_10ck81 = 0 time = 820
* CHECK dout0_11 vdout0_11ck81 = 1.8 time = 820
* CHECK dout0_12 vdout0_12ck81 = 1.8 time = 820
* CHECK dout0_13 vdout0_13ck81 = 0 time = 820
* CHECK dout0_14 vdout0_14ck81 = 1.8 time = 820
* CHECK dout0_15 vdout0_15ck81 = 0 time = 820
* CHECK dout0_16 vdout0_16ck81 = 1.8 time = 820
* CHECK dout0_17 vdout0_17ck81 = 1.8 time = 820
* CHECK dout0_18 vdout0_18ck81 = 1.8 time = 820
* CHECK dout0_19 vdout0_19ck81 = 0 time = 820
* CHECK dout0_20 vdout0_20ck81 = 0 time = 820
* CHECK dout0_21 vdout0_21ck81 = 1.8 time = 820
* CHECK dout0_22 vdout0_22ck81 = 0 time = 820
* CHECK dout0_23 vdout0_23ck81 = 0 time = 820
* CHECK dout0_24 vdout0_24ck81 = 0 time = 820
* CHECK dout0_25 vdout0_25ck81 = 1.8 time = 820
* CHECK dout0_26 vdout0_26ck81 = 1.8 time = 820
* CHECK dout0_27 vdout0_27ck81 = 1.8 time = 820
* CHECK dout0_28 vdout0_28ck81 = 0 time = 820
* CHECK dout0_29 vdout0_29ck81 = 0 time = 820
* CHECK dout0_30 vdout0_30ck81 = 1.8 time = 820
* CHECK dout0_31 vdout0_31ck81 = 0 time = 820
* CHECK dout0_0 vdout0_0ck82 = 1.8 time = 830
* CHECK dout0_1 vdout0_1ck82 = 1.8 time = 830
* CHECK dout0_2 vdout0_2ck82 = 1.8 time = 830
* CHECK dout0_3 vdout0_3ck82 = 0 time = 830
* CHECK dout0_4 vdout0_4ck82 = 0 time = 830
* CHECK dout0_5 vdout0_5ck82 = 1.8 time = 830
* CHECK dout0_6 vdout0_6ck82 = 1.8 time = 830
* CHECK dout0_7 vdout0_7ck82 = 0 time = 830
* CHECK dout0_8 vdout0_8ck82 = 1.8 time = 830
* CHECK dout0_9 vdout0_9ck82 = 0 time = 830
* CHECK dout0_10 vdout0_10ck82 = 0 time = 830
* CHECK dout0_11 vdout0_11ck82 = 1.8 time = 830
* CHECK dout0_12 vdout0_12ck82 = 1.8 time = 830
* CHECK dout0_13 vdout0_13ck82 = 0 time = 830
* CHECK dout0_14 vdout0_14ck82 = 1.8 time = 830
* CHECK dout0_15 vdout0_15ck82 = 1.8 time = 830
* CHECK dout0_16 vdout0_16ck82 = 1.8 time = 830
* CHECK dout0_17 vdout0_17ck82 = 0 time = 830
* CHECK dout0_18 vdout0_18ck82 = 1.8 time = 830
* CHECK dout0_19 vdout0_19ck82 = 1.8 time = 830
* CHECK dout0_20 vdout0_20ck82 = 0 time = 830
* CHECK dout0_21 vdout0_21ck82 = 0 time = 830
* CHECK dout0_22 vdout0_22ck82 = 0 time = 830
* CHECK dout0_23 vdout0_23ck82 = 0 time = 830
* CHECK dout0_24 vdout0_24ck82 = 0 time = 830
* CHECK dout0_25 vdout0_25ck82 = 1.8 time = 830
* CHECK dout0_26 vdout0_26ck82 = 0 time = 830
* CHECK dout0_27 vdout0_27ck82 = 1.8 time = 830
* CHECK dout0_28 vdout0_28ck82 = 0 time = 830
* CHECK dout0_29 vdout0_29ck82 = 0 time = 830
* CHECK dout0_30 vdout0_30ck82 = 0 time = 830
* CHECK dout0_31 vdout0_31ck82 = 0 time = 830
* CHECK dout1_0 vdout1_0ck82 = 0 time = 830
* CHECK dout1_1 vdout1_1ck82 = 1.8 time = 830
* CHECK dout1_2 vdout1_2ck82 = 0 time = 830
* CHECK dout1_3 vdout1_3ck82 = 1.8 time = 830
* CHECK dout1_4 vdout1_4ck82 = 0 time = 830
* CHECK dout1_5 vdout1_5ck82 = 1.8 time = 830
* CHECK dout1_6 vdout1_6ck82 = 0 time = 830
* CHECK dout1_7 vdout1_7ck82 = 1.8 time = 830
* CHECK dout1_8 vdout1_8ck82 = 0 time = 830
* CHECK dout1_9 vdout1_9ck82 = 1.8 time = 830
* CHECK dout1_10 vdout1_10ck82 = 0 time = 830
* CHECK dout1_11 vdout1_11ck82 = 1.8 time = 830
* CHECK dout1_12 vdout1_12ck82 = 0 time = 830
* CHECK dout1_13 vdout1_13ck82 = 1.8 time = 830
* CHECK dout1_14 vdout1_14ck82 = 0 time = 830
* CHECK dout1_15 vdout1_15ck82 = 0 time = 830
* CHECK dout1_16 vdout1_16ck82 = 1.8 time = 830
* CHECK dout1_17 vdout1_17ck82 = 1.8 time = 830
* CHECK dout1_18 vdout1_18ck82 = 0 time = 830
* CHECK dout1_19 vdout1_19ck82 = 0 time = 830
* CHECK dout1_20 vdout1_20ck82 = 1.8 time = 830
* CHECK dout1_21 vdout1_21ck82 = 1.8 time = 830
* CHECK dout1_22 vdout1_22ck82 = 0 time = 830
* CHECK dout1_23 vdout1_23ck82 = 0 time = 830
* CHECK dout1_24 vdout1_24ck82 = 0 time = 830
* CHECK dout1_25 vdout1_25ck82 = 0 time = 830
* CHECK dout1_26 vdout1_26ck82 = 1.8 time = 830
* CHECK dout1_27 vdout1_27ck82 = 1.8 time = 830
* CHECK dout1_28 vdout1_28ck82 = 1.8 time = 830
* CHECK dout1_29 vdout1_29ck82 = 0 time = 830
* CHECK dout1_30 vdout1_30ck82 = 0 time = 830
* CHECK dout1_31 vdout1_31ck82 = 0 time = 830
* CHECK dout0_0 vdout0_0ck85 = 1.8 time = 860
* CHECK dout0_1 vdout0_1ck85 = 1.8 time = 860
* CHECK dout0_2 vdout0_2ck85 = 0 time = 860
* CHECK dout0_3 vdout0_3ck85 = 0 time = 860
* CHECK dout0_4 vdout0_4ck85 = 0 time = 860
* CHECK dout0_5 vdout0_5ck85 = 1.8 time = 860
* CHECK dout0_6 vdout0_6ck85 = 1.8 time = 860
* CHECK dout0_7 vdout0_7ck85 = 1.8 time = 860
* CHECK dout0_8 vdout0_8ck85 = 0 time = 860
* CHECK dout0_9 vdout0_9ck85 = 1.8 time = 860
* CHECK dout0_10 vdout0_10ck85 = 0 time = 860
* CHECK dout0_11 vdout0_11ck85 = 0 time = 860
* CHECK dout0_12 vdout0_12ck85 = 0 time = 860
* CHECK dout0_13 vdout0_13ck85 = 1.8 time = 860
* CHECK dout0_14 vdout0_14ck85 = 0 time = 860
* CHECK dout0_15 vdout0_15ck85 = 0 time = 860
* CHECK dout0_16 vdout0_16ck85 = 1.8 time = 860
* CHECK dout0_17 vdout0_17ck85 = 1.8 time = 860
* CHECK dout0_18 vdout0_18ck85 = 1.8 time = 860
* CHECK dout0_19 vdout0_19ck85 = 1.8 time = 860
* CHECK dout0_20 vdout0_20ck85 = 0 time = 860
* CHECK dout0_21 vdout0_21ck85 = 0 time = 860
* CHECK dout0_22 vdout0_22ck85 = 1.8 time = 860
* CHECK dout0_23 vdout0_23ck85 = 1.8 time = 860
* CHECK dout0_24 vdout0_24ck85 = 1.8 time = 860
* CHECK dout0_25 vdout0_25ck85 = 1.8 time = 860
* CHECK dout0_26 vdout0_26ck85 = 0 time = 860
* CHECK dout0_27 vdout0_27ck85 = 0 time = 860
* CHECK dout0_28 vdout0_28ck85 = 0 time = 860
* CHECK dout0_29 vdout0_29ck85 = 1.8 time = 860
* CHECK dout0_30 vdout0_30ck85 = 1.8 time = 860
* CHECK dout0_31 vdout0_31ck85 = 1.8 time = 860
* CHECK dout1_0 vdout1_0ck85 = 0 time = 860
* CHECK dout1_1 vdout1_1ck85 = 1.8 time = 860
* CHECK dout1_2 vdout1_2ck85 = 0 time = 860
* CHECK dout1_3 vdout1_3ck85 = 1.8 time = 860
* CHECK dout1_4 vdout1_4ck85 = 0 time = 860
* CHECK dout1_5 vdout1_5ck85 = 1.8 time = 860
* CHECK dout1_6 vdout1_6ck85 = 0 time = 860
* CHECK dout1_7 vdout1_7ck85 = 1.8 time = 860
* CHECK dout1_8 vdout1_8ck85 = 0 time = 860
* CHECK dout1_9 vdout1_9ck85 = 1.8 time = 860
* CHECK dout1_10 vdout1_10ck85 = 0 time = 860
* CHECK dout1_11 vdout1_11ck85 = 1.8 time = 860
* CHECK dout1_12 vdout1_12ck85 = 0 time = 860
* CHECK dout1_13 vdout1_13ck85 = 1.8 time = 860
* CHECK dout1_14 vdout1_14ck85 = 0 time = 860
* CHECK dout1_15 vdout1_15ck85 = 0 time = 860
* CHECK dout1_16 vdout1_16ck85 = 1.8 time = 860
* CHECK dout1_17 vdout1_17ck85 = 1.8 time = 860
* CHECK dout1_18 vdout1_18ck85 = 0 time = 860
* CHECK dout1_19 vdout1_19ck85 = 0 time = 860
* CHECK dout1_20 vdout1_20ck85 = 1.8 time = 860
* CHECK dout1_21 vdout1_21ck85 = 1.8 time = 860
* CHECK dout1_22 vdout1_22ck85 = 0 time = 860
* CHECK dout1_23 vdout1_23ck85 = 0 time = 860
* CHECK dout1_24 vdout1_24ck85 = 0 time = 860
* CHECK dout1_25 vdout1_25ck85 = 0 time = 860
* CHECK dout1_26 vdout1_26ck85 = 1.8 time = 860
* CHECK dout1_27 vdout1_27ck85 = 1.8 time = 860
* CHECK dout1_28 vdout1_28ck85 = 1.8 time = 860
* CHECK dout1_29 vdout1_29ck85 = 0 time = 860
* CHECK dout1_30 vdout1_30ck85 = 0 time = 860
* CHECK dout1_31 vdout1_31ck85 = 0 time = 860
* CHECK dout1_0 vdout1_0ck86 = 1.8 time = 870
* CHECK dout1_1 vdout1_1ck86 = 1.8 time = 870
* CHECK dout1_2 vdout1_2ck86 = 0 time = 870
* CHECK dout1_3 vdout1_3ck86 = 1.8 time = 870
* CHECK dout1_4 vdout1_4ck86 = 0 time = 870
* CHECK dout1_5 vdout1_5ck86 = 0 time = 870
* CHECK dout1_6 vdout1_6ck86 = 1.8 time = 870
* CHECK dout1_7 vdout1_7ck86 = 0 time = 870
* CHECK dout1_8 vdout1_8ck86 = 1.8 time = 870
* CHECK dout1_9 vdout1_9ck86 = 0 time = 870
* CHECK dout1_10 vdout1_10ck86 = 0 time = 870
* CHECK dout1_11 vdout1_11ck86 = 1.8 time = 870
* CHECK dout1_12 vdout1_12ck86 = 1.8 time = 870
* CHECK dout1_13 vdout1_13ck86 = 0 time = 870
* CHECK dout1_14 vdout1_14ck86 = 1.8 time = 870
* CHECK dout1_15 vdout1_15ck86 = 0 time = 870
* CHECK dout1_16 vdout1_16ck86 = 1.8 time = 870
* CHECK dout1_17 vdout1_17ck86 = 1.8 time = 870
* CHECK dout1_18 vdout1_18ck86 = 1.8 time = 870
* CHECK dout1_19 vdout1_19ck86 = 0 time = 870
* CHECK dout1_20 vdout1_20ck86 = 0 time = 870
* CHECK dout1_21 vdout1_21ck86 = 1.8 time = 870
* CHECK dout1_22 vdout1_22ck86 = 0 time = 870
* CHECK dout1_23 vdout1_23ck86 = 0 time = 870
* CHECK dout1_24 vdout1_24ck86 = 0 time = 870
* CHECK dout1_25 vdout1_25ck86 = 1.8 time = 870
* CHECK dout1_26 vdout1_26ck86 = 1.8 time = 870
* CHECK dout1_27 vdout1_27ck86 = 1.8 time = 870
* CHECK dout1_28 vdout1_28ck86 = 0 time = 870
* CHECK dout1_29 vdout1_29ck86 = 0 time = 870
* CHECK dout1_30 vdout1_30ck86 = 1.8 time = 870
* CHECK dout1_31 vdout1_31ck86 = 0 time = 870
* CHECK dout1_0 vdout1_0ck87 = 0 time = 880
* CHECK dout1_1 vdout1_1ck87 = 1.8 time = 880
* CHECK dout1_2 vdout1_2ck87 = 1.8 time = 880
* CHECK dout1_3 vdout1_3ck87 = 1.8 time = 880
* CHECK dout1_4 vdout1_4ck87 = 1.8 time = 880
* CHECK dout1_5 vdout1_5ck87 = 1.8 time = 880
* CHECK dout1_6 vdout1_6ck87 = 0 time = 880
* CHECK dout1_7 vdout1_7ck87 = 1.8 time = 880
* CHECK dout1_8 vdout1_8ck87 = 1.8 time = 880
* CHECK dout1_9 vdout1_9ck87 = 0 time = 880
* CHECK dout1_10 vdout1_10ck87 = 0 time = 880
* CHECK dout1_11 vdout1_11ck87 = 1.8 time = 880
* CHECK dout1_12 vdout1_12ck87 = 0 time = 880
* CHECK dout1_13 vdout1_13ck87 = 1.8 time = 880
* CHECK dout1_14 vdout1_14ck87 = 0 time = 880
* CHECK dout1_15 vdout1_15ck87 = 1.8 time = 880
* CHECK dout1_16 vdout1_16ck87 = 1.8 time = 880
* CHECK dout1_17 vdout1_17ck87 = 0 time = 880
* CHECK dout1_18 vdout1_18ck87 = 0 time = 880
* CHECK dout1_19 vdout1_19ck87 = 0 time = 880
* CHECK dout1_20 vdout1_20ck87 = 1.8 time = 880
* CHECK dout1_21 vdout1_21ck87 = 1.8 time = 880
* CHECK dout1_22 vdout1_22ck87 = 1.8 time = 880
* CHECK dout1_23 vdout1_23ck87 = 0 time = 880
* CHECK dout1_24 vdout1_24ck87 = 0 time = 880
* CHECK dout1_25 vdout1_25ck87 = 0 time = 880
* CHECK dout1_26 vdout1_26ck87 = 0 time = 880
* CHECK dout1_27 vdout1_27ck87 = 1.8 time = 880
* CHECK dout1_28 vdout1_28ck87 = 1.8 time = 880
* CHECK dout1_29 vdout1_29ck87 = 0 time = 880
* CHECK dout1_30 vdout1_30ck87 = 1.8 time = 880
* CHECK dout1_31 vdout1_31ck87 = 0 time = 880
* CHECK dout0_0 vdout0_0ck88 = 0 time = 890
* CHECK dout0_1 vdout0_1ck88 = 1.8 time = 890
* CHECK dout0_2 vdout0_2ck88 = 1.8 time = 890
* CHECK dout0_3 vdout0_3ck88 = 1.8 time = 890
* CHECK dout0_4 vdout0_4ck88 = 1.8 time = 890
* CHECK dout0_5 vdout0_5ck88 = 1.8 time = 890
* CHECK dout0_6 vdout0_6ck88 = 0 time = 890
* CHECK dout0_7 vdout0_7ck88 = 1.8 time = 890
* CHECK dout0_8 vdout0_8ck88 = 1.8 time = 890
* CHECK dout0_9 vdout0_9ck88 = 0 time = 890
* CHECK dout0_10 vdout0_10ck88 = 0 time = 890
* CHECK dout0_11 vdout0_11ck88 = 1.8 time = 890
* CHECK dout0_12 vdout0_12ck88 = 0 time = 890
* CHECK dout0_13 vdout0_13ck88 = 1.8 time = 890
* CHECK dout0_14 vdout0_14ck88 = 0 time = 890
* CHECK dout0_15 vdout0_15ck88 = 1.8 time = 890
* CHECK dout0_16 vdout0_16ck88 = 1.8 time = 890
* CHECK dout0_17 vdout0_17ck88 = 0 time = 890
* CHECK dout0_18 vdout0_18ck88 = 0 time = 890
* CHECK dout0_19 vdout0_19ck88 = 0 time = 890
* CHECK dout0_20 vdout0_20ck88 = 1.8 time = 890
* CHECK dout0_21 vdout0_21ck88 = 1.8 time = 890
* CHECK dout0_22 vdout0_22ck88 = 1.8 time = 890
* CHECK dout0_23 vdout0_23ck88 = 0 time = 890
* CHECK dout0_24 vdout0_24ck88 = 0 time = 890
* CHECK dout0_25 vdout0_25ck88 = 0 time = 890
* CHECK dout0_26 vdout0_26ck88 = 0 time = 890
* CHECK dout0_27 vdout0_27ck88 = 1.8 time = 890
* CHECK dout0_28 vdout0_28ck88 = 1.8 time = 890
* CHECK dout0_29 vdout0_29ck88 = 0 time = 890
* CHECK dout0_30 vdout0_30ck88 = 1.8 time = 890
* CHECK dout0_31 vdout0_31ck88 = 0 time = 890
* CHECK dout0_0 vdout0_0ck89 = 0 time = 900
* CHECK dout0_1 vdout0_1ck89 = 1.8 time = 900
* CHECK dout0_2 vdout0_2ck89 = 1.8 time = 900
* CHECK dout0_3 vdout0_3ck89 = 1.8 time = 900
* CHECK dout0_4 vdout0_4ck89 = 1.8 time = 900
* CHECK dout0_5 vdout0_5ck89 = 1.8 time = 900
* CHECK dout0_6 vdout0_6ck89 = 0 time = 900
* CHECK dout0_7 vdout0_7ck89 = 1.8 time = 900
* CHECK dout0_8 vdout0_8ck89 = 1.8 time = 900
* CHECK dout0_9 vdout0_9ck89 = 0 time = 900
* CHECK dout0_10 vdout0_10ck89 = 0 time = 900
* CHECK dout0_11 vdout0_11ck89 = 1.8 time = 900
* CHECK dout0_12 vdout0_12ck89 = 0 time = 900
* CHECK dout0_13 vdout0_13ck89 = 1.8 time = 900
* CHECK dout0_14 vdout0_14ck89 = 0 time = 900
* CHECK dout0_15 vdout0_15ck89 = 1.8 time = 900
* CHECK dout0_16 vdout0_16ck89 = 1.8 time = 900
* CHECK dout0_17 vdout0_17ck89 = 0 time = 900
* CHECK dout0_18 vdout0_18ck89 = 0 time = 900
* CHECK dout0_19 vdout0_19ck89 = 0 time = 900
* CHECK dout0_20 vdout0_20ck89 = 1.8 time = 900
* CHECK dout0_21 vdout0_21ck89 = 1.8 time = 900
* CHECK dout0_22 vdout0_22ck89 = 1.8 time = 900
* CHECK dout0_23 vdout0_23ck89 = 0 time = 900
* CHECK dout0_24 vdout0_24ck89 = 0 time = 900
* CHECK dout0_25 vdout0_25ck89 = 0 time = 900
* CHECK dout0_26 vdout0_26ck89 = 0 time = 900
* CHECK dout0_27 vdout0_27ck89 = 1.8 time = 900
* CHECK dout0_28 vdout0_28ck89 = 1.8 time = 900
* CHECK dout0_29 vdout0_29ck89 = 0 time = 900
* CHECK dout0_30 vdout0_30ck89 = 1.8 time = 900
* CHECK dout0_31 vdout0_31ck89 = 0 time = 900
* CHECK dout1_0 vdout1_0ck89 = 0 time = 900
* CHECK dout1_1 vdout1_1ck89 = 1.8 time = 900
* CHECK dout1_2 vdout1_2ck89 = 1.8 time = 900
* CHECK dout1_3 vdout1_3ck89 = 1.8 time = 900
* CHECK dout1_4 vdout1_4ck89 = 1.8 time = 900
* CHECK dout1_5 vdout1_5ck89 = 1.8 time = 900
* CHECK dout1_6 vdout1_6ck89 = 0 time = 900
* CHECK dout1_7 vdout1_7ck89 = 1.8 time = 900
* CHECK dout1_8 vdout1_8ck89 = 1.8 time = 900
* CHECK dout1_9 vdout1_9ck89 = 0 time = 900
* CHECK dout1_10 vdout1_10ck89 = 0 time = 900
* CHECK dout1_11 vdout1_11ck89 = 1.8 time = 900
* CHECK dout1_12 vdout1_12ck89 = 0 time = 900
* CHECK dout1_13 vdout1_13ck89 = 1.8 time = 900
* CHECK dout1_14 vdout1_14ck89 = 0 time = 900
* CHECK dout1_15 vdout1_15ck89 = 1.8 time = 900
* CHECK dout1_16 vdout1_16ck89 = 1.8 time = 900
* CHECK dout1_17 vdout1_17ck89 = 0 time = 900
* CHECK dout1_18 vdout1_18ck89 = 0 time = 900
* CHECK dout1_19 vdout1_19ck89 = 0 time = 900
* CHECK dout1_20 vdout1_20ck89 = 1.8 time = 900
* CHECK dout1_21 vdout1_21ck89 = 1.8 time = 900
* CHECK dout1_22 vdout1_22ck89 = 1.8 time = 900
* CHECK dout1_23 vdout1_23ck89 = 0 time = 900
* CHECK dout1_24 vdout1_24ck89 = 0 time = 900
* CHECK dout1_25 vdout1_25ck89 = 0 time = 900
* CHECK dout1_26 vdout1_26ck89 = 0 time = 900
* CHECK dout1_27 vdout1_27ck89 = 1.8 time = 900
* CHECK dout1_28 vdout1_28ck89 = 1.8 time = 900
* CHECK dout1_29 vdout1_29ck89 = 0 time = 900
* CHECK dout1_30 vdout1_30ck89 = 1.8 time = 900
* CHECK dout1_31 vdout1_31ck89 = 0 time = 900
* CHECK dout0_0 vdout0_0ck93 = 0 time = 940
* CHECK dout0_1 vdout0_1ck93 = 0 time = 940
* CHECK dout0_2 vdout0_2ck93 = 1.8 time = 940
* CHECK dout0_3 vdout0_3ck93 = 0 time = 940
* CHECK dout0_4 vdout0_4ck93 = 0 time = 940
* CHECK dout0_5 vdout0_5ck93 = 1.8 time = 940
* CHECK dout0_6 vdout0_6ck93 = 0 time = 940
* CHECK dout0_7 vdout0_7ck93 = 0 time = 940
* CHECK dout0_8 vdout0_8ck93 = 1.8 time = 940
* CHECK dout0_9 vdout0_9ck93 = 0 time = 940
* CHECK dout0_10 vdout0_10ck93 = 1.8 time = 940
* CHECK dout0_11 vdout0_11ck93 = 1.8 time = 940
* CHECK dout0_12 vdout0_12ck93 = 1.8 time = 940
* CHECK dout0_13 vdout0_13ck93 = 1.8 time = 940
* CHECK dout0_14 vdout0_14ck93 = 1.8 time = 940
* CHECK dout0_15 vdout0_15ck93 = 1.8 time = 940
* CHECK dout0_16 vdout0_16ck93 = 0 time = 940
* CHECK dout0_17 vdout0_17ck93 = 0 time = 940
* CHECK dout0_18 vdout0_18ck93 = 1.8 time = 940
* CHECK dout0_19 vdout0_19ck93 = 0 time = 940
* CHECK dout0_20 vdout0_20ck93 = 1.8 time = 940
* CHECK dout0_21 vdout0_21ck93 = 0 time = 940
* CHECK dout0_22 vdout0_22ck93 = 1.8 time = 940
* CHECK dout0_23 vdout0_23ck93 = 0 time = 940
* CHECK dout0_24 vdout0_24ck93 = 0 time = 940
* CHECK dout0_25 vdout0_25ck93 = 1.8 time = 940
* CHECK dout0_26 vdout0_26ck93 = 1.8 time = 940
* CHECK dout0_27 vdout0_27ck93 = 0 time = 940
* CHECK dout0_28 vdout0_28ck93 = 0 time = 940
* CHECK dout0_29 vdout0_29ck93 = 1.8 time = 940
* CHECK dout0_30 vdout0_30ck93 = 0 time = 940
* CHECK dout0_31 vdout0_31ck93 = 0 time = 940
* CHECK dout1_0 vdout1_0ck93 = 0 time = 940
* CHECK dout1_1 vdout1_1ck93 = 1.8 time = 940
* CHECK dout1_2 vdout1_2ck93 = 1.8 time = 940
* CHECK dout1_3 vdout1_3ck93 = 1.8 time = 940
* CHECK dout1_4 vdout1_4ck93 = 1.8 time = 940
* CHECK dout1_5 vdout1_5ck93 = 1.8 time = 940
* CHECK dout1_6 vdout1_6ck93 = 0 time = 940
* CHECK dout1_7 vdout1_7ck93 = 1.8 time = 940
* CHECK dout1_8 vdout1_8ck93 = 1.8 time = 940
* CHECK dout1_9 vdout1_9ck93 = 0 time = 940
* CHECK dout1_10 vdout1_10ck93 = 0 time = 940
* CHECK dout1_11 vdout1_11ck93 = 1.8 time = 940
* CHECK dout1_12 vdout1_12ck93 = 0 time = 940
* CHECK dout1_13 vdout1_13ck93 = 1.8 time = 940
* CHECK dout1_14 vdout1_14ck93 = 0 time = 940
* CHECK dout1_15 vdout1_15ck93 = 1.8 time = 940
* CHECK dout1_16 vdout1_16ck93 = 1.8 time = 940
* CHECK dout1_17 vdout1_17ck93 = 0 time = 940
* CHECK dout1_18 vdout1_18ck93 = 0 time = 940
* CHECK dout1_19 vdout1_19ck93 = 0 time = 940
* CHECK dout1_20 vdout1_20ck93 = 1.8 time = 940
* CHECK dout1_21 vdout1_21ck93 = 1.8 time = 940
* CHECK dout1_22 vdout1_22ck93 = 1.8 time = 940
* CHECK dout1_23 vdout1_23ck93 = 0 time = 940
* CHECK dout1_24 vdout1_24ck93 = 0 time = 940
* CHECK dout1_25 vdout1_25ck93 = 0 time = 940
* CHECK dout1_26 vdout1_26ck93 = 0 time = 940
* CHECK dout1_27 vdout1_27ck93 = 1.8 time = 940
* CHECK dout1_28 vdout1_28ck93 = 1.8 time = 940
* CHECK dout1_29 vdout1_29ck93 = 0 time = 940
* CHECK dout1_30 vdout1_30ck93 = 1.8 time = 940
* CHECK dout1_31 vdout1_31ck93 = 0 time = 940
* CHECK dout0_0 vdout0_0ck94 = 0 time = 950
* CHECK dout0_1 vdout0_1ck94 = 1.8 time = 950
* CHECK dout0_2 vdout0_2ck94 = 1.8 time = 950
* CHECK dout0_3 vdout0_3ck94 = 1.8 time = 950
* CHECK dout0_4 vdout0_4ck94 = 0 time = 950
* CHECK dout0_5 vdout0_5ck94 = 0 time = 950
* CHECK dout0_6 vdout0_6ck94 = 0 time = 950
* CHECK dout0_7 vdout0_7ck94 = 0 time = 950
* CHECK dout0_8 vdout0_8ck94 = 0 time = 950
* CHECK dout0_9 vdout0_9ck94 = 1.8 time = 950
* CHECK dout0_10 vdout0_10ck94 = 0 time = 950
* CHECK dout0_11 vdout0_11ck94 = 1.8 time = 950
* CHECK dout0_12 vdout0_12ck94 = 0 time = 950
* CHECK dout0_13 vdout0_13ck94 = 1.8 time = 950
* CHECK dout0_14 vdout0_14ck94 = 0 time = 950
* CHECK dout0_15 vdout0_15ck94 = 0 time = 950
* CHECK dout0_16 vdout0_16ck94 = 1.8 time = 950
* CHECK dout0_17 vdout0_17ck94 = 0 time = 950
* CHECK dout0_18 vdout0_18ck94 = 0 time = 950
* CHECK dout0_19 vdout0_19ck94 = 1.8 time = 950
* CHECK dout0_20 vdout0_20ck94 = 1.8 time = 950
* CHECK dout0_21 vdout0_21ck94 = 1.8 time = 950
* CHECK dout0_22 vdout0_22ck94 = 0 time = 950
* CHECK dout0_23 vdout0_23ck94 = 1.8 time = 950
* CHECK dout0_24 vdout0_24ck94 = 1.8 time = 950
* CHECK dout0_25 vdout0_25ck94 = 1.8 time = 950
* CHECK dout0_26 vdout0_26ck94 = 1.8 time = 950
* CHECK dout0_27 vdout0_27ck94 = 1.8 time = 950
* CHECK dout0_28 vdout0_28ck94 = 0 time = 950
* CHECK dout0_29 vdout0_29ck94 = 0 time = 950
* CHECK dout0_30 vdout0_30ck94 = 1.8 time = 950
* CHECK dout0_31 vdout0_31ck94 = 1.8 time = 950
* CHECK dout1_0 vdout1_0ck94 = 0 time = 950
* CHECK dout1_1 vdout1_1ck94 = 0 time = 950
* CHECK dout1_2 vdout1_2ck94 = 1.8 time = 950
* CHECK dout1_3 vdout1_3ck94 = 0 time = 950
* CHECK dout1_4 vdout1_4ck94 = 0 time = 950
* CHECK dout1_5 vdout1_5ck94 = 0 time = 950
* CHECK dout1_6 vdout1_6ck94 = 1.8 time = 950
* CHECK dout1_7 vdout1_7ck94 = 0 time = 950
* CHECK dout1_8 vdout1_8ck94 = 0 time = 950
* CHECK dout1_9 vdout1_9ck94 = 1.8 time = 950
* CHECK dout1_10 vdout1_10ck94 = 0 time = 950
* CHECK dout1_11 vdout1_11ck94 = 0 time = 950
* CHECK dout1_12 vdout1_12ck94 = 1.8 time = 950
* CHECK dout1_13 vdout1_13ck94 = 1.8 time = 950
* CHECK dout1_14 vdout1_14ck94 = 0 time = 950
* CHECK dout1_15 vdout1_15ck94 = 0 time = 950
* CHECK dout1_16 vdout1_16ck94 = 1.8 time = 950
* CHECK dout1_17 vdout1_17ck94 = 1.8 time = 950
* CHECK dout1_18 vdout1_18ck94 = 0 time = 950
* CHECK dout1_19 vdout1_19ck94 = 1.8 time = 950
* CHECK dout1_20 vdout1_20ck94 = 1.8 time = 950
* CHECK dout1_21 vdout1_21ck94 = 0 time = 950
* CHECK dout1_22 vdout1_22ck94 = 0 time = 950
* CHECK dout1_23 vdout1_23ck94 = 0 time = 950
* CHECK dout1_24 vdout1_24ck94 = 1.8 time = 950
* CHECK dout1_25 vdout1_25ck94 = 1.8 time = 950
* CHECK dout1_26 vdout1_26ck94 = 1.8 time = 950
* CHECK dout1_27 vdout1_27ck94 = 1.8 time = 950
* CHECK dout1_28 vdout1_28ck94 = 1.8 time = 950
* CHECK dout1_29 vdout1_29ck94 = 1.8 time = 950
* CHECK dout1_30 vdout1_30ck94 = 0 time = 950
* CHECK dout1_31 vdout1_31ck94 = 0 time = 950
* CHECK dout0_0 vdout0_0ck95 = 0 time = 960
* CHECK dout0_1 vdout0_1ck95 = 1.8 time = 960
* CHECK dout0_2 vdout0_2ck95 = 1.8 time = 960
* CHECK dout0_3 vdout0_3ck95 = 1.8 time = 960
* CHECK dout0_4 vdout0_4ck95 = 1.8 time = 960
* CHECK dout0_5 vdout0_5ck95 = 1.8 time = 960
* CHECK dout0_6 vdout0_6ck95 = 0 time = 960
* CHECK dout0_7 vdout0_7ck95 = 1.8 time = 960
* CHECK dout0_8 vdout0_8ck95 = 1.8 time = 960
* CHECK dout0_9 vdout0_9ck95 = 0 time = 960
* CHECK dout0_10 vdout0_10ck95 = 0 time = 960
* CHECK dout0_11 vdout0_11ck95 = 1.8 time = 960
* CHECK dout0_12 vdout0_12ck95 = 0 time = 960
* CHECK dout0_13 vdout0_13ck95 = 1.8 time = 960
* CHECK dout0_14 vdout0_14ck95 = 0 time = 960
* CHECK dout0_15 vdout0_15ck95 = 1.8 time = 960
* CHECK dout0_16 vdout0_16ck95 = 1.8 time = 960
* CHECK dout0_17 vdout0_17ck95 = 0 time = 960
* CHECK dout0_18 vdout0_18ck95 = 0 time = 960
* CHECK dout0_19 vdout0_19ck95 = 0 time = 960
* CHECK dout0_20 vdout0_20ck95 = 1.8 time = 960
* CHECK dout0_21 vdout0_21ck95 = 1.8 time = 960
* CHECK dout0_22 vdout0_22ck95 = 1.8 time = 960
* CHECK dout0_23 vdout0_23ck95 = 0 time = 960
* CHECK dout0_24 vdout0_24ck95 = 0 time = 960
* CHECK dout0_25 vdout0_25ck95 = 0 time = 960
* CHECK dout0_26 vdout0_26ck95 = 0 time = 960
* CHECK dout0_27 vdout0_27ck95 = 1.8 time = 960
* CHECK dout0_28 vdout0_28ck95 = 1.8 time = 960
* CHECK dout0_29 vdout0_29ck95 = 0 time = 960
* CHECK dout0_30 vdout0_30ck95 = 1.8 time = 960
* CHECK dout0_31 vdout0_31ck95 = 0 time = 960
* CHECK dout0_0 vdout0_0ck96 = 0 time = 970
* CHECK dout0_1 vdout0_1ck96 = 0 time = 970
* CHECK dout0_2 vdout0_2ck96 = 1.8 time = 970
* CHECK dout0_3 vdout0_3ck96 = 0 time = 970
* CHECK dout0_4 vdout0_4ck96 = 0 time = 970
* CHECK dout0_5 vdout0_5ck96 = 0 time = 970
* CHECK dout0_6 vdout0_6ck96 = 1.8 time = 970
* CHECK dout0_7 vdout0_7ck96 = 0 time = 970
* CHECK dout0_8 vdout0_8ck96 = 0 time = 970
* CHECK dout0_9 vdout0_9ck96 = 1.8 time = 970
* CHECK dout0_10 vdout0_10ck96 = 0 time = 970
* CHECK dout0_11 vdout0_11ck96 = 0 time = 970
* CHECK dout0_12 vdout0_12ck96 = 1.8 time = 970
* CHECK dout0_13 vdout0_13ck96 = 1.8 time = 970
* CHECK dout0_14 vdout0_14ck96 = 0 time = 970
* CHECK dout0_15 vdout0_15ck96 = 0 time = 970
* CHECK dout0_16 vdout0_16ck96 = 1.8 time = 970
* CHECK dout0_17 vdout0_17ck96 = 1.8 time = 970
* CHECK dout0_18 vdout0_18ck96 = 0 time = 970
* CHECK dout0_19 vdout0_19ck96 = 1.8 time = 970
* CHECK dout0_20 vdout0_20ck96 = 1.8 time = 970
* CHECK dout0_21 vdout0_21ck96 = 0 time = 970
* CHECK dout0_22 vdout0_22ck96 = 0 time = 970
* CHECK dout0_23 vdout0_23ck96 = 0 time = 970
* CHECK dout0_24 vdout0_24ck96 = 1.8 time = 970
* CHECK dout0_25 vdout0_25ck96 = 1.8 time = 970
* CHECK dout0_26 vdout0_26ck96 = 1.8 time = 970
* CHECK dout0_27 vdout0_27ck96 = 1.8 time = 970
* CHECK dout0_28 vdout0_28ck96 = 1.8 time = 970
* CHECK dout0_29 vdout0_29ck96 = 1.8 time = 970
* CHECK dout0_30 vdout0_30ck96 = 0 time = 970
* CHECK dout0_31 vdout0_31ck96 = 0 time = 970
* CHECK dout1_0 vdout1_0ck96 = 0 time = 970
* CHECK dout1_1 vdout1_1ck96 = 1.8 time = 970
* CHECK dout1_2 vdout1_2ck96 = 1.8 time = 970
* CHECK dout1_3 vdout1_3ck96 = 1.8 time = 970
* CHECK dout1_4 vdout1_4ck96 = 1.8 time = 970
* CHECK dout1_5 vdout1_5ck96 = 1.8 time = 970
* CHECK dout1_6 vdout1_6ck96 = 0 time = 970
* CHECK dout1_7 vdout1_7ck96 = 1.8 time = 970
* CHECK dout1_8 vdout1_8ck96 = 1.8 time = 970
* CHECK dout1_9 vdout1_9ck96 = 0 time = 970
* CHECK dout1_10 vdout1_10ck96 = 0 time = 970
* CHECK dout1_11 vdout1_11ck96 = 1.8 time = 970
* CHECK dout1_12 vdout1_12ck96 = 0 time = 970
* CHECK dout1_13 vdout1_13ck96 = 1.8 time = 970
* CHECK dout1_14 vdout1_14ck96 = 0 time = 970
* CHECK dout1_15 vdout1_15ck96 = 1.8 time = 970
* CHECK dout1_16 vdout1_16ck96 = 1.8 time = 970
* CHECK dout1_17 vdout1_17ck96 = 0 time = 970
* CHECK dout1_18 vdout1_18ck96 = 0 time = 970
* CHECK dout1_19 vdout1_19ck96 = 0 time = 970
* CHECK dout1_20 vdout1_20ck96 = 1.8 time = 970
* CHECK dout1_21 vdout1_21ck96 = 1.8 time = 970
* CHECK dout1_22 vdout1_22ck96 = 1.8 time = 970
* CHECK dout1_23 vdout1_23ck96 = 0 time = 970
* CHECK dout1_24 vdout1_24ck96 = 0 time = 970
* CHECK dout1_25 vdout1_25ck96 = 0 time = 970
* CHECK dout1_26 vdout1_26ck96 = 0 time = 970
* CHECK dout1_27 vdout1_27ck96 = 1.8 time = 970
* CHECK dout1_28 vdout1_28ck96 = 1.8 time = 970
* CHECK dout1_29 vdout1_29ck96 = 0 time = 970
* CHECK dout1_30 vdout1_30ck96 = 1.8 time = 970
* CHECK dout1_31 vdout1_31ck96 = 0 time = 970
* CHECK dout1_0 vdout1_0ck97 = 0 time = 980
* CHECK dout1_1 vdout1_1ck97 = 1.8 time = 980
* CHECK dout1_2 vdout1_2ck97 = 1.8 time = 980
* CHECK dout1_3 vdout1_3ck97 = 1.8 time = 980
* CHECK dout1_4 vdout1_4ck97 = 1.8 time = 980
* CHECK dout1_5 vdout1_5ck97 = 1.8 time = 980
* CHECK dout1_6 vdout1_6ck97 = 0 time = 980
* CHECK dout1_7 vdout1_7ck97 = 1.8 time = 980
* CHECK dout1_8 vdout1_8ck97 = 1.8 time = 980
* CHECK dout1_9 vdout1_9ck97 = 0 time = 980
* CHECK dout1_10 vdout1_10ck97 = 0 time = 980
* CHECK dout1_11 vdout1_11ck97 = 1.8 time = 980
* CHECK dout1_12 vdout1_12ck97 = 0 time = 980
* CHECK dout1_13 vdout1_13ck97 = 1.8 time = 980
* CHECK dout1_14 vdout1_14ck97 = 0 time = 980
* CHECK dout1_15 vdout1_15ck97 = 1.8 time = 980
* CHECK dout1_16 vdout1_16ck97 = 1.8 time = 980
* CHECK dout1_17 vdout1_17ck97 = 0 time = 980
* CHECK dout1_18 vdout1_18ck97 = 0 time = 980
* CHECK dout1_19 vdout1_19ck97 = 0 time = 980
* CHECK dout1_20 vdout1_20ck97 = 1.8 time = 980
* CHECK dout1_21 vdout1_21ck97 = 1.8 time = 980
* CHECK dout1_22 vdout1_22ck97 = 1.8 time = 980
* CHECK dout1_23 vdout1_23ck97 = 0 time = 980
* CHECK dout1_24 vdout1_24ck97 = 0 time = 980
* CHECK dout1_25 vdout1_25ck97 = 0 time = 980
* CHECK dout1_26 vdout1_26ck97 = 0 time = 980
* CHECK dout1_27 vdout1_27ck97 = 1.8 time = 980
* CHECK dout1_28 vdout1_28ck97 = 1.8 time = 980
* CHECK dout1_29 vdout1_29ck97 = 0 time = 980
* CHECK dout1_30 vdout1_30ck97 = 1.8 time = 980
* CHECK dout1_31 vdout1_31ck97 = 0 time = 980
* CHECK dout1_0 vdout1_0ck99 = 0 time = 1000
* CHECK dout1_1 vdout1_1ck99 = 0 time = 1000
* CHECK dout1_2 vdout1_2ck99 = 1.8 time = 1000
* CHECK dout1_3 vdout1_3ck99 = 0 time = 1000
* CHECK dout1_4 vdout1_4ck99 = 0 time = 1000
* CHECK dout1_5 vdout1_5ck99 = 0 time = 1000
* CHECK dout1_6 vdout1_6ck99 = 1.8 time = 1000
* CHECK dout1_7 vdout1_7ck99 = 0 time = 1000
* CHECK dout1_8 vdout1_8ck99 = 0 time = 1000
* CHECK dout1_9 vdout1_9ck99 = 1.8 time = 1000
* CHECK dout1_10 vdout1_10ck99 = 0 time = 1000
* CHECK dout1_11 vdout1_11ck99 = 0 time = 1000
* CHECK dout1_12 vdout1_12ck99 = 1.8 time = 1000
* CHECK dout1_13 vdout1_13ck99 = 1.8 time = 1000
* CHECK dout1_14 vdout1_14ck99 = 0 time = 1000
* CHECK dout1_15 vdout1_15ck99 = 0 time = 1000
* CHECK dout1_16 vdout1_16ck99 = 1.8 time = 1000
* CHECK dout1_17 vdout1_17ck99 = 1.8 time = 1000
* CHECK dout1_18 vdout1_18ck99 = 0 time = 1000
* CHECK dout1_19 vdout1_19ck99 = 1.8 time = 1000
* CHECK dout1_20 vdout1_20ck99 = 1.8 time = 1000
* CHECK dout1_21 vdout1_21ck99 = 0 time = 1000
* CHECK dout1_22 vdout1_22ck99 = 0 time = 1000
* CHECK dout1_23 vdout1_23ck99 = 0 time = 1000
* CHECK dout1_24 vdout1_24ck99 = 1.8 time = 1000
* CHECK dout1_25 vdout1_25ck99 = 1.8 time = 1000
* CHECK dout1_26 vdout1_26ck99 = 1.8 time = 1000
* CHECK dout1_27 vdout1_27ck99 = 1.8 time = 1000
* CHECK dout1_28 vdout1_28ck99 = 1.8 time = 1000
* CHECK dout1_29 vdout1_29ck99 = 1.8 time = 1000
* CHECK dout1_30 vdout1_30ck99 = 0 time = 1000
* CHECK dout1_31 vdout1_31ck99 = 0 time = 1000
* CHECK dout0_0 vdout0_0ck101 = 0 time = 1020
* CHECK dout0_1 vdout0_1ck101 = 0 time = 1020
* CHECK dout0_2 vdout0_2ck101 = 1.8 time = 1020
* CHECK dout0_3 vdout0_3ck101 = 0 time = 1020
* CHECK dout0_4 vdout0_4ck101 = 0 time = 1020
* CHECK dout0_5 vdout0_5ck101 = 1.8 time = 1020
* CHECK dout0_6 vdout0_6ck101 = 0 time = 1020
* CHECK dout0_7 vdout0_7ck101 = 0 time = 1020
* CHECK dout0_8 vdout0_8ck101 = 1.8 time = 1020
* CHECK dout0_9 vdout0_9ck101 = 0 time = 1020
* CHECK dout0_10 vdout0_10ck101 = 1.8 time = 1020
* CHECK dout0_11 vdout0_11ck101 = 1.8 time = 1020
* CHECK dout0_12 vdout0_12ck101 = 1.8 time = 1020
* CHECK dout0_13 vdout0_13ck101 = 1.8 time = 1020
* CHECK dout0_14 vdout0_14ck101 = 1.8 time = 1020
* CHECK dout0_15 vdout0_15ck101 = 1.8 time = 1020
* CHECK dout0_16 vdout0_16ck101 = 0 time = 1020
* CHECK dout0_17 vdout0_17ck101 = 0 time = 1020
* CHECK dout0_18 vdout0_18ck101 = 1.8 time = 1020
* CHECK dout0_19 vdout0_19ck101 = 0 time = 1020
* CHECK dout0_20 vdout0_20ck101 = 1.8 time = 1020
* CHECK dout0_21 vdout0_21ck101 = 0 time = 1020
* CHECK dout0_22 vdout0_22ck101 = 1.8 time = 1020
* CHECK dout0_23 vdout0_23ck101 = 0 time = 1020
* CHECK dout0_24 vdout0_24ck101 = 0 time = 1020
* CHECK dout0_25 vdout0_25ck101 = 1.8 time = 1020
* CHECK dout0_26 vdout0_26ck101 = 1.8 time = 1020
* CHECK dout0_27 vdout0_27ck101 = 0 time = 1020
* CHECK dout0_28 vdout0_28ck101 = 0 time = 1020
* CHECK dout0_29 vdout0_29ck101 = 1.8 time = 1020
* CHECK dout0_30 vdout0_30ck101 = 0 time = 1020
* CHECK dout0_31 vdout0_31ck101 = 0 time = 1020
* CHECK dout0_0 vdout0_0ck103 = 0 time = 1040
* CHECK dout0_1 vdout0_1ck103 = 1.8 time = 1040
* CHECK dout0_2 vdout0_2ck103 = 1.8 time = 1040
* CHECK dout0_3 vdout0_3ck103 = 1.8 time = 1040
* CHECK dout0_4 vdout0_4ck103 = 0 time = 1040
* CHECK dout0_5 vdout0_5ck103 = 0 time = 1040
* CHECK dout0_6 vdout0_6ck103 = 0 time = 1040
* CHECK dout0_7 vdout0_7ck103 = 0 time = 1040
* CHECK dout0_8 vdout0_8ck103 = 0 time = 1040
* CHECK dout0_9 vdout0_9ck103 = 1.8 time = 1040
* CHECK dout0_10 vdout0_10ck103 = 0 time = 1040
* CHECK dout0_11 vdout0_11ck103 = 1.8 time = 1040
* CHECK dout0_12 vdout0_12ck103 = 0 time = 1040
* CHECK dout0_13 vdout0_13ck103 = 1.8 time = 1040
* CHECK dout0_14 vdout0_14ck103 = 0 time = 1040
* CHECK dout0_15 vdout0_15ck103 = 0 time = 1040
* CHECK dout0_16 vdout0_16ck103 = 0 time = 1040
* CHECK dout0_17 vdout0_17ck103 = 0 time = 1040
* CHECK dout0_18 vdout0_18ck103 = 1.8 time = 1040
* CHECK dout0_19 vdout0_19ck103 = 1.8 time = 1040
* CHECK dout0_20 vdout0_20ck103 = 1.8 time = 1040
* CHECK dout0_21 vdout0_21ck103 = 1.8 time = 1040
* CHECK dout0_22 vdout0_22ck103 = 0 time = 1040
* CHECK dout0_23 vdout0_23ck103 = 0 time = 1040
* CHECK dout0_24 vdout0_24ck103 = 1.8 time = 1040
* CHECK dout0_25 vdout0_25ck103 = 1.8 time = 1040
* CHECK dout0_26 vdout0_26ck103 = 1.8 time = 1040
* CHECK dout0_27 vdout0_27ck103 = 1.8 time = 1040
* CHECK dout0_28 vdout0_28ck103 = 0 time = 1040
* CHECK dout0_29 vdout0_29ck103 = 0 time = 1040
* CHECK dout0_30 vdout0_30ck103 = 1.8 time = 1040
* CHECK dout0_31 vdout0_31ck103 = 1.8 time = 1040
* CHECK dout1_0 vdout1_0ck103 = 0 time = 1040
* CHECK dout1_1 vdout1_1ck103 = 0 time = 1040
* CHECK dout1_2 vdout1_2ck103 = 1.8 time = 1040
* CHECK dout1_3 vdout1_3ck103 = 0 time = 1040
* CHECK dout1_4 vdout1_4ck103 = 0 time = 1040
* CHECK dout1_5 vdout1_5ck103 = 1.8 time = 1040
* CHECK dout1_6 vdout1_6ck103 = 0 time = 1040
* CHECK dout1_7 vdout1_7ck103 = 0 time = 1040
* CHECK dout1_8 vdout1_8ck103 = 1.8 time = 1040
* CHECK dout1_9 vdout1_9ck103 = 0 time = 1040
* CHECK dout1_10 vdout1_10ck103 = 1.8 time = 1040
* CHECK dout1_11 vdout1_11ck103 = 1.8 time = 1040
* CHECK dout1_12 vdout1_12ck103 = 1.8 time = 1040
* CHECK dout1_13 vdout1_13ck103 = 1.8 time = 1040
* CHECK dout1_14 vdout1_14ck103 = 1.8 time = 1040
* CHECK dout1_15 vdout1_15ck103 = 1.8 time = 1040
* CHECK dout1_16 vdout1_16ck103 = 0 time = 1040
* CHECK dout1_17 vdout1_17ck103 = 0 time = 1040
* CHECK dout1_18 vdout1_18ck103 = 1.8 time = 1040
* CHECK dout1_19 vdout1_19ck103 = 0 time = 1040
* CHECK dout1_20 vdout1_20ck103 = 1.8 time = 1040
* CHECK dout1_21 vdout1_21ck103 = 0 time = 1040
* CHECK dout1_22 vdout1_22ck103 = 1.8 time = 1040
* CHECK dout1_23 vdout1_23ck103 = 0 time = 1040
* CHECK dout1_24 vdout1_24ck103 = 0 time = 1040
* CHECK dout1_25 vdout1_25ck103 = 1.8 time = 1040
* CHECK dout1_26 vdout1_26ck103 = 1.8 time = 1040
* CHECK dout1_27 vdout1_27ck103 = 0 time = 1040
* CHECK dout1_28 vdout1_28ck103 = 0 time = 1040
* CHECK dout1_29 vdout1_29ck103 = 1.8 time = 1040
* CHECK dout1_30 vdout1_30ck103 = 0 time = 1040
* CHECK dout1_31 vdout1_31ck103 = 0 time = 1040
* CHECK dout0_0 vdout0_0ck105 = 0 time = 1060
* CHECK dout0_1 vdout0_1ck105 = 0 time = 1060
* CHECK dout0_2 vdout0_2ck105 = 1.8 time = 1060
* CHECK dout0_3 vdout0_3ck105 = 0 time = 1060
* CHECK dout0_4 vdout0_4ck105 = 0 time = 1060
* CHECK dout0_5 vdout0_5ck105 = 1.8 time = 1060
* CHECK dout0_6 vdout0_6ck105 = 0 time = 1060
* CHECK dout0_7 vdout0_7ck105 = 1.8 time = 1060
* CHECK dout0_8 vdout0_8ck105 = 1.8 time = 1060
* CHECK dout0_9 vdout0_9ck105 = 0 time = 1060
* CHECK dout0_10 vdout0_10ck105 = 1.8 time = 1060
* CHECK dout0_11 vdout0_11ck105 = 1.8 time = 1060
* CHECK dout0_12 vdout0_12ck105 = 0 time = 1060
* CHECK dout0_13 vdout0_13ck105 = 0 time = 1060
* CHECK dout0_14 vdout0_14ck105 = 1.8 time = 1060
* CHECK dout0_15 vdout0_15ck105 = 0 time = 1060
* CHECK dout0_16 vdout0_16ck105 = 0 time = 1060
* CHECK dout0_17 vdout0_17ck105 = 1.8 time = 1060
* CHECK dout0_18 vdout0_18ck105 = 1.8 time = 1060
* CHECK dout0_19 vdout0_19ck105 = 0 time = 1060
* CHECK dout0_20 vdout0_20ck105 = 0 time = 1060
* CHECK dout0_21 vdout0_21ck105 = 1.8 time = 1060
* CHECK dout0_22 vdout0_22ck105 = 0 time = 1060
* CHECK dout0_23 vdout0_23ck105 = 1.8 time = 1060
* CHECK dout0_24 vdout0_24ck105 = 0 time = 1060
* CHECK dout0_25 vdout0_25ck105 = 0 time = 1060
* CHECK dout0_26 vdout0_26ck105 = 0 time = 1060
* CHECK dout0_27 vdout0_27ck105 = 1.8 time = 1060
* CHECK dout0_28 vdout0_28ck105 = 1.8 time = 1060
* CHECK dout0_29 vdout0_29ck105 = 1.8 time = 1060
* CHECK dout0_30 vdout0_30ck105 = 1.8 time = 1060
* CHECK dout0_31 vdout0_31ck105 = 0 time = 1060
* CHECK dout1_0 vdout1_0ck106 = 0 time = 1070
* CHECK dout1_1 vdout1_1ck106 = 0 time = 1070
* CHECK dout1_2 vdout1_2ck106 = 1.8 time = 1070
* CHECK dout1_3 vdout1_3ck106 = 0 time = 1070
* CHECK dout1_4 vdout1_4ck106 = 0 time = 1070
* CHECK dout1_5 vdout1_5ck106 = 1.8 time = 1070
* CHECK dout1_6 vdout1_6ck106 = 0 time = 1070
* CHECK dout1_7 vdout1_7ck106 = 0 time = 1070
* CHECK dout1_8 vdout1_8ck106 = 1.8 time = 1070
* CHECK dout1_9 vdout1_9ck106 = 0 time = 1070
* CHECK dout1_10 vdout1_10ck106 = 1.8 time = 1070
* CHECK dout1_11 vdout1_11ck106 = 1.8 time = 1070
* CHECK dout1_12 vdout1_12ck106 = 1.8 time = 1070
* CHECK dout1_13 vdout1_13ck106 = 1.8 time = 1070
* CHECK dout1_14 vdout1_14ck106 = 1.8 time = 1070
* CHECK dout1_15 vdout1_15ck106 = 1.8 time = 1070
* CHECK dout1_16 vdout1_16ck106 = 0 time = 1070
* CHECK dout1_17 vdout1_17ck106 = 0 time = 1070
* CHECK dout1_18 vdout1_18ck106 = 1.8 time = 1070
* CHECK dout1_19 vdout1_19ck106 = 0 time = 1070
* CHECK dout1_20 vdout1_20ck106 = 1.8 time = 1070
* CHECK dout1_21 vdout1_21ck106 = 0 time = 1070
* CHECK dout1_22 vdout1_22ck106 = 1.8 time = 1070
* CHECK dout1_23 vdout1_23ck106 = 0 time = 1070
* CHECK dout1_24 vdout1_24ck106 = 0 time = 1070
* CHECK dout1_25 vdout1_25ck106 = 1.8 time = 1070
* CHECK dout1_26 vdout1_26ck106 = 1.8 time = 1070
* CHECK dout1_27 vdout1_27ck106 = 0 time = 1070
* CHECK dout1_28 vdout1_28ck106 = 0 time = 1070
* CHECK dout1_29 vdout1_29ck106 = 1.8 time = 1070
* CHECK dout1_30 vdout1_30ck106 = 0 time = 1070
* CHECK dout1_31 vdout1_31ck106 = 0 time = 1070
* CHECK dout0_0 vdout0_0ck107 = 0 time = 1080
* CHECK dout0_1 vdout0_1ck107 = 1.8 time = 1080
* CHECK dout0_2 vdout0_2ck107 = 0 time = 1080
* CHECK dout0_3 vdout0_3ck107 = 0 time = 1080
* CHECK dout0_4 vdout0_4ck107 = 1.8 time = 1080
* CHECK dout0_5 vdout0_5ck107 = 0 time = 1080
* CHECK dout0_6 vdout0_6ck107 = 0 time = 1080
* CHECK dout0_7 vdout0_7ck107 = 0 time = 1080
* CHECK dout0_8 vdout0_8ck107 = 0 time = 1080
* CHECK dout0_9 vdout0_9ck107 = 0 time = 1080
* CHECK dout0_10 vdout0_10ck107 = 0 time = 1080
* CHECK dout0_11 vdout0_11ck107 = 1.8 time = 1080
* CHECK dout0_12 vdout0_12ck107 = 0 time = 1080
* CHECK dout0_13 vdout0_13ck107 = 1.8 time = 1080
* CHECK dout0_14 vdout0_14ck107 = 1.8 time = 1080
* CHECK dout0_15 vdout0_15ck107 = 0 time = 1080
* CHECK dout0_16 vdout0_16ck107 = 0 time = 1080
* CHECK dout0_17 vdout0_17ck107 = 0 time = 1080
* CHECK dout0_18 vdout0_18ck107 = 0 time = 1080
* CHECK dout0_19 vdout0_19ck107 = 1.8 time = 1080
* CHECK dout0_20 vdout0_20ck107 = 1.8 time = 1080
* CHECK dout0_21 vdout0_21ck107 = 1.8 time = 1080
* CHECK dout0_22 vdout0_22ck107 = 1.8 time = 1080
* CHECK dout0_23 vdout0_23ck107 = 0 time = 1080
* CHECK dout0_24 vdout0_24ck107 = 0 time = 1080
* CHECK dout0_25 vdout0_25ck107 = 0 time = 1080
* CHECK dout0_26 vdout0_26ck107 = 0 time = 1080
* CHECK dout0_27 vdout0_27ck107 = 0 time = 1080
* CHECK dout0_28 vdout0_28ck107 = 0 time = 1080
* CHECK dout0_29 vdout0_29ck107 = 1.8 time = 1080
* CHECK dout0_30 vdout0_30ck107 = 1.8 time = 1080
* CHECK dout0_31 vdout0_31ck107 = 0 time = 1080
* CHECK dout1_0 vdout1_0ck107 = 0 time = 1080
* CHECK dout1_1 vdout1_1ck107 = 1.8 time = 1080
* CHECK dout1_2 vdout1_2ck107 = 0 time = 1080
* CHECK dout1_3 vdout1_3ck107 = 0 time = 1080
* CHECK dout1_4 vdout1_4ck107 = 1.8 time = 1080
* CHECK dout1_5 vdout1_5ck107 = 0 time = 1080
* CHECK dout1_6 vdout1_6ck107 = 0 time = 1080
* CHECK dout1_7 vdout1_7ck107 = 0 time = 1080
* CHECK dout1_8 vdout1_8ck107 = 0 time = 1080
* CHECK dout1_9 vdout1_9ck107 = 0 time = 1080
* CHECK dout1_10 vdout1_10ck107 = 0 time = 1080
* CHECK dout1_11 vdout1_11ck107 = 1.8 time = 1080
* CHECK dout1_12 vdout1_12ck107 = 0 time = 1080
* CHECK dout1_13 vdout1_13ck107 = 1.8 time = 1080
* CHECK dout1_14 vdout1_14ck107 = 1.8 time = 1080
* CHECK dout1_15 vdout1_15ck107 = 0 time = 1080
* CHECK dout1_16 vdout1_16ck107 = 0 time = 1080
* CHECK dout1_17 vdout1_17ck107 = 0 time = 1080
* CHECK dout1_18 vdout1_18ck107 = 0 time = 1080
* CHECK dout1_19 vdout1_19ck107 = 1.8 time = 1080
* CHECK dout1_20 vdout1_20ck107 = 1.8 time = 1080
* CHECK dout1_21 vdout1_21ck107 = 1.8 time = 1080
* CHECK dout1_22 vdout1_22ck107 = 1.8 time = 1080
* CHECK dout1_23 vdout1_23ck107 = 0 time = 1080
* CHECK dout1_24 vdout1_24ck107 = 0 time = 1080
* CHECK dout1_25 vdout1_25ck107 = 0 time = 1080
* CHECK dout1_26 vdout1_26ck107 = 0 time = 1080
* CHECK dout1_27 vdout1_27ck107 = 0 time = 1080
* CHECK dout1_28 vdout1_28ck107 = 0 time = 1080
* CHECK dout1_29 vdout1_29ck107 = 1.8 time = 1080
* CHECK dout1_30 vdout1_30ck107 = 1.8 time = 1080
* CHECK dout1_31 vdout1_31ck107 = 0 time = 1080
* CHECK dout0_0 vdout0_0ck108 = 0 time = 1090
* CHECK dout0_1 vdout0_1ck108 = 0 time = 1090
* CHECK dout0_2 vdout0_2ck108 = 1.8 time = 1090
* CHECK dout0_3 vdout0_3ck108 = 0 time = 1090
* CHECK dout0_4 vdout0_4ck108 = 0 time = 1090
* CHECK dout0_5 vdout0_5ck108 = 1.8 time = 1090
* CHECK dout0_6 vdout0_6ck108 = 0 time = 1090
* CHECK dout0_7 vdout0_7ck108 = 0 time = 1090
* CHECK dout0_8 vdout0_8ck108 = 1.8 time = 1090
* CHECK dout0_9 vdout0_9ck108 = 0 time = 1090
* CHECK dout0_10 vdout0_10ck108 = 1.8 time = 1090
* CHECK dout0_11 vdout0_11ck108 = 1.8 time = 1090
* CHECK dout0_12 vdout0_12ck108 = 1.8 time = 1090
* CHECK dout0_13 vdout0_13ck108 = 1.8 time = 1090
* CHECK dout0_14 vdout0_14ck108 = 1.8 time = 1090
* CHECK dout0_15 vdout0_15ck108 = 1.8 time = 1090
* CHECK dout0_16 vdout0_16ck108 = 0 time = 1090
* CHECK dout0_17 vdout0_17ck108 = 0 time = 1090
* CHECK dout0_18 vdout0_18ck108 = 1.8 time = 1090
* CHECK dout0_19 vdout0_19ck108 = 0 time = 1090
* CHECK dout0_20 vdout0_20ck108 = 1.8 time = 1090
* CHECK dout0_21 vdout0_21ck108 = 0 time = 1090
* CHECK dout0_22 vdout0_22ck108 = 1.8 time = 1090
* CHECK dout0_23 vdout0_23ck108 = 0 time = 1090
* CHECK dout0_24 vdout0_24ck108 = 0 time = 1090
* CHECK dout0_25 vdout0_25ck108 = 1.8 time = 1090
* CHECK dout0_26 vdout0_26ck108 = 1.8 time = 1090
* CHECK dout0_27 vdout0_27ck108 = 0 time = 1090
* CHECK dout0_28 vdout0_28ck108 = 0 time = 1090
* CHECK dout0_29 vdout0_29ck108 = 1.8 time = 1090
* CHECK dout0_30 vdout0_30ck108 = 0 time = 1090
* CHECK dout0_31 vdout0_31ck108 = 0 time = 1090
* CHECK dout1_0 vdout1_0ck108 = 0 time = 1090
* CHECK dout1_1 vdout1_1ck108 = 0 time = 1090
* CHECK dout1_2 vdout1_2ck108 = 1.8 time = 1090
* CHECK dout1_3 vdout1_3ck108 = 0 time = 1090
* CHECK dout1_4 vdout1_4ck108 = 0 time = 1090
* CHECK dout1_5 vdout1_5ck108 = 1.8 time = 1090
* CHECK dout1_6 vdout1_6ck108 = 0 time = 1090
* CHECK dout1_7 vdout1_7ck108 = 1.8 time = 1090
* CHECK dout1_8 vdout1_8ck108 = 1.8 time = 1090
* CHECK dout1_9 vdout1_9ck108 = 0 time = 1090
* CHECK dout1_10 vdout1_10ck108 = 1.8 time = 1090
* CHECK dout1_11 vdout1_11ck108 = 1.8 time = 1090
* CHECK dout1_12 vdout1_12ck108 = 0 time = 1090
* CHECK dout1_13 vdout1_13ck108 = 0 time = 1090
* CHECK dout1_14 vdout1_14ck108 = 1.8 time = 1090
* CHECK dout1_15 vdout1_15ck108 = 0 time = 1090
* CHECK dout1_16 vdout1_16ck108 = 0 time = 1090
* CHECK dout1_17 vdout1_17ck108 = 1.8 time = 1090
* CHECK dout1_18 vdout1_18ck108 = 1.8 time = 1090
* CHECK dout1_19 vdout1_19ck108 = 0 time = 1090
* CHECK dout1_20 vdout1_20ck108 = 0 time = 1090
* CHECK dout1_21 vdout1_21ck108 = 1.8 time = 1090
* CHECK dout1_22 vdout1_22ck108 = 0 time = 1090
* CHECK dout1_23 vdout1_23ck108 = 1.8 time = 1090
* CHECK dout1_24 vdout1_24ck108 = 0 time = 1090
* CHECK dout1_25 vdout1_25ck108 = 0 time = 1090
* CHECK dout1_26 vdout1_26ck108 = 0 time = 1090
* CHECK dout1_27 vdout1_27ck108 = 1.8 time = 1090
* CHECK dout1_28 vdout1_28ck108 = 1.8 time = 1090
* CHECK dout1_29 vdout1_29ck108 = 1.8 time = 1090
* CHECK dout1_30 vdout1_30ck108 = 1.8 time = 1090
* CHECK dout1_31 vdout1_31ck108 = 0 time = 1090
* CHECK dout0_0 vdout0_0ck109 = 0 time = 1100
* CHECK dout0_1 vdout0_1ck109 = 0 time = 1100
* CHECK dout0_2 vdout0_2ck109 = 1.8 time = 1100
* CHECK dout0_3 vdout0_3ck109 = 0 time = 1100
* CHECK dout0_4 vdout0_4ck109 = 0 time = 1100
* CHECK dout0_5 vdout0_5ck109 = 1.8 time = 1100
* CHECK dout0_6 vdout0_6ck109 = 0 time = 1100
* CHECK dout0_7 vdout0_7ck109 = 1.8 time = 1100
* CHECK dout0_8 vdout0_8ck109 = 1.8 time = 1100
* CHECK dout0_9 vdout0_9ck109 = 0 time = 1100
* CHECK dout0_10 vdout0_10ck109 = 1.8 time = 1100
* CHECK dout0_11 vdout0_11ck109 = 1.8 time = 1100
* CHECK dout0_12 vdout0_12ck109 = 0 time = 1100
* CHECK dout0_13 vdout0_13ck109 = 0 time = 1100
* CHECK dout0_14 vdout0_14ck109 = 1.8 time = 1100
* CHECK dout0_15 vdout0_15ck109 = 0 time = 1100
* CHECK dout0_16 vdout0_16ck109 = 0 time = 1100
* CHECK dout0_17 vdout0_17ck109 = 1.8 time = 1100
* CHECK dout0_18 vdout0_18ck109 = 1.8 time = 1100
* CHECK dout0_19 vdout0_19ck109 = 0 time = 1100
* CHECK dout0_20 vdout0_20ck109 = 0 time = 1100
* CHECK dout0_21 vdout0_21ck109 = 1.8 time = 1100
* CHECK dout0_22 vdout0_22ck109 = 0 time = 1100
* CHECK dout0_23 vdout0_23ck109 = 1.8 time = 1100
* CHECK dout0_24 vdout0_24ck109 = 0 time = 1100
* CHECK dout0_25 vdout0_25ck109 = 0 time = 1100
* CHECK dout0_26 vdout0_26ck109 = 0 time = 1100
* CHECK dout0_27 vdout0_27ck109 = 1.8 time = 1100
* CHECK dout0_28 vdout0_28ck109 = 1.8 time = 1100
* CHECK dout0_29 vdout0_29ck109 = 1.8 time = 1100
* CHECK dout0_30 vdout0_30ck109 = 1.8 time = 1100
* CHECK dout0_31 vdout0_31ck109 = 0 time = 1100
* CHECK dout1_0 vdout1_0ck110 = 0 time = 1110
* CHECK dout1_1 vdout1_1ck110 = 0 time = 1110
* CHECK dout1_2 vdout1_2ck110 = 1.8 time = 1110
* CHECK dout1_3 vdout1_3ck110 = 0 time = 1110
* CHECK dout1_4 vdout1_4ck110 = 0 time = 1110
* CHECK dout1_5 vdout1_5ck110 = 1.8 time = 1110
* CHECK dout1_6 vdout1_6ck110 = 0 time = 1110
* CHECK dout1_7 vdout1_7ck110 = 1.8 time = 1110
* CHECK dout1_8 vdout1_8ck110 = 1.8 time = 1110
* CHECK dout1_9 vdout1_9ck110 = 0 time = 1110
* CHECK dout1_10 vdout1_10ck110 = 1.8 time = 1110
* CHECK dout1_11 vdout1_11ck110 = 1.8 time = 1110
* CHECK dout1_12 vdout1_12ck110 = 0 time = 1110
* CHECK dout1_13 vdout1_13ck110 = 0 time = 1110
* CHECK dout1_14 vdout1_14ck110 = 1.8 time = 1110
* CHECK dout1_15 vdout1_15ck110 = 0 time = 1110
* CHECK dout1_16 vdout1_16ck110 = 0 time = 1110
* CHECK dout1_17 vdout1_17ck110 = 1.8 time = 1110
* CHECK dout1_18 vdout1_18ck110 = 1.8 time = 1110
* CHECK dout1_19 vdout1_19ck110 = 0 time = 1110
* CHECK dout1_20 vdout1_20ck110 = 0 time = 1110
* CHECK dout1_21 vdout1_21ck110 = 1.8 time = 1110
* CHECK dout1_22 vdout1_22ck110 = 0 time = 1110
* CHECK dout1_23 vdout1_23ck110 = 1.8 time = 1110
* CHECK dout1_24 vdout1_24ck110 = 0 time = 1110
* CHECK dout1_25 vdout1_25ck110 = 0 time = 1110
* CHECK dout1_26 vdout1_26ck110 = 0 time = 1110
* CHECK dout1_27 vdout1_27ck110 = 1.8 time = 1110
* CHECK dout1_28 vdout1_28ck110 = 1.8 time = 1110
* CHECK dout1_29 vdout1_29ck110 = 1.8 time = 1110
* CHECK dout1_30 vdout1_30ck110 = 1.8 time = 1110
* CHECK dout1_31 vdout1_31ck110 = 0 time = 1110
* CHECK dout0_0 vdout0_0ck111 = 0 time = 1120
* CHECK dout0_1 vdout0_1ck111 = 0 time = 1120
* CHECK dout0_2 vdout0_2ck111 = 1.8 time = 1120
* CHECK dout0_3 vdout0_3ck111 = 0 time = 1120
* CHECK dout0_4 vdout0_4ck111 = 0 time = 1120
* CHECK dout0_5 vdout0_5ck111 = 1.8 time = 1120
* CHECK dout0_6 vdout0_6ck111 = 0 time = 1120
* CHECK dout0_7 vdout0_7ck111 = 0 time = 1120
* CHECK dout0_8 vdout0_8ck111 = 1.8 time = 1120
* CHECK dout0_9 vdout0_9ck111 = 0 time = 1120
* CHECK dout0_10 vdout0_10ck111 = 1.8 time = 1120
* CHECK dout0_11 vdout0_11ck111 = 1.8 time = 1120
* CHECK dout0_12 vdout0_12ck111 = 1.8 time = 1120
* CHECK dout0_13 vdout0_13ck111 = 1.8 time = 1120
* CHECK dout0_14 vdout0_14ck111 = 1.8 time = 1120
* CHECK dout0_15 vdout0_15ck111 = 1.8 time = 1120
* CHECK dout0_16 vdout0_16ck111 = 0 time = 1120
* CHECK dout0_17 vdout0_17ck111 = 0 time = 1120
* CHECK dout0_18 vdout0_18ck111 = 1.8 time = 1120
* CHECK dout0_19 vdout0_19ck111 = 0 time = 1120
* CHECK dout0_20 vdout0_20ck111 = 1.8 time = 1120
* CHECK dout0_21 vdout0_21ck111 = 0 time = 1120
* CHECK dout0_22 vdout0_22ck111 = 1.8 time = 1120
* CHECK dout0_23 vdout0_23ck111 = 0 time = 1120
* CHECK dout0_24 vdout0_24ck111 = 0 time = 1120
* CHECK dout0_25 vdout0_25ck111 = 1.8 time = 1120
* CHECK dout0_26 vdout0_26ck111 = 1.8 time = 1120
* CHECK dout0_27 vdout0_27ck111 = 0 time = 1120
* CHECK dout0_28 vdout0_28ck111 = 0 time = 1120
* CHECK dout0_29 vdout0_29ck111 = 1.8 time = 1120
* CHECK dout0_30 vdout0_30ck111 = 0 time = 1120
* CHECK dout0_31 vdout0_31ck111 = 0 time = 1120
* CHECK dout1_0 vdout1_0ck111 = 0 time = 1120
* CHECK dout1_1 vdout1_1ck111 = 0 time = 1120
* CHECK dout1_2 vdout1_2ck111 = 1.8 time = 1120
* CHECK dout1_3 vdout1_3ck111 = 0 time = 1120
* CHECK dout1_4 vdout1_4ck111 = 0 time = 1120
* CHECK dout1_5 vdout1_5ck111 = 1.8 time = 1120
* CHECK dout1_6 vdout1_6ck111 = 0 time = 1120
* CHECK dout1_7 vdout1_7ck111 = 1.8 time = 1120
* CHECK dout1_8 vdout1_8ck111 = 1.8 time = 1120
* CHECK dout1_9 vdout1_9ck111 = 0 time = 1120
* CHECK dout1_10 vdout1_10ck111 = 1.8 time = 1120
* CHECK dout1_11 vdout1_11ck111 = 1.8 time = 1120
* CHECK dout1_12 vdout1_12ck111 = 0 time = 1120
* CHECK dout1_13 vdout1_13ck111 = 0 time = 1120
* CHECK dout1_14 vdout1_14ck111 = 1.8 time = 1120
* CHECK dout1_15 vdout1_15ck111 = 0 time = 1120
* CHECK dout1_16 vdout1_16ck111 = 0 time = 1120
* CHECK dout1_17 vdout1_17ck111 = 1.8 time = 1120
* CHECK dout1_18 vdout1_18ck111 = 1.8 time = 1120
* CHECK dout1_19 vdout1_19ck111 = 0 time = 1120
* CHECK dout1_20 vdout1_20ck111 = 0 time = 1120
* CHECK dout1_21 vdout1_21ck111 = 1.8 time = 1120
* CHECK dout1_22 vdout1_22ck111 = 0 time = 1120
* CHECK dout1_23 vdout1_23ck111 = 1.8 time = 1120
* CHECK dout1_24 vdout1_24ck111 = 0 time = 1120
* CHECK dout1_25 vdout1_25ck111 = 0 time = 1120
* CHECK dout1_26 vdout1_26ck111 = 0 time = 1120
* CHECK dout1_27 vdout1_27ck111 = 1.8 time = 1120
* CHECK dout1_28 vdout1_28ck111 = 1.8 time = 1120
* CHECK dout1_29 vdout1_29ck111 = 1.8 time = 1120
* CHECK dout1_30 vdout1_30ck111 = 1.8 time = 1120
* CHECK dout1_31 vdout1_31ck111 = 0 time = 1120
* CHECK dout0_0 vdout0_0ck114 = 1.8 time = 1150
* CHECK dout0_1 vdout0_1ck114 = 1.8 time = 1150
* CHECK dout0_2 vdout0_2ck114 = 1.8 time = 1150
* CHECK dout0_3 vdout0_3ck114 = 0 time = 1150
* CHECK dout0_4 vdout0_4ck114 = 1.8 time = 1150
* CHECK dout0_5 vdout0_5ck114 = 1.8 time = 1150
* CHECK dout0_6 vdout0_6ck114 = 1.8 time = 1150
* CHECK dout0_7 vdout0_7ck114 = 0 time = 1150
* CHECK dout0_8 vdout0_8ck114 = 1.8 time = 1150
* CHECK dout0_9 vdout0_9ck114 = 0 time = 1150
* CHECK dout0_10 vdout0_10ck114 = 1.8 time = 1150
* CHECK dout0_11 vdout0_11ck114 = 0 time = 1150
* CHECK dout0_12 vdout0_12ck114 = 0 time = 1150
* CHECK dout0_13 vdout0_13ck114 = 0 time = 1150
* CHECK dout0_14 vdout0_14ck114 = 1.8 time = 1150
* CHECK dout0_15 vdout0_15ck114 = 0 time = 1150
* CHECK dout0_16 vdout0_16ck114 = 0 time = 1150
* CHECK dout0_17 vdout0_17ck114 = 1.8 time = 1150
* CHECK dout0_18 vdout0_18ck114 = 1.8 time = 1150
* CHECK dout0_19 vdout0_19ck114 = 1.8 time = 1150
* CHECK dout0_20 vdout0_20ck114 = 0 time = 1150
* CHECK dout0_21 vdout0_21ck114 = 1.8 time = 1150
* CHECK dout0_22 vdout0_22ck114 = 0 time = 1150
* CHECK dout0_23 vdout0_23ck114 = 0 time = 1150
* CHECK dout0_24 vdout0_24ck114 = 1.8 time = 1150
* CHECK dout0_25 vdout0_25ck114 = 0 time = 1150
* CHECK dout0_26 vdout0_26ck114 = 1.8 time = 1150
* CHECK dout0_27 vdout0_27ck114 = 1.8 time = 1150
* CHECK dout0_28 vdout0_28ck114 = 0 time = 1150
* CHECK dout0_29 vdout0_29ck114 = 1.8 time = 1150
* CHECK dout0_30 vdout0_30ck114 = 1.8 time = 1150
* CHECK dout0_31 vdout0_31ck114 = 0 time = 1150
* CHECK dout1_0 vdout1_0ck115 = 1.8 time = 1160
* CHECK dout1_1 vdout1_1ck115 = 0 time = 1160
* CHECK dout1_2 vdout1_2ck115 = 1.8 time = 1160
* CHECK dout1_3 vdout1_3ck115 = 1.8 time = 1160
* CHECK dout1_4 vdout1_4ck115 = 1.8 time = 1160
* CHECK dout1_5 vdout1_5ck115 = 0 time = 1160
* CHECK dout1_6 vdout1_6ck115 = 1.8 time = 1160
* CHECK dout1_7 vdout1_7ck115 = 1.8 time = 1160
* CHECK dout1_8 vdout1_8ck115 = 1.8 time = 1160
* CHECK dout1_9 vdout1_9ck115 = 1.8 time = 1160
* CHECK dout1_10 vdout1_10ck115 = 0 time = 1160
* CHECK dout1_11 vdout1_11ck115 = 1.8 time = 1160
* CHECK dout1_12 vdout1_12ck115 = 0 time = 1160
* CHECK dout1_13 vdout1_13ck115 = 1.8 time = 1160
* CHECK dout1_14 vdout1_14ck115 = 0 time = 1160
* CHECK dout1_15 vdout1_15ck115 = 0 time = 1160
* CHECK dout1_16 vdout1_16ck115 = 1.8 time = 1160
* CHECK dout1_17 vdout1_17ck115 = 0 time = 1160
* CHECK dout1_18 vdout1_18ck115 = 1.8 time = 1160
* CHECK dout1_19 vdout1_19ck115 = 1.8 time = 1160
* CHECK dout1_20 vdout1_20ck115 = 1.8 time = 1160
* CHECK dout1_21 vdout1_21ck115 = 0 time = 1160
* CHECK dout1_22 vdout1_22ck115 = 1.8 time = 1160
* CHECK dout1_23 vdout1_23ck115 = 0 time = 1160
* CHECK dout1_24 vdout1_24ck115 = 0 time = 1160
* CHECK dout1_25 vdout1_25ck115 = 0 time = 1160
* CHECK dout1_26 vdout1_26ck115 = 0 time = 1160
* CHECK dout1_27 vdout1_27ck115 = 1.8 time = 1160
* CHECK dout1_28 vdout1_28ck115 = 1.8 time = 1160
* CHECK dout1_29 vdout1_29ck115 = 1.8 time = 1160
* CHECK dout1_30 vdout1_30ck115 = 0 time = 1160
* CHECK dout1_31 vdout1_31ck115 = 0 time = 1160
* CHECK dout0_0 vdout0_0ck116 = 1.8 time = 1170
* CHECK dout0_1 vdout0_1ck116 = 1.8 time = 1170
* CHECK dout0_2 vdout0_2ck116 = 1.8 time = 1170
* CHECK dout0_3 vdout0_3ck116 = 1.8 time = 1170
* CHECK dout0_4 vdout0_4ck116 = 1.8 time = 1170
* CHECK dout0_5 vdout0_5ck116 = 0 time = 1170
* CHECK dout0_6 vdout0_6ck116 = 1.8 time = 1170
* CHECK dout0_7 vdout0_7ck116 = 0 time = 1170
* CHECK dout0_8 vdout0_8ck116 = 0 time = 1170
* CHECK dout0_9 vdout0_9ck116 = 0 time = 1170
* CHECK dout0_10 vdout0_10ck116 = 1.8 time = 1170
* CHECK dout0_11 vdout0_11ck116 = 0 time = 1170
* CHECK dout0_12 vdout0_12ck116 = 0 time = 1170
* CHECK dout0_13 vdout0_13ck116 = 0 time = 1170
* CHECK dout0_14 vdout0_14ck116 = 1.8 time = 1170
* CHECK dout0_15 vdout0_15ck116 = 0 time = 1170
* CHECK dout0_16 vdout0_16ck116 = 0 time = 1170
* CHECK dout0_17 vdout0_17ck116 = 1.8 time = 1170
* CHECK dout0_18 vdout0_18ck116 = 1.8 time = 1170
* CHECK dout0_19 vdout0_19ck116 = 1.8 time = 1170
* CHECK dout0_20 vdout0_20ck116 = 0 time = 1170
* CHECK dout0_21 vdout0_21ck116 = 1.8 time = 1170
* CHECK dout0_22 vdout0_22ck116 = 1.8 time = 1170
* CHECK dout0_23 vdout0_23ck116 = 0 time = 1170
* CHECK dout0_24 vdout0_24ck116 = 0 time = 1170
* CHECK dout0_25 vdout0_25ck116 = 1.8 time = 1170
* CHECK dout0_26 vdout0_26ck116 = 1.8 time = 1170
* CHECK dout0_27 vdout0_27ck116 = 1.8 time = 1170
* CHECK dout0_28 vdout0_28ck116 = 1.8 time = 1170
* CHECK dout0_29 vdout0_29ck116 = 0 time = 1170
* CHECK dout0_30 vdout0_30ck116 = 0 time = 1170
* CHECK dout0_31 vdout0_31ck116 = 0 time = 1170
* CHECK dout1_0 vdout1_0ck116 = 1.8 time = 1170
* CHECK dout1_1 vdout1_1ck116 = 1.8 time = 1170
* CHECK dout1_2 vdout1_2ck116 = 1.8 time = 1170
* CHECK dout1_3 vdout1_3ck116 = 1.8 time = 1170
* CHECK dout1_4 vdout1_4ck116 = 1.8 time = 1170
* CHECK dout1_5 vdout1_5ck116 = 0 time = 1170
* CHECK dout1_6 vdout1_6ck116 = 1.8 time = 1170
* CHECK dout1_7 vdout1_7ck116 = 0 time = 1170
* CHECK dout1_8 vdout1_8ck116 = 0 time = 1170
* CHECK dout1_9 vdout1_9ck116 = 0 time = 1170
* CHECK dout1_10 vdout1_10ck116 = 1.8 time = 1170
* CHECK dout1_11 vdout1_11ck116 = 0 time = 1170
* CHECK dout1_12 vdout1_12ck116 = 0 time = 1170
* CHECK dout1_13 vdout1_13ck116 = 0 time = 1170
* CHECK dout1_14 vdout1_14ck116 = 1.8 time = 1170
* CHECK dout1_15 vdout1_15ck116 = 0 time = 1170
* CHECK dout1_16 vdout1_16ck116 = 0 time = 1170
* CHECK dout1_17 vdout1_17ck116 = 1.8 time = 1170
* CHECK dout1_18 vdout1_18ck116 = 1.8 time = 1170
* CHECK dout1_19 vdout1_19ck116 = 1.8 time = 1170
* CHECK dout1_20 vdout1_20ck116 = 0 time = 1170
* CHECK dout1_21 vdout1_21ck116 = 1.8 time = 1170
* CHECK dout1_22 vdout1_22ck116 = 1.8 time = 1170
* CHECK dout1_23 vdout1_23ck116 = 0 time = 1170
* CHECK dout1_24 vdout1_24ck116 = 0 time = 1170
* CHECK dout1_25 vdout1_25ck116 = 1.8 time = 1170
* CHECK dout1_26 vdout1_26ck116 = 1.8 time = 1170
* CHECK dout1_27 vdout1_27ck116 = 1.8 time = 1170
* CHECK dout1_28 vdout1_28ck116 = 1.8 time = 1170
* CHECK dout1_29 vdout1_29ck116 = 0 time = 1170
* CHECK dout1_30 vdout1_30ck116 = 0 time = 1170
* CHECK dout1_31 vdout1_31ck116 = 0 time = 1170
* CHECK dout0_0 vdout0_0ck117 = 1.8 time = 1180
* CHECK dout0_1 vdout0_1ck117 = 0 time = 1180
* CHECK dout0_2 vdout0_2ck117 = 1.8 time = 1180
* CHECK dout0_3 vdout0_3ck117 = 1.8 time = 1180
* CHECK dout0_4 vdout0_4ck117 = 1.8 time = 1180
* CHECK dout0_5 vdout0_5ck117 = 0 time = 1180
* CHECK dout0_6 vdout0_6ck117 = 1.8 time = 1180
* CHECK dout0_7 vdout0_7ck117 = 1.8 time = 1180
* CHECK dout0_8 vdout0_8ck117 = 1.8 time = 1180
* CHECK dout0_9 vdout0_9ck117 = 1.8 time = 1180
* CHECK dout0_10 vdout0_10ck117 = 0 time = 1180
* CHECK dout0_11 vdout0_11ck117 = 1.8 time = 1180
* CHECK dout0_12 vdout0_12ck117 = 0 time = 1180
* CHECK dout0_13 vdout0_13ck117 = 1.8 time = 1180
* CHECK dout0_14 vdout0_14ck117 = 0 time = 1180
* CHECK dout0_15 vdout0_15ck117 = 0 time = 1180
* CHECK dout0_16 vdout0_16ck117 = 1.8 time = 1180
* CHECK dout0_17 vdout0_17ck117 = 0 time = 1180
* CHECK dout0_18 vdout0_18ck117 = 1.8 time = 1180
* CHECK dout0_19 vdout0_19ck117 = 1.8 time = 1180
* CHECK dout0_20 vdout0_20ck117 = 1.8 time = 1180
* CHECK dout0_21 vdout0_21ck117 = 0 time = 1180
* CHECK dout0_22 vdout0_22ck117 = 1.8 time = 1180
* CHECK dout0_23 vdout0_23ck117 = 0 time = 1180
* CHECK dout0_24 vdout0_24ck117 = 0 time = 1180
* CHECK dout0_25 vdout0_25ck117 = 0 time = 1180
* CHECK dout0_26 vdout0_26ck117 = 0 time = 1180
* CHECK dout0_27 vdout0_27ck117 = 1.8 time = 1180
* CHECK dout0_28 vdout0_28ck117 = 1.8 time = 1180
* CHECK dout0_29 vdout0_29ck117 = 1.8 time = 1180
* CHECK dout0_30 vdout0_30ck117 = 0 time = 1180
* CHECK dout0_31 vdout0_31ck117 = 0 time = 1180
* CHECK dout1_0 vdout1_0ck117 = 1.8 time = 1180
* CHECK dout1_1 vdout1_1ck117 = 0 time = 1180
* CHECK dout1_2 vdout1_2ck117 = 1.8 time = 1180
* CHECK dout1_3 vdout1_3ck117 = 0 time = 1180
* CHECK dout1_4 vdout1_4ck117 = 0 time = 1180
* CHECK dout1_5 vdout1_5ck117 = 1.8 time = 1180
* CHECK dout1_6 vdout1_6ck117 = 1.8 time = 1180
* CHECK dout1_7 vdout1_7ck117 = 0 time = 1180
* CHECK dout1_8 vdout1_8ck117 = 0 time = 1180
* CHECK dout1_9 vdout1_9ck117 = 1.8 time = 1180
* CHECK dout1_10 vdout1_10ck117 = 0 time = 1180
* CHECK dout1_11 vdout1_11ck117 = 0 time = 1180
* CHECK dout1_12 vdout1_12ck117 = 0 time = 1180
* CHECK dout1_13 vdout1_13ck117 = 0 time = 1180
* CHECK dout1_14 vdout1_14ck117 = 0 time = 1180
* CHECK dout1_15 vdout1_15ck117 = 0 time = 1180
* CHECK dout1_16 vdout1_16ck117 = 1.8 time = 1180
* CHECK dout1_17 vdout1_17ck117 = 0 time = 1180
* CHECK dout1_18 vdout1_18ck117 = 1.8 time = 1180
* CHECK dout1_19 vdout1_19ck117 = 1.8 time = 1180
* CHECK dout1_20 vdout1_20ck117 = 1.8 time = 1180
* CHECK dout1_21 vdout1_21ck117 = 1.8 time = 1180
* CHECK dout1_22 vdout1_22ck117 = 1.8 time = 1180
* CHECK dout1_23 vdout1_23ck117 = 1.8 time = 1180
* CHECK dout1_24 vdout1_24ck117 = 1.8 time = 1180
* CHECK dout1_25 vdout1_25ck117 = 1.8 time = 1180
* CHECK dout1_26 vdout1_26ck117 = 1.8 time = 1180
* CHECK dout1_27 vdout1_27ck117 = 0 time = 1180
* CHECK dout1_28 vdout1_28ck117 = 0 time = 1180
* CHECK dout1_29 vdout1_29ck117 = 0 time = 1180
* CHECK dout1_30 vdout1_30ck117 = 0 time = 1180
* CHECK dout1_31 vdout1_31ck117 = 0 time = 1180
* CHECK dout0_0 vdout0_0ck118 = 1.8 time = 1190
* CHECK dout0_1 vdout0_1ck118 = 1.8 time = 1190
* CHECK dout0_2 vdout0_2ck118 = 1.8 time = 1190
* CHECK dout0_3 vdout0_3ck118 = 1.8 time = 1190
* CHECK dout0_4 vdout0_4ck118 = 1.8 time = 1190
* CHECK dout0_5 vdout0_5ck118 = 0 time = 1190
* CHECK dout0_6 vdout0_6ck118 = 1.8 time = 1190
* CHECK dout0_7 vdout0_7ck118 = 0 time = 1190
* CHECK dout0_8 vdout0_8ck118 = 0 time = 1190
* CHECK dout0_9 vdout0_9ck118 = 0 time = 1190
* CHECK dout0_10 vdout0_10ck118 = 1.8 time = 1190
* CHECK dout0_11 vdout0_11ck118 = 0 time = 1190
* CHECK dout0_12 vdout0_12ck118 = 0 time = 1190
* CHECK dout0_13 vdout0_13ck118 = 0 time = 1190
* CHECK dout0_14 vdout0_14ck118 = 1.8 time = 1190
* CHECK dout0_15 vdout0_15ck118 = 0 time = 1190
* CHECK dout0_16 vdout0_16ck118 = 0 time = 1190
* CHECK dout0_17 vdout0_17ck118 = 1.8 time = 1190
* CHECK dout0_18 vdout0_18ck118 = 1.8 time = 1190
* CHECK dout0_19 vdout0_19ck118 = 1.8 time = 1190
* CHECK dout0_20 vdout0_20ck118 = 0 time = 1190
* CHECK dout0_21 vdout0_21ck118 = 1.8 time = 1190
* CHECK dout0_22 vdout0_22ck118 = 1.8 time = 1190
* CHECK dout0_23 vdout0_23ck118 = 0 time = 1190
* CHECK dout0_24 vdout0_24ck118 = 0 time = 1190
* CHECK dout0_25 vdout0_25ck118 = 1.8 time = 1190
* CHECK dout0_26 vdout0_26ck118 = 1.8 time = 1190
* CHECK dout0_27 vdout0_27ck118 = 1.8 time = 1190
* CHECK dout0_28 vdout0_28ck118 = 1.8 time = 1190
* CHECK dout0_29 vdout0_29ck118 = 0 time = 1190
* CHECK dout0_30 vdout0_30ck118 = 0 time = 1190
* CHECK dout0_31 vdout0_31ck118 = 0 time = 1190
* CHECK dout0_0 vdout0_0ck119 = 1.8 time = 1200
* CHECK dout0_1 vdout0_1ck119 = 0 time = 1200
* CHECK dout0_2 vdout0_2ck119 = 1.8 time = 1200
* CHECK dout0_3 vdout0_3ck119 = 0 time = 1200
* CHECK dout0_4 vdout0_4ck119 = 0 time = 1200
* CHECK dout0_5 vdout0_5ck119 = 1.8 time = 1200
* CHECK dout0_6 vdout0_6ck119 = 1.8 time = 1200
* CHECK dout0_7 vdout0_7ck119 = 0 time = 1200
* CHECK dout0_8 vdout0_8ck119 = 0 time = 1200
* CHECK dout0_9 vdout0_9ck119 = 1.8 time = 1200
* CHECK dout0_10 vdout0_10ck119 = 0 time = 1200
* CHECK dout0_11 vdout0_11ck119 = 0 time = 1200
* CHECK dout0_12 vdout0_12ck119 = 0 time = 1200
* CHECK dout0_13 vdout0_13ck119 = 0 time = 1200
* CHECK dout0_14 vdout0_14ck119 = 0 time = 1200
* CHECK dout0_15 vdout0_15ck119 = 0 time = 1200
* CHECK dout0_16 vdout0_16ck119 = 1.8 time = 1200
* CHECK dout0_17 vdout0_17ck119 = 0 time = 1200
* CHECK dout0_18 vdout0_18ck119 = 1.8 time = 1200
* CHECK dout0_19 vdout0_19ck119 = 1.8 time = 1200
* CHECK dout0_20 vdout0_20ck119 = 1.8 time = 1200
* CHECK dout0_21 vdout0_21ck119 = 1.8 time = 1200
* CHECK dout0_22 vdout0_22ck119 = 1.8 time = 1200
* CHECK dout0_23 vdout0_23ck119 = 1.8 time = 1200
* CHECK dout0_24 vdout0_24ck119 = 1.8 time = 1200
* CHECK dout0_25 vdout0_25ck119 = 1.8 time = 1200
* CHECK dout0_26 vdout0_26ck119 = 1.8 time = 1200
* CHECK dout0_27 vdout0_27ck119 = 0 time = 1200
* CHECK dout0_28 vdout0_28ck119 = 0 time = 1200
* CHECK dout0_29 vdout0_29ck119 = 0 time = 1200
* CHECK dout0_30 vdout0_30ck119 = 0 time = 1200
* CHECK dout0_31 vdout0_31ck119 = 0 time = 1200
* CHECK dout1_0 vdout1_0ck119 = 1.8 time = 1200
* CHECK dout1_1 vdout1_1ck119 = 1.8 time = 1200
* CHECK dout1_2 vdout1_2ck119 = 1.8 time = 1200
* CHECK dout1_3 vdout1_3ck119 = 0 time = 1200
* CHECK dout1_4 vdout1_4ck119 = 1.8 time = 1200
* CHECK dout1_5 vdout1_5ck119 = 1.8 time = 1200
* CHECK dout1_6 vdout1_6ck119 = 1.8 time = 1200
* CHECK dout1_7 vdout1_7ck119 = 0 time = 1200
* CHECK dout1_8 vdout1_8ck119 = 1.8 time = 1200
* CHECK dout1_9 vdout1_9ck119 = 0 time = 1200
* CHECK dout1_10 vdout1_10ck119 = 1.8 time = 1200
* CHECK dout1_11 vdout1_11ck119 = 0 time = 1200
* CHECK dout1_12 vdout1_12ck119 = 0 time = 1200
* CHECK dout1_13 vdout1_13ck119 = 0 time = 1200
* CHECK dout1_14 vdout1_14ck119 = 1.8 time = 1200
* CHECK dout1_15 vdout1_15ck119 = 0 time = 1200
* CHECK dout1_16 vdout1_16ck119 = 0 time = 1200
* CHECK dout1_17 vdout1_17ck119 = 1.8 time = 1200
* CHECK dout1_18 vdout1_18ck119 = 1.8 time = 1200
* CHECK dout1_19 vdout1_19ck119 = 1.8 time = 1200
* CHECK dout1_20 vdout1_20ck119 = 0 time = 1200
* CHECK dout1_21 vdout1_21ck119 = 1.8 time = 1200
* CHECK dout1_22 vdout1_22ck119 = 0 time = 1200
* CHECK dout1_23 vdout1_23ck119 = 0 time = 1200
* CHECK dout1_24 vdout1_24ck119 = 1.8 time = 1200
* CHECK dout1_25 vdout1_25ck119 = 0 time = 1200
* CHECK dout1_26 vdout1_26ck119 = 1.8 time = 1200
* CHECK dout1_27 vdout1_27ck119 = 1.8 time = 1200
* CHECK dout1_28 vdout1_28ck119 = 0 time = 1200
* CHECK dout1_29 vdout1_29ck119 = 1.8 time = 1200
* CHECK dout1_30 vdout1_30ck119 = 1.8 time = 1200
* CHECK dout1_31 vdout1_31ck119 = 0 time = 1200
* CHECK dout0_0 vdout0_0ck120 = 1.8 time = 1210
* CHECK dout0_1 vdout0_1ck120 = 1.8 time = 1210
* CHECK dout0_2 vdout0_2ck120 = 1.8 time = 1210
* CHECK dout0_3 vdout0_3ck120 = 1.8 time = 1210
* CHECK dout0_4 vdout0_4ck120 = 1.8 time = 1210
* CHECK dout0_5 vdout0_5ck120 = 0 time = 1210
* CHECK dout0_6 vdout0_6ck120 = 1.8 time = 1210
* CHECK dout0_7 vdout0_7ck120 = 0 time = 1210
* CHECK dout0_8 vdout0_8ck120 = 0 time = 1210
* CHECK dout0_9 vdout0_9ck120 = 0 time = 1210
* CHECK dout0_10 vdout0_10ck120 = 1.8 time = 1210
* CHECK dout0_11 vdout0_11ck120 = 0 time = 1210
* CHECK dout0_12 vdout0_12ck120 = 0 time = 1210
* CHECK dout0_13 vdout0_13ck120 = 0 time = 1210
* CHECK dout0_14 vdout0_14ck120 = 1.8 time = 1210
* CHECK dout0_15 vdout0_15ck120 = 0 time = 1210
* CHECK dout0_16 vdout0_16ck120 = 0 time = 1210
* CHECK dout0_17 vdout0_17ck120 = 1.8 time = 1210
* CHECK dout0_18 vdout0_18ck120 = 1.8 time = 1210
* CHECK dout0_19 vdout0_19ck120 = 1.8 time = 1210
* CHECK dout0_20 vdout0_20ck120 = 0 time = 1210
* CHECK dout0_21 vdout0_21ck120 = 1.8 time = 1210
* CHECK dout0_22 vdout0_22ck120 = 1.8 time = 1210
* CHECK dout0_23 vdout0_23ck120 = 0 time = 1210
* CHECK dout0_24 vdout0_24ck120 = 0 time = 1210
* CHECK dout0_25 vdout0_25ck120 = 1.8 time = 1210
* CHECK dout0_26 vdout0_26ck120 = 1.8 time = 1210
* CHECK dout0_27 vdout0_27ck120 = 1.8 time = 1210
* CHECK dout0_28 vdout0_28ck120 = 1.8 time = 1210
* CHECK dout0_29 vdout0_29ck120 = 0 time = 1210
* CHECK dout0_30 vdout0_30ck120 = 0 time = 1210
* CHECK dout0_31 vdout0_31ck120 = 0 time = 1210
* CHECK dout1_0 vdout1_0ck122 = 0 time = 1230
* CHECK dout1_1 vdout1_1ck122 = 1.8 time = 1230
* CHECK dout1_2 vdout1_2ck122 = 1.8 time = 1230
* CHECK dout1_3 vdout1_3ck122 = 1.8 time = 1230
* CHECK dout1_4 vdout1_4ck122 = 0 time = 1230
* CHECK dout1_5 vdout1_5ck122 = 0 time = 1230
* CHECK dout1_6 vdout1_6ck122 = 1.8 time = 1230
* CHECK dout1_7 vdout1_7ck122 = 1.8 time = 1230
* CHECK dout1_8 vdout1_8ck122 = 1.8 time = 1230
* CHECK dout1_9 vdout1_9ck122 = 1.8 time = 1230
* CHECK dout1_10 vdout1_10ck122 = 1.8 time = 1230
* CHECK dout1_11 vdout1_11ck122 = 0 time = 1230
* CHECK dout1_12 vdout1_12ck122 = 0 time = 1230
* CHECK dout1_13 vdout1_13ck122 = 0 time = 1230
* CHECK dout1_14 vdout1_14ck122 = 0 time = 1230
* CHECK dout1_15 vdout1_15ck122 = 0 time = 1230
* CHECK dout1_16 vdout1_16ck122 = 1.8 time = 1230
* CHECK dout1_17 vdout1_17ck122 = 0 time = 1230
* CHECK dout1_18 vdout1_18ck122 = 1.8 time = 1230
* CHECK dout1_19 vdout1_19ck122 = 1.8 time = 1230
* CHECK dout1_20 vdout1_20ck122 = 1.8 time = 1230
* CHECK dout1_21 vdout1_21ck122 = 0 time = 1230
* CHECK dout1_22 vdout1_22ck122 = 1.8 time = 1230
* CHECK dout1_23 vdout1_23ck122 = 0 time = 1230
* CHECK dout1_24 vdout1_24ck122 = 0 time = 1230
* CHECK dout1_25 vdout1_25ck122 = 0 time = 1230
* CHECK dout1_26 vdout1_26ck122 = 0 time = 1230
* CHECK dout1_27 vdout1_27ck122 = 1.8 time = 1230
* CHECK dout1_28 vdout1_28ck122 = 1.8 time = 1230
* CHECK dout1_29 vdout1_29ck122 = 1.8 time = 1230
* CHECK dout1_30 vdout1_30ck122 = 0 time = 1230
* CHECK dout1_31 vdout1_31ck122 = 0 time = 1230
* CHECK dout1_0 vdout1_0ck123 = 0 time = 1240
* CHECK dout1_1 vdout1_1ck123 = 1.8 time = 1240
* CHECK dout1_2 vdout1_2ck123 = 1.8 time = 1240
* CHECK dout1_3 vdout1_3ck123 = 1.8 time = 1240
* CHECK dout1_4 vdout1_4ck123 = 0 time = 1240
* CHECK dout1_5 vdout1_5ck123 = 0 time = 1240
* CHECK dout1_6 vdout1_6ck123 = 1.8 time = 1240
* CHECK dout1_7 vdout1_7ck123 = 1.8 time = 1240
* CHECK dout1_8 vdout1_8ck123 = 1.8 time = 1240
* CHECK dout1_9 vdout1_9ck123 = 1.8 time = 1240
* CHECK dout1_10 vdout1_10ck123 = 1.8 time = 1240
* CHECK dout1_11 vdout1_11ck123 = 0 time = 1240
* CHECK dout1_12 vdout1_12ck123 = 0 time = 1240
* CHECK dout1_13 vdout1_13ck123 = 0 time = 1240
* CHECK dout1_14 vdout1_14ck123 = 0 time = 1240
* CHECK dout1_15 vdout1_15ck123 = 0 time = 1240
* CHECK dout1_16 vdout1_16ck123 = 1.8 time = 1240
* CHECK dout1_17 vdout1_17ck123 = 0 time = 1240
* CHECK dout1_18 vdout1_18ck123 = 1.8 time = 1240
* CHECK dout1_19 vdout1_19ck123 = 1.8 time = 1240
* CHECK dout1_20 vdout1_20ck123 = 1.8 time = 1240
* CHECK dout1_21 vdout1_21ck123 = 0 time = 1240
* CHECK dout1_22 vdout1_22ck123 = 1.8 time = 1240
* CHECK dout1_23 vdout1_23ck123 = 0 time = 1240
* CHECK dout1_24 vdout1_24ck123 = 0 time = 1240
* CHECK dout1_25 vdout1_25ck123 = 0 time = 1240
* CHECK dout1_26 vdout1_26ck123 = 0 time = 1240
* CHECK dout1_27 vdout1_27ck123 = 1.8 time = 1240
* CHECK dout1_28 vdout1_28ck123 = 1.8 time = 1240
* CHECK dout1_29 vdout1_29ck123 = 1.8 time = 1240
* CHECK dout1_30 vdout1_30ck123 = 0 time = 1240
* CHECK dout1_31 vdout1_31ck123 = 0 time = 1240
* CHECK dout1_0 vdout1_0ck124 = 1.8 time = 1250
* CHECK dout1_1 vdout1_1ck124 = 0 time = 1250
* CHECK dout1_2 vdout1_2ck124 = 1.8 time = 1250
* CHECK dout1_3 vdout1_3ck124 = 0 time = 1250
* CHECK dout1_4 vdout1_4ck124 = 0 time = 1250
* CHECK dout1_5 vdout1_5ck124 = 1.8 time = 1250
* CHECK dout1_6 vdout1_6ck124 = 1.8 time = 1250
* CHECK dout1_7 vdout1_7ck124 = 0 time = 1250
* CHECK dout1_8 vdout1_8ck124 = 0 time = 1250
* CHECK dout1_9 vdout1_9ck124 = 1.8 time = 1250
* CHECK dout1_10 vdout1_10ck124 = 0 time = 1250
* CHECK dout1_11 vdout1_11ck124 = 0 time = 1250
* CHECK dout1_12 vdout1_12ck124 = 0 time = 1250
* CHECK dout1_13 vdout1_13ck124 = 0 time = 1250
* CHECK dout1_14 vdout1_14ck124 = 0 time = 1250
* CHECK dout1_15 vdout1_15ck124 = 0 time = 1250
* CHECK dout1_16 vdout1_16ck124 = 1.8 time = 1250
* CHECK dout1_17 vdout1_17ck124 = 0 time = 1250
* CHECK dout1_18 vdout1_18ck124 = 1.8 time = 1250
* CHECK dout1_19 vdout1_19ck124 = 1.8 time = 1250
* CHECK dout1_20 vdout1_20ck124 = 1.8 time = 1250
* CHECK dout1_21 vdout1_21ck124 = 1.8 time = 1250
* CHECK dout1_22 vdout1_22ck124 = 1.8 time = 1250
* CHECK dout1_23 vdout1_23ck124 = 1.8 time = 1250
* CHECK dout1_24 vdout1_24ck124 = 1.8 time = 1250
* CHECK dout1_25 vdout1_25ck124 = 1.8 time = 1250
* CHECK dout1_26 vdout1_26ck124 = 1.8 time = 1250
* CHECK dout1_27 vdout1_27ck124 = 0 time = 1250
* CHECK dout1_28 vdout1_28ck124 = 0 time = 1250
* CHECK dout1_29 vdout1_29ck124 = 0 time = 1250
* CHECK dout1_30 vdout1_30ck124 = 0 time = 1250
* CHECK dout1_31 vdout1_31ck124 = 0 time = 1250
* CHECK dout1_0 vdout1_0ck125 = 0 time = 1260
* CHECK dout1_1 vdout1_1ck125 = 1.8 time = 1260
* CHECK dout1_2 vdout1_2ck125 = 1.8 time = 1260
* CHECK dout1_3 vdout1_3ck125 = 1.8 time = 1260
* CHECK dout1_4 vdout1_4ck125 = 0 time = 1260
* CHECK dout1_5 vdout1_5ck125 = 0 time = 1260
* CHECK dout1_6 vdout1_6ck125 = 1.8 time = 1260
* CHECK dout1_7 vdout1_7ck125 = 1.8 time = 1260
* CHECK dout1_8 vdout1_8ck125 = 1.8 time = 1260
* CHECK dout1_9 vdout1_9ck125 = 1.8 time = 1260
* CHECK dout1_10 vdout1_10ck125 = 1.8 time = 1260
* CHECK dout1_11 vdout1_11ck125 = 0 time = 1260
* CHECK dout1_12 vdout1_12ck125 = 0 time = 1260
* CHECK dout1_13 vdout1_13ck125 = 0 time = 1260
* CHECK dout1_14 vdout1_14ck125 = 0 time = 1260
* CHECK dout1_15 vdout1_15ck125 = 0 time = 1260
* CHECK dout1_16 vdout1_16ck125 = 1.8 time = 1260
* CHECK dout1_17 vdout1_17ck125 = 0 time = 1260
* CHECK dout1_18 vdout1_18ck125 = 1.8 time = 1260
* CHECK dout1_19 vdout1_19ck125 = 1.8 time = 1260
* CHECK dout1_20 vdout1_20ck125 = 1.8 time = 1260
* CHECK dout1_21 vdout1_21ck125 = 0 time = 1260
* CHECK dout1_22 vdout1_22ck125 = 1.8 time = 1260
* CHECK dout1_23 vdout1_23ck125 = 0 time = 1260
* CHECK dout1_24 vdout1_24ck125 = 0 time = 1260
* CHECK dout1_25 vdout1_25ck125 = 0 time = 1260
* CHECK dout1_26 vdout1_26ck125 = 0 time = 1260
* CHECK dout1_27 vdout1_27ck125 = 1.8 time = 1260
* CHECK dout1_28 vdout1_28ck125 = 1.8 time = 1260
* CHECK dout1_29 vdout1_29ck125 = 1.8 time = 1260
* CHECK dout1_30 vdout1_30ck125 = 0 time = 1260
* CHECK dout1_31 vdout1_31ck125 = 0 time = 1260
* CHECK dout1_0 vdout1_0ck127 = 1.8 time = 1280
* CHECK dout1_1 vdout1_1ck127 = 0 time = 1280
* CHECK dout1_2 vdout1_2ck127 = 0 time = 1280
* CHECK dout1_3 vdout1_3ck127 = 1.8 time = 1280
* CHECK dout1_4 vdout1_4ck127 = 0 time = 1280
* CHECK dout1_5 vdout1_5ck127 = 0 time = 1280
* CHECK dout1_6 vdout1_6ck127 = 1.8 time = 1280
* CHECK dout1_7 vdout1_7ck127 = 0 time = 1280
* CHECK dout1_8 vdout1_8ck127 = 0 time = 1280
* CHECK dout1_9 vdout1_9ck127 = 0 time = 1280
* CHECK dout1_10 vdout1_10ck127 = 0 time = 1280
* CHECK dout1_11 vdout1_11ck127 = 1.8 time = 1280
* CHECK dout1_12 vdout1_12ck127 = 0 time = 1280
* CHECK dout1_13 vdout1_13ck127 = 1.8 time = 1280
* CHECK dout1_14 vdout1_14ck127 = 1.8 time = 1280
* CHECK dout1_15 vdout1_15ck127 = 1.8 time = 1280
* CHECK dout1_16 vdout1_16ck127 = 0 time = 1280
* CHECK dout1_17 vdout1_17ck127 = 1.8 time = 1280
* CHECK dout1_18 vdout1_18ck127 = 1.8 time = 1280
* CHECK dout1_19 vdout1_19ck127 = 1.8 time = 1280
* CHECK dout1_20 vdout1_20ck127 = 0 time = 1280
* CHECK dout1_21 vdout1_21ck127 = 0 time = 1280
* CHECK dout1_22 vdout1_22ck127 = 0 time = 1280
* CHECK dout1_23 vdout1_23ck127 = 1.8 time = 1280
* CHECK dout1_24 vdout1_24ck127 = 1.8 time = 1280
* CHECK dout1_25 vdout1_25ck127 = 0 time = 1280
* CHECK dout1_26 vdout1_26ck127 = 0 time = 1280
* CHECK dout1_27 vdout1_27ck127 = 0 time = 1280
* CHECK dout1_28 vdout1_28ck127 = 0 time = 1280
* CHECK dout1_29 vdout1_29ck127 = 0 time = 1280
* CHECK dout1_30 vdout1_30ck127 = 1.8 time = 1280
* CHECK dout1_31 vdout1_31ck127 = 0 time = 1280
* CHECK dout0_0 vdout0_0ck129 = 1.8 time = 1300
* CHECK dout0_1 vdout0_1ck129 = 0 time = 1300
* CHECK dout0_2 vdout0_2ck129 = 1.8 time = 1300
* CHECK dout0_3 vdout0_3ck129 = 0 time = 1300
* CHECK dout0_4 vdout0_4ck129 = 0 time = 1300
* CHECK dout0_5 vdout0_5ck129 = 1.8 time = 1300
* CHECK dout0_6 vdout0_6ck129 = 1.8 time = 1300
* CHECK dout0_7 vdout0_7ck129 = 0 time = 1300
* CHECK dout0_8 vdout0_8ck129 = 0 time = 1300
* CHECK dout0_9 vdout0_9ck129 = 1.8 time = 1300
* CHECK dout0_10 vdout0_10ck129 = 0 time = 1300
* CHECK dout0_11 vdout0_11ck129 = 0 time = 1300
* CHECK dout0_12 vdout0_12ck129 = 0 time = 1300
* CHECK dout0_13 vdout0_13ck129 = 0 time = 1300
* CHECK dout0_14 vdout0_14ck129 = 0 time = 1300
* CHECK dout0_15 vdout0_15ck129 = 0 time = 1300
* CHECK dout0_16 vdout0_16ck129 = 1.8 time = 1300
* CHECK dout0_17 vdout0_17ck129 = 0 time = 1300
* CHECK dout0_18 vdout0_18ck129 = 1.8 time = 1300
* CHECK dout0_19 vdout0_19ck129 = 1.8 time = 1300
* CHECK dout0_20 vdout0_20ck129 = 1.8 time = 1300
* CHECK dout0_21 vdout0_21ck129 = 1.8 time = 1300
* CHECK dout0_22 vdout0_22ck129 = 1.8 time = 1300
* CHECK dout0_23 vdout0_23ck129 = 1.8 time = 1300
* CHECK dout0_24 vdout0_24ck129 = 1.8 time = 1300
* CHECK dout0_25 vdout0_25ck129 = 1.8 time = 1300
* CHECK dout0_26 vdout0_26ck129 = 1.8 time = 1300
* CHECK dout0_27 vdout0_27ck129 = 0 time = 1300
* CHECK dout0_28 vdout0_28ck129 = 0 time = 1300
* CHECK dout0_29 vdout0_29ck129 = 0 time = 1300
* CHECK dout0_30 vdout0_30ck129 = 0 time = 1300
* CHECK dout0_31 vdout0_31ck129 = 0 time = 1300
* CHECK dout0_0 vdout0_0ck132 = 1.8 time = 1330
* CHECK dout0_1 vdout0_1ck132 = 0 time = 1330
* CHECK dout0_2 vdout0_2ck132 = 0 time = 1330
* CHECK dout0_3 vdout0_3ck132 = 1.8 time = 1330
* CHECK dout0_4 vdout0_4ck132 = 0 time = 1330
* CHECK dout0_5 vdout0_5ck132 = 0 time = 1330
* CHECK dout0_6 vdout0_6ck132 = 1.8 time = 1330
* CHECK dout0_7 vdout0_7ck132 = 0 time = 1330
* CHECK dout0_8 vdout0_8ck132 = 0 time = 1330
* CHECK dout0_9 vdout0_9ck132 = 0 time = 1330
* CHECK dout0_10 vdout0_10ck132 = 0 time = 1330
* CHECK dout0_11 vdout0_11ck132 = 1.8 time = 1330
* CHECK dout0_12 vdout0_12ck132 = 0 time = 1330
* CHECK dout0_13 vdout0_13ck132 = 1.8 time = 1330
* CHECK dout0_14 vdout0_14ck132 = 1.8 time = 1330
* CHECK dout0_15 vdout0_15ck132 = 1.8 time = 1330
* CHECK dout0_16 vdout0_16ck132 = 0 time = 1330
* CHECK dout0_17 vdout0_17ck132 = 1.8 time = 1330
* CHECK dout0_18 vdout0_18ck132 = 1.8 time = 1330
* CHECK dout0_19 vdout0_19ck132 = 1.8 time = 1330
* CHECK dout0_20 vdout0_20ck132 = 0 time = 1330
* CHECK dout0_21 vdout0_21ck132 = 0 time = 1330
* CHECK dout0_22 vdout0_22ck132 = 0 time = 1330
* CHECK dout0_23 vdout0_23ck132 = 1.8 time = 1330
* CHECK dout0_24 vdout0_24ck132 = 1.8 time = 1330
* CHECK dout0_25 vdout0_25ck132 = 0 time = 1330
* CHECK dout0_26 vdout0_26ck132 = 0 time = 1330
* CHECK dout0_27 vdout0_27ck132 = 0 time = 1330
* CHECK dout0_28 vdout0_28ck132 = 0 time = 1330
* CHECK dout0_29 vdout0_29ck132 = 0 time = 1330
* CHECK dout0_30 vdout0_30ck132 = 1.8 time = 1330
* CHECK dout0_31 vdout0_31ck132 = 0 time = 1330
* CHECK dout1_0 vdout1_0ck132 = 1.8 time = 1330
* CHECK dout1_1 vdout1_1ck132 = 0 time = 1330
* CHECK dout1_2 vdout1_2ck132 = 1.8 time = 1330
* CHECK dout1_3 vdout1_3ck132 = 0 time = 1330
* CHECK dout1_4 vdout1_4ck132 = 0 time = 1330
* CHECK dout1_5 vdout1_5ck132 = 1.8 time = 1330
* CHECK dout1_6 vdout1_6ck132 = 1.8 time = 1330
* CHECK dout1_7 vdout1_7ck132 = 0 time = 1330
* CHECK dout1_8 vdout1_8ck132 = 0 time = 1330
* CHECK dout1_9 vdout1_9ck132 = 1.8 time = 1330
* CHECK dout1_10 vdout1_10ck132 = 0 time = 1330
* CHECK dout1_11 vdout1_11ck132 = 0 time = 1330
* CHECK dout1_12 vdout1_12ck132 = 0 time = 1330
* CHECK dout1_13 vdout1_13ck132 = 0 time = 1330
* CHECK dout1_14 vdout1_14ck132 = 0 time = 1330
* CHECK dout1_15 vdout1_15ck132 = 0 time = 1330
* CHECK dout1_16 vdout1_16ck132 = 1.8 time = 1330
* CHECK dout1_17 vdout1_17ck132 = 0 time = 1330
* CHECK dout1_18 vdout1_18ck132 = 1.8 time = 1330
* CHECK dout1_19 vdout1_19ck132 = 1.8 time = 1330
* CHECK dout1_20 vdout1_20ck132 = 1.8 time = 1330
* CHECK dout1_21 vdout1_21ck132 = 1.8 time = 1330
* CHECK dout1_22 vdout1_22ck132 = 1.8 time = 1330
* CHECK dout1_23 vdout1_23ck132 = 1.8 time = 1330
* CHECK dout1_24 vdout1_24ck132 = 1.8 time = 1330
* CHECK dout1_25 vdout1_25ck132 = 1.8 time = 1330
* CHECK dout1_26 vdout1_26ck132 = 1.8 time = 1330
* CHECK dout1_27 vdout1_27ck132 = 0 time = 1330
* CHECK dout1_28 vdout1_28ck132 = 0 time = 1330
* CHECK dout1_29 vdout1_29ck132 = 0 time = 1330
* CHECK dout1_30 vdout1_30ck132 = 0 time = 1330
* CHECK dout1_31 vdout1_31ck132 = 0 time = 1330
* CHECK dout0_0 vdout0_0ck133 = 1.8 time = 1340
* CHECK dout0_1 vdout0_1ck133 = 0 time = 1340
* CHECK dout0_2 vdout0_2ck133 = 1.8 time = 1340
* CHECK dout0_3 vdout0_3ck133 = 1.8 time = 1340
* CHECK dout0_4 vdout0_4ck133 = 0 time = 1340
* CHECK dout0_5 vdout0_5ck133 = 1.8 time = 1340
* CHECK dout0_6 vdout0_6ck133 = 1.8 time = 1340
* CHECK dout0_7 vdout0_7ck133 = 0 time = 1340
* CHECK dout0_8 vdout0_8ck133 = 1.8 time = 1340
* CHECK dout0_9 vdout0_9ck133 = 0 time = 1340
* CHECK dout0_10 vdout0_10ck133 = 0 time = 1340
* CHECK dout0_11 vdout0_11ck133 = 1.8 time = 1340
* CHECK dout0_12 vdout0_12ck133 = 0 time = 1340
* CHECK dout0_13 vdout0_13ck133 = 1.8 time = 1340
* CHECK dout0_14 vdout0_14ck133 = 1.8 time = 1340
* CHECK dout0_15 vdout0_15ck133 = 1.8 time = 1340
* CHECK dout0_16 vdout0_16ck133 = 1.8 time = 1340
* CHECK dout0_17 vdout0_17ck133 = 1.8 time = 1340
* CHECK dout0_18 vdout0_18ck133 = 0 time = 1340
* CHECK dout0_19 vdout0_19ck133 = 1.8 time = 1340
* CHECK dout0_20 vdout0_20ck133 = 1.8 time = 1340
* CHECK dout0_21 vdout0_21ck133 = 1.8 time = 1340
* CHECK dout0_22 vdout0_22ck133 = 0 time = 1340
* CHECK dout0_23 vdout0_23ck133 = 1.8 time = 1340
* CHECK dout0_24 vdout0_24ck133 = 1.8 time = 1340
* CHECK dout0_25 vdout0_25ck133 = 1.8 time = 1340
* CHECK dout0_26 vdout0_26ck133 = 1.8 time = 1340
* CHECK dout0_27 vdout0_27ck133 = 0 time = 1340
* CHECK dout0_28 vdout0_28ck133 = 1.8 time = 1340
* CHECK dout0_29 vdout0_29ck133 = 1.8 time = 1340
* CHECK dout0_30 vdout0_30ck133 = 1.8 time = 1340
* CHECK dout0_31 vdout0_31ck133 = 1.8 time = 1340
* CHECK dout1_0 vdout1_0ck133 = 1.8 time = 1340
* CHECK dout1_1 vdout1_1ck133 = 0 time = 1340
* CHECK dout1_2 vdout1_2ck133 = 0 time = 1340
* CHECK dout1_3 vdout1_3ck133 = 1.8 time = 1340
* CHECK dout1_4 vdout1_4ck133 = 0 time = 1340
* CHECK dout1_5 vdout1_5ck133 = 0 time = 1340
* CHECK dout1_6 vdout1_6ck133 = 1.8 time = 1340
* CHECK dout1_7 vdout1_7ck133 = 0 time = 1340
* CHECK dout1_8 vdout1_8ck133 = 0 time = 1340
* CHECK dout1_9 vdout1_9ck133 = 0 time = 1340
* CHECK dout1_10 vdout1_10ck133 = 0 time = 1340
* CHECK dout1_11 vdout1_11ck133 = 1.8 time = 1340
* CHECK dout1_12 vdout1_12ck133 = 0 time = 1340
* CHECK dout1_13 vdout1_13ck133 = 1.8 time = 1340
* CHECK dout1_14 vdout1_14ck133 = 1.8 time = 1340
* CHECK dout1_15 vdout1_15ck133 = 1.8 time = 1340
* CHECK dout1_16 vdout1_16ck133 = 0 time = 1340
* CHECK dout1_17 vdout1_17ck133 = 1.8 time = 1340
* CHECK dout1_18 vdout1_18ck133 = 1.8 time = 1340
* CHECK dout1_19 vdout1_19ck133 = 1.8 time = 1340
* CHECK dout1_20 vdout1_20ck133 = 0 time = 1340
* CHECK dout1_21 vdout1_21ck133 = 0 time = 1340
* CHECK dout1_22 vdout1_22ck133 = 0 time = 1340
* CHECK dout1_23 vdout1_23ck133 = 1.8 time = 1340
* CHECK dout1_24 vdout1_24ck133 = 1.8 time = 1340
* CHECK dout1_25 vdout1_25ck133 = 0 time = 1340
* CHECK dout1_26 vdout1_26ck133 = 0 time = 1340
* CHECK dout1_27 vdout1_27ck133 = 0 time = 1340
* CHECK dout1_28 vdout1_28ck133 = 0 time = 1340
* CHECK dout1_29 vdout1_29ck133 = 0 time = 1340
* CHECK dout1_30 vdout1_30ck133 = 1.8 time = 1340
* CHECK dout1_31 vdout1_31ck133 = 0 time = 1340
* CHECK dout0_0 vdout0_0ck136 = 1.8 time = 1370
* CHECK dout0_1 vdout0_1ck136 = 0 time = 1370
* CHECK dout0_2 vdout0_2ck136 = 0 time = 1370
* CHECK dout0_3 vdout0_3ck136 = 1.8 time = 1370
* CHECK dout0_4 vdout0_4ck136 = 0 time = 1370
* CHECK dout0_5 vdout0_5ck136 = 0 time = 1370
* CHECK dout0_6 vdout0_6ck136 = 1.8 time = 1370
* CHECK dout0_7 vdout0_7ck136 = 0 time = 1370
* CHECK dout0_8 vdout0_8ck136 = 0 time = 1370
* CHECK dout0_9 vdout0_9ck136 = 0 time = 1370
* CHECK dout0_10 vdout0_10ck136 = 0 time = 1370
* CHECK dout0_11 vdout0_11ck136 = 1.8 time = 1370
* CHECK dout0_12 vdout0_12ck136 = 0 time = 1370
* CHECK dout0_13 vdout0_13ck136 = 1.8 time = 1370
* CHECK dout0_14 vdout0_14ck136 = 1.8 time = 1370
* CHECK dout0_15 vdout0_15ck136 = 1.8 time = 1370
* CHECK dout0_16 vdout0_16ck136 = 0 time = 1370
* CHECK dout0_17 vdout0_17ck136 = 1.8 time = 1370
* CHECK dout0_18 vdout0_18ck136 = 1.8 time = 1370
* CHECK dout0_19 vdout0_19ck136 = 1.8 time = 1370
* CHECK dout0_20 vdout0_20ck136 = 0 time = 1370
* CHECK dout0_21 vdout0_21ck136 = 0 time = 1370
* CHECK dout0_22 vdout0_22ck136 = 0 time = 1370
* CHECK dout0_23 vdout0_23ck136 = 1.8 time = 1370
* CHECK dout0_24 vdout0_24ck136 = 1.8 time = 1370
* CHECK dout0_25 vdout0_25ck136 = 0 time = 1370
* CHECK dout0_26 vdout0_26ck136 = 0 time = 1370
* CHECK dout0_27 vdout0_27ck136 = 0 time = 1370
* CHECK dout0_28 vdout0_28ck136 = 0 time = 1370
* CHECK dout0_29 vdout0_29ck136 = 0 time = 1370
* CHECK dout0_30 vdout0_30ck136 = 1.8 time = 1370
* CHECK dout0_31 vdout0_31ck136 = 0 time = 1370
* CHECK dout1_0 vdout1_0ck136 = 1.8 time = 1370
* CHECK dout1_1 vdout1_1ck136 = 0 time = 1370
* CHECK dout1_2 vdout1_2ck136 = 0 time = 1370
* CHECK dout1_3 vdout1_3ck136 = 0 time = 1370
* CHECK dout1_4 vdout1_4ck136 = 1.8 time = 1370
* CHECK dout1_5 vdout1_5ck136 = 1.8 time = 1370
* CHECK dout1_6 vdout1_6ck136 = 1.8 time = 1370
* CHECK dout1_7 vdout1_7ck136 = 0 time = 1370
* CHECK dout1_8 vdout1_8ck136 = 1.8 time = 1370
* CHECK dout1_9 vdout1_9ck136 = 1.8 time = 1370
* CHECK dout1_10 vdout1_10ck136 = 0 time = 1370
* CHECK dout1_11 vdout1_11ck136 = 1.8 time = 1370
* CHECK dout1_12 vdout1_12ck136 = 0 time = 1370
* CHECK dout1_13 vdout1_13ck136 = 0 time = 1370
* CHECK dout1_14 vdout1_14ck136 = 1.8 time = 1370
* CHECK dout1_15 vdout1_15ck136 = 1.8 time = 1370
* CHECK dout1_16 vdout1_16ck136 = 1.8 time = 1370
* CHECK dout1_17 vdout1_17ck136 = 0 time = 1370
* CHECK dout1_18 vdout1_18ck136 = 0 time = 1370
* CHECK dout1_19 vdout1_19ck136 = 1.8 time = 1370
* CHECK dout1_20 vdout1_20ck136 = 1.8 time = 1370
* CHECK dout1_21 vdout1_21ck136 = 0 time = 1370
* CHECK dout1_22 vdout1_22ck136 = 1.8 time = 1370
* CHECK dout1_23 vdout1_23ck136 = 0 time = 1370
* CHECK dout1_24 vdout1_24ck136 = 1.8 time = 1370
* CHECK dout1_25 vdout1_25ck136 = 0 time = 1370
* CHECK dout1_26 vdout1_26ck136 = 1.8 time = 1370
* CHECK dout1_27 vdout1_27ck136 = 1.8 time = 1370
* CHECK dout1_28 vdout1_28ck136 = 0 time = 1370
* CHECK dout1_29 vdout1_29ck136 = 0 time = 1370
* CHECK dout1_30 vdout1_30ck136 = 1.8 time = 1370
* CHECK dout1_31 vdout1_31ck136 = 0 time = 1370
* CHECK dout0_0 vdout0_0ck137 = 1.8 time = 1380
* CHECK dout0_1 vdout0_1ck137 = 1.8 time = 1380
* CHECK dout0_2 vdout0_2ck137 = 1.8 time = 1380
* CHECK dout0_3 vdout0_3ck137 = 0 time = 1380
* CHECK dout0_4 vdout0_4ck137 = 0 time = 1380
* CHECK dout0_5 vdout0_5ck137 = 0 time = 1380
* CHECK dout0_6 vdout0_6ck137 = 0 time = 1380
* CHECK dout0_7 vdout0_7ck137 = 0 time = 1380
* CHECK dout0_8 vdout0_8ck137 = 1.8 time = 1380
* CHECK dout0_9 vdout0_9ck137 = 0 time = 1380
* CHECK dout0_10 vdout0_10ck137 = 0 time = 1380
* CHECK dout0_11 vdout0_11ck137 = 1.8 time = 1380
* CHECK dout0_12 vdout0_12ck137 = 0 time = 1380
* CHECK dout0_13 vdout0_13ck137 = 0 time = 1380
* CHECK dout0_14 vdout0_14ck137 = 1.8 time = 1380
* CHECK dout0_15 vdout0_15ck137 = 0 time = 1380
* CHECK dout0_16 vdout0_16ck137 = 1.8 time = 1380
* CHECK dout0_17 vdout0_17ck137 = 0 time = 1380
* CHECK dout0_18 vdout0_18ck137 = 1.8 time = 1380
* CHECK dout0_19 vdout0_19ck137 = 1.8 time = 1380
* CHECK dout0_20 vdout0_20ck137 = 1.8 time = 1380
* CHECK dout0_21 vdout0_21ck137 = 1.8 time = 1380
* CHECK dout0_22 vdout0_22ck137 = 1.8 time = 1380
* CHECK dout0_23 vdout0_23ck137 = 1.8 time = 1380
* CHECK dout0_24 vdout0_24ck137 = 1.8 time = 1380
* CHECK dout0_25 vdout0_25ck137 = 1.8 time = 1380
* CHECK dout0_26 vdout0_26ck137 = 1.8 time = 1380
* CHECK dout0_27 vdout0_27ck137 = 0 time = 1380
* CHECK dout0_28 vdout0_28ck137 = 0 time = 1380
* CHECK dout0_29 vdout0_29ck137 = 0 time = 1380
* CHECK dout0_30 vdout0_30ck137 = 0 time = 1380
* CHECK dout0_31 vdout0_31ck137 = 0 time = 1380
* CHECK dout0_0 vdout0_0ck138 = 1.8 time = 1390
* CHECK dout0_1 vdout0_1ck138 = 1.8 time = 1390
* CHECK dout0_2 vdout0_2ck138 = 1.8 time = 1390
* CHECK dout0_3 vdout0_3ck138 = 0 time = 1390
* CHECK dout0_4 vdout0_4ck138 = 0 time = 1390
* CHECK dout0_5 vdout0_5ck138 = 0 time = 1390
* CHECK dout0_6 vdout0_6ck138 = 0 time = 1390
* CHECK dout0_7 vdout0_7ck138 = 0 time = 1390
* CHECK dout0_8 vdout0_8ck138 = 1.8 time = 1390
* CHECK dout0_9 vdout0_9ck138 = 0 time = 1390
* CHECK dout0_10 vdout0_10ck138 = 0 time = 1390
* CHECK dout0_11 vdout0_11ck138 = 1.8 time = 1390
* CHECK dout0_12 vdout0_12ck138 = 0 time = 1390
* CHECK dout0_13 vdout0_13ck138 = 0 time = 1390
* CHECK dout0_14 vdout0_14ck138 = 1.8 time = 1390
* CHECK dout0_15 vdout0_15ck138 = 0 time = 1390
* CHECK dout0_16 vdout0_16ck138 = 1.8 time = 1390
* CHECK dout0_17 vdout0_17ck138 = 0 time = 1390
* CHECK dout0_18 vdout0_18ck138 = 1.8 time = 1390
* CHECK dout0_19 vdout0_19ck138 = 1.8 time = 1390
* CHECK dout0_20 vdout0_20ck138 = 1.8 time = 1390
* CHECK dout0_21 vdout0_21ck138 = 1.8 time = 1390
* CHECK dout0_22 vdout0_22ck138 = 1.8 time = 1390
* CHECK dout0_23 vdout0_23ck138 = 1.8 time = 1390
* CHECK dout0_24 vdout0_24ck138 = 1.8 time = 1390
* CHECK dout0_25 vdout0_25ck138 = 1.8 time = 1390
* CHECK dout0_26 vdout0_26ck138 = 1.8 time = 1390
* CHECK dout0_27 vdout0_27ck138 = 0 time = 1390
* CHECK dout0_28 vdout0_28ck138 = 0 time = 1390
* CHECK dout0_29 vdout0_29ck138 = 0 time = 1390
* CHECK dout0_30 vdout0_30ck138 = 0 time = 1390
* CHECK dout0_31 vdout0_31ck138 = 0 time = 1390
* CHECK dout0_0 vdout0_0ck140 = 1.8 time = 1410
* CHECK dout0_1 vdout0_1ck140 = 0 time = 1410
* CHECK dout0_2 vdout0_2ck140 = 0 time = 1410
* CHECK dout0_3 vdout0_3ck140 = 0 time = 1410
* CHECK dout0_4 vdout0_4ck140 = 1.8 time = 1410
* CHECK dout0_5 vdout0_5ck140 = 1.8 time = 1410
* CHECK dout0_6 vdout0_6ck140 = 1.8 time = 1410
* CHECK dout0_7 vdout0_7ck140 = 0 time = 1410
* CHECK dout0_8 vdout0_8ck140 = 1.8 time = 1410
* CHECK dout0_9 vdout0_9ck140 = 1.8 time = 1410
* CHECK dout0_10 vdout0_10ck140 = 0 time = 1410
* CHECK dout0_11 vdout0_11ck140 = 1.8 time = 1410
* CHECK dout0_12 vdout0_12ck140 = 0 time = 1410
* CHECK dout0_13 vdout0_13ck140 = 0 time = 1410
* CHECK dout0_14 vdout0_14ck140 = 1.8 time = 1410
* CHECK dout0_15 vdout0_15ck140 = 1.8 time = 1410
* CHECK dout0_16 vdout0_16ck140 = 0 time = 1410
* CHECK dout0_17 vdout0_17ck140 = 1.8 time = 1410
* CHECK dout0_18 vdout0_18ck140 = 0 time = 1410
* CHECK dout0_19 vdout0_19ck140 = 0 time = 1410
* CHECK dout0_20 vdout0_20ck140 = 0 time = 1410
* CHECK dout0_21 vdout0_21ck140 = 1.8 time = 1410
* CHECK dout0_22 vdout0_22ck140 = 0 time = 1410
* CHECK dout0_23 vdout0_23ck140 = 0 time = 1410
* CHECK dout0_24 vdout0_24ck140 = 1.8 time = 1410
* CHECK dout0_25 vdout0_25ck140 = 0 time = 1410
* CHECK dout0_26 vdout0_26ck140 = 1.8 time = 1410
* CHECK dout0_27 vdout0_27ck140 = 1.8 time = 1410
* CHECK dout0_28 vdout0_28ck140 = 0 time = 1410
* CHECK dout0_29 vdout0_29ck140 = 0 time = 1410
* CHECK dout0_30 vdout0_30ck140 = 1.8 time = 1410
* CHECK dout0_31 vdout0_31ck140 = 0 time = 1410
* CHECK dout0_0 vdout0_0ck143 = 1.8 time = 1440
* CHECK dout0_1 vdout0_1ck143 = 0 time = 1440
* CHECK dout0_2 vdout0_2ck143 = 0 time = 1440
* CHECK dout0_3 vdout0_3ck143 = 1.8 time = 1440
* CHECK dout0_4 vdout0_4ck143 = 0 time = 1440
* CHECK dout0_5 vdout0_5ck143 = 1.8 time = 1440
* CHECK dout0_6 vdout0_6ck143 = 1.8 time = 1440
* CHECK dout0_7 vdout0_7ck143 = 0 time = 1440
* CHECK dout0_8 vdout0_8ck143 = 1.8 time = 1440
* CHECK dout0_9 vdout0_9ck143 = 1.8 time = 1440
* CHECK dout0_10 vdout0_10ck143 = 1.8 time = 1440
* CHECK dout0_11 vdout0_11ck143 = 0 time = 1440
* CHECK dout0_12 vdout0_12ck143 = 0 time = 1440
* CHECK dout0_13 vdout0_13ck143 = 0 time = 1440
* CHECK dout0_14 vdout0_14ck143 = 0 time = 1440
* CHECK dout0_15 vdout0_15ck143 = 0 time = 1440
* CHECK dout0_16 vdout0_16ck143 = 1.8 time = 1440
* CHECK dout0_17 vdout0_17ck143 = 0 time = 1440
* CHECK dout0_18 vdout0_18ck143 = 1.8 time = 1440
* CHECK dout0_19 vdout0_19ck143 = 0 time = 1440
* CHECK dout0_20 vdout0_20ck143 = 1.8 time = 1440
* CHECK dout0_21 vdout0_21ck143 = 1.8 time = 1440
* CHECK dout0_22 vdout0_22ck143 = 0 time = 1440
* CHECK dout0_23 vdout0_23ck143 = 1.8 time = 1440
* CHECK dout0_24 vdout0_24ck143 = 1.8 time = 1440
* CHECK dout0_25 vdout0_25ck143 = 0 time = 1440
* CHECK dout0_26 vdout0_26ck143 = 1.8 time = 1440
* CHECK dout0_27 vdout0_27ck143 = 0 time = 1440
* CHECK dout0_28 vdout0_28ck143 = 0 time = 1440
* CHECK dout0_29 vdout0_29ck143 = 1.8 time = 1440
* CHECK dout0_30 vdout0_30ck143 = 0 time = 1440
* CHECK dout0_31 vdout0_31ck143 = 1.8 time = 1440
* CHECK dout0_0 vdout0_0ck144 = 0 time = 1450
* CHECK dout0_1 vdout0_1ck144 = 1.8 time = 1450
* CHECK dout0_2 vdout0_2ck144 = 1.8 time = 1450
* CHECK dout0_3 vdout0_3ck144 = 1.8 time = 1450
* CHECK dout0_4 vdout0_4ck144 = 0 time = 1450
* CHECK dout0_5 vdout0_5ck144 = 0 time = 1450
* CHECK dout0_6 vdout0_6ck144 = 1.8 time = 1450
* CHECK dout0_7 vdout0_7ck144 = 1.8 time = 1450
* CHECK dout0_8 vdout0_8ck144 = 1.8 time = 1450
* CHECK dout0_9 vdout0_9ck144 = 1.8 time = 1450
* CHECK dout0_10 vdout0_10ck144 = 1.8 time = 1450
* CHECK dout0_11 vdout0_11ck144 = 0 time = 1450
* CHECK dout0_12 vdout0_12ck144 = 0 time = 1450
* CHECK dout0_13 vdout0_13ck144 = 0 time = 1450
* CHECK dout0_14 vdout0_14ck144 = 0 time = 1450
* CHECK dout0_15 vdout0_15ck144 = 0 time = 1450
* CHECK dout0_16 vdout0_16ck144 = 1.8 time = 1450
* CHECK dout0_17 vdout0_17ck144 = 0 time = 1450
* CHECK dout0_18 vdout0_18ck144 = 1.8 time = 1450
* CHECK dout0_19 vdout0_19ck144 = 1.8 time = 1450
* CHECK dout0_20 vdout0_20ck144 = 1.8 time = 1450
* CHECK dout0_21 vdout0_21ck144 = 0 time = 1450
* CHECK dout0_22 vdout0_22ck144 = 1.8 time = 1450
* CHECK dout0_23 vdout0_23ck144 = 0 time = 1450
* CHECK dout0_24 vdout0_24ck144 = 0 time = 1450
* CHECK dout0_25 vdout0_25ck144 = 0 time = 1450
* CHECK dout0_26 vdout0_26ck144 = 0 time = 1450
* CHECK dout0_27 vdout0_27ck144 = 1.8 time = 1450
* CHECK dout0_28 vdout0_28ck144 = 1.8 time = 1450
* CHECK dout0_29 vdout0_29ck144 = 1.8 time = 1450
* CHECK dout0_30 vdout0_30ck144 = 0 time = 1450
* CHECK dout0_31 vdout0_31ck144 = 0 time = 1450
* CHECK dout0_0 vdout0_0ck145 = 1.8 time = 1460
* CHECK dout0_1 vdout0_1ck145 = 1.8 time = 1460
* CHECK dout0_2 vdout0_2ck145 = 1.8 time = 1460
* CHECK dout0_3 vdout0_3ck145 = 0 time = 1460
* CHECK dout0_4 vdout0_4ck145 = 0 time = 1460
* CHECK dout0_5 vdout0_5ck145 = 0 time = 1460
* CHECK dout0_6 vdout0_6ck145 = 0 time = 1460
* CHECK dout0_7 vdout0_7ck145 = 0 time = 1460
* CHECK dout0_8 vdout0_8ck145 = 1.8 time = 1460
* CHECK dout0_9 vdout0_9ck145 = 0 time = 1460
* CHECK dout0_10 vdout0_10ck145 = 0 time = 1460
* CHECK dout0_11 vdout0_11ck145 = 1.8 time = 1460
* CHECK dout0_12 vdout0_12ck145 = 0 time = 1460
* CHECK dout0_13 vdout0_13ck145 = 0 time = 1460
* CHECK dout0_14 vdout0_14ck145 = 1.8 time = 1460
* CHECK dout0_15 vdout0_15ck145 = 0 time = 1460
* CHECK dout0_16 vdout0_16ck145 = 1.8 time = 1460
* CHECK dout0_17 vdout0_17ck145 = 0 time = 1460
* CHECK dout0_18 vdout0_18ck145 = 1.8 time = 1460
* CHECK dout0_19 vdout0_19ck145 = 1.8 time = 1460
* CHECK dout0_20 vdout0_20ck145 = 1.8 time = 1460
* CHECK dout0_21 vdout0_21ck145 = 1.8 time = 1460
* CHECK dout0_22 vdout0_22ck145 = 1.8 time = 1460
* CHECK dout0_23 vdout0_23ck145 = 1.8 time = 1460
* CHECK dout0_24 vdout0_24ck145 = 1.8 time = 1460
* CHECK dout0_25 vdout0_25ck145 = 1.8 time = 1460
* CHECK dout0_26 vdout0_26ck145 = 1.8 time = 1460
* CHECK dout0_27 vdout0_27ck145 = 0 time = 1460
* CHECK dout0_28 vdout0_28ck145 = 0 time = 1460
* CHECK dout0_29 vdout0_29ck145 = 0 time = 1460
* CHECK dout0_30 vdout0_30ck145 = 0 time = 1460
* CHECK dout0_31 vdout0_31ck145 = 0 time = 1460
* CHECK dout1_0 vdout1_0ck145 = 1.8 time = 1460
* CHECK dout1_1 vdout1_1ck145 = 0 time = 1460
* CHECK dout1_2 vdout1_2ck145 = 0 time = 1460
* CHECK dout1_3 vdout1_3ck145 = 1.8 time = 1460
* CHECK dout1_4 vdout1_4ck145 = 0 time = 1460
* CHECK dout1_5 vdout1_5ck145 = 1.8 time = 1460
* CHECK dout1_6 vdout1_6ck145 = 1.8 time = 1460
* CHECK dout1_7 vdout1_7ck145 = 0 time = 1460
* CHECK dout1_8 vdout1_8ck145 = 1.8 time = 1460
* CHECK dout1_9 vdout1_9ck145 = 1.8 time = 1460
* CHECK dout1_10 vdout1_10ck145 = 1.8 time = 1460
* CHECK dout1_11 vdout1_11ck145 = 0 time = 1460
* CHECK dout1_12 vdout1_12ck145 = 0 time = 1460
* CHECK dout1_13 vdout1_13ck145 = 0 time = 1460
* CHECK dout1_14 vdout1_14ck145 = 0 time = 1460
* CHECK dout1_15 vdout1_15ck145 = 0 time = 1460
* CHECK dout1_16 vdout1_16ck145 = 1.8 time = 1460
* CHECK dout1_17 vdout1_17ck145 = 0 time = 1460
* CHECK dout1_18 vdout1_18ck145 = 1.8 time = 1460
* CHECK dout1_19 vdout1_19ck145 = 0 time = 1460
* CHECK dout1_20 vdout1_20ck145 = 1.8 time = 1460
* CHECK dout1_21 vdout1_21ck145 = 1.8 time = 1460
* CHECK dout1_22 vdout1_22ck145 = 0 time = 1460
* CHECK dout1_23 vdout1_23ck145 = 1.8 time = 1460
* CHECK dout1_24 vdout1_24ck145 = 1.8 time = 1460
* CHECK dout1_25 vdout1_25ck145 = 0 time = 1460
* CHECK dout1_26 vdout1_26ck145 = 1.8 time = 1460
* CHECK dout1_27 vdout1_27ck145 = 0 time = 1460
* CHECK dout1_28 vdout1_28ck145 = 0 time = 1460
* CHECK dout1_29 vdout1_29ck145 = 1.8 time = 1460
* CHECK dout1_30 vdout1_30ck145 = 0 time = 1460
* CHECK dout1_31 vdout1_31ck145 = 1.8 time = 1460
* CHECK dout0_0 vdout0_0ck146 = 1.8 time = 1470
* CHECK dout0_1 vdout0_1ck146 = 1.8 time = 1470
* CHECK dout0_2 vdout0_2ck146 = 1.8 time = 1470
* CHECK dout0_3 vdout0_3ck146 = 0 time = 1470
* CHECK dout0_4 vdout0_4ck146 = 0 time = 1470
* CHECK dout0_5 vdout0_5ck146 = 0 time = 1470
* CHECK dout0_6 vdout0_6ck146 = 0 time = 1470
* CHECK dout0_7 vdout0_7ck146 = 0 time = 1470
* CHECK dout0_8 vdout0_8ck146 = 1.8 time = 1470
* CHECK dout0_9 vdout0_9ck146 = 0 time = 1470
* CHECK dout0_10 vdout0_10ck146 = 0 time = 1470
* CHECK dout0_11 vdout0_11ck146 = 1.8 time = 1470
* CHECK dout0_12 vdout0_12ck146 = 0 time = 1470
* CHECK dout0_13 vdout0_13ck146 = 0 time = 1470
* CHECK dout0_14 vdout0_14ck146 = 1.8 time = 1470
* CHECK dout0_15 vdout0_15ck146 = 0 time = 1470
* CHECK dout0_16 vdout0_16ck146 = 1.8 time = 1470
* CHECK dout0_17 vdout0_17ck146 = 0 time = 1470
* CHECK dout0_18 vdout0_18ck146 = 1.8 time = 1470
* CHECK dout0_19 vdout0_19ck146 = 1.8 time = 1470
* CHECK dout0_20 vdout0_20ck146 = 1.8 time = 1470
* CHECK dout0_21 vdout0_21ck146 = 1.8 time = 1470
* CHECK dout0_22 vdout0_22ck146 = 1.8 time = 1470
* CHECK dout0_23 vdout0_23ck146 = 1.8 time = 1470
* CHECK dout0_24 vdout0_24ck146 = 1.8 time = 1470
* CHECK dout0_25 vdout0_25ck146 = 1.8 time = 1470
* CHECK dout0_26 vdout0_26ck146 = 1.8 time = 1470
* CHECK dout0_27 vdout0_27ck146 = 0 time = 1470
* CHECK dout0_28 vdout0_28ck146 = 0 time = 1470
* CHECK dout0_29 vdout0_29ck146 = 0 time = 1470
* CHECK dout0_30 vdout0_30ck146 = 0 time = 1470
* CHECK dout0_31 vdout0_31ck146 = 0 time = 1470
* CHECK dout0_0 vdout0_0ck147 = 0 time = 1480
* CHECK dout0_1 vdout0_1ck147 = 1.8 time = 1480
* CHECK dout0_2 vdout0_2ck147 = 1.8 time = 1480
* CHECK dout0_3 vdout0_3ck147 = 1.8 time = 1480
* CHECK dout0_4 vdout0_4ck147 = 0 time = 1480
* CHECK dout0_5 vdout0_5ck147 = 0 time = 1480
* CHECK dout0_6 vdout0_6ck147 = 1.8 time = 1480
* CHECK dout0_7 vdout0_7ck147 = 1.8 time = 1480
* CHECK dout0_8 vdout0_8ck147 = 1.8 time = 1480
* CHECK dout0_9 vdout0_9ck147 = 1.8 time = 1480
* CHECK dout0_10 vdout0_10ck147 = 1.8 time = 1480
* CHECK dout0_11 vdout0_11ck147 = 0 time = 1480
* CHECK dout0_12 vdout0_12ck147 = 0 time = 1480
* CHECK dout0_13 vdout0_13ck147 = 0 time = 1480
* CHECK dout0_14 vdout0_14ck147 = 0 time = 1480
* CHECK dout0_15 vdout0_15ck147 = 0 time = 1480
* CHECK dout0_16 vdout0_16ck147 = 1.8 time = 1480
* CHECK dout0_17 vdout0_17ck147 = 0 time = 1480
* CHECK dout0_18 vdout0_18ck147 = 1.8 time = 1480
* CHECK dout0_19 vdout0_19ck147 = 1.8 time = 1480
* CHECK dout0_20 vdout0_20ck147 = 1.8 time = 1480
* CHECK dout0_21 vdout0_21ck147 = 0 time = 1480
* CHECK dout0_22 vdout0_22ck147 = 1.8 time = 1480
* CHECK dout0_23 vdout0_23ck147 = 0 time = 1480
* CHECK dout0_24 vdout0_24ck147 = 0 time = 1480
* CHECK dout0_25 vdout0_25ck147 = 0 time = 1480
* CHECK dout0_26 vdout0_26ck147 = 0 time = 1480
* CHECK dout0_27 vdout0_27ck147 = 1.8 time = 1480
* CHECK dout0_28 vdout0_28ck147 = 1.8 time = 1480
* CHECK dout0_29 vdout0_29ck147 = 1.8 time = 1480
* CHECK dout0_30 vdout0_30ck147 = 0 time = 1480
* CHECK dout0_31 vdout0_31ck147 = 0 time = 1480
* CHECK dout1_0 vdout1_0ck147 = 1.8 time = 1480
* CHECK dout1_1 vdout1_1ck147 = 0 time = 1480
* CHECK dout1_2 vdout1_2ck147 = 0 time = 1480
* CHECK dout1_3 vdout1_3ck147 = 1.8 time = 1480
* CHECK dout1_4 vdout1_4ck147 = 0 time = 1480
* CHECK dout1_5 vdout1_5ck147 = 1.8 time = 1480
* CHECK dout1_6 vdout1_6ck147 = 1.8 time = 1480
* CHECK dout1_7 vdout1_7ck147 = 0 time = 1480
* CHECK dout1_8 vdout1_8ck147 = 1.8 time = 1480
* CHECK dout1_9 vdout1_9ck147 = 1.8 time = 1480
* CHECK dout1_10 vdout1_10ck147 = 1.8 time = 1480
* CHECK dout1_11 vdout1_11ck147 = 0 time = 1480
* CHECK dout1_12 vdout1_12ck147 = 0 time = 1480
* CHECK dout1_13 vdout1_13ck147 = 0 time = 1480
* CHECK dout1_14 vdout1_14ck147 = 0 time = 1480
* CHECK dout1_15 vdout1_15ck147 = 0 time = 1480
* CHECK dout1_16 vdout1_16ck147 = 1.8 time = 1480
* CHECK dout1_17 vdout1_17ck147 = 0 time = 1480
* CHECK dout1_18 vdout1_18ck147 = 1.8 time = 1480
* CHECK dout1_19 vdout1_19ck147 = 0 time = 1480
* CHECK dout1_20 vdout1_20ck147 = 1.8 time = 1480
* CHECK dout1_21 vdout1_21ck147 = 1.8 time = 1480
* CHECK dout1_22 vdout1_22ck147 = 0 time = 1480
* CHECK dout1_23 vdout1_23ck147 = 1.8 time = 1480
* CHECK dout1_24 vdout1_24ck147 = 1.8 time = 1480
* CHECK dout1_25 vdout1_25ck147 = 0 time = 1480
* CHECK dout1_26 vdout1_26ck147 = 1.8 time = 1480
* CHECK dout1_27 vdout1_27ck147 = 0 time = 1480
* CHECK dout1_28 vdout1_28ck147 = 0 time = 1480
* CHECK dout1_29 vdout1_29ck147 = 1.8 time = 1480
* CHECK dout1_30 vdout1_30ck147 = 0 time = 1480
* CHECK dout1_31 vdout1_31ck147 = 1.8 time = 1480
* CHECK dout1_0 vdout1_0ck148 = 0 time = 1490
* CHECK dout1_1 vdout1_1ck148 = 1.8 time = 1490
* CHECK dout1_2 vdout1_2ck148 = 1.8 time = 1490
* CHECK dout1_3 vdout1_3ck148 = 1.8 time = 1490
* CHECK dout1_4 vdout1_4ck148 = 0 time = 1490
* CHECK dout1_5 vdout1_5ck148 = 0 time = 1490
* CHECK dout1_6 vdout1_6ck148 = 1.8 time = 1490
* CHECK dout1_7 vdout1_7ck148 = 1.8 time = 1490
* CHECK dout1_8 vdout1_8ck148 = 1.8 time = 1490
* CHECK dout1_9 vdout1_9ck148 = 1.8 time = 1490
* CHECK dout1_10 vdout1_10ck148 = 1.8 time = 1490
* CHECK dout1_11 vdout1_11ck148 = 0 time = 1490
* CHECK dout1_12 vdout1_12ck148 = 0 time = 1490
* CHECK dout1_13 vdout1_13ck148 = 0 time = 1490
* CHECK dout1_14 vdout1_14ck148 = 0 time = 1490
* CHECK dout1_15 vdout1_15ck148 = 0 time = 1490
* CHECK dout1_16 vdout1_16ck148 = 1.8 time = 1490
* CHECK dout1_17 vdout1_17ck148 = 0 time = 1490
* CHECK dout1_18 vdout1_18ck148 = 1.8 time = 1490
* CHECK dout1_19 vdout1_19ck148 = 1.8 time = 1490
* CHECK dout1_20 vdout1_20ck148 = 1.8 time = 1490
* CHECK dout1_21 vdout1_21ck148 = 0 time = 1490
* CHECK dout1_22 vdout1_22ck148 = 1.8 time = 1490
* CHECK dout1_23 vdout1_23ck148 = 0 time = 1490
* CHECK dout1_24 vdout1_24ck148 = 0 time = 1490
* CHECK dout1_25 vdout1_25ck148 = 0 time = 1490
* CHECK dout1_26 vdout1_26ck148 = 0 time = 1490
* CHECK dout1_27 vdout1_27ck148 = 1.8 time = 1490
* CHECK dout1_28 vdout1_28ck148 = 1.8 time = 1490
* CHECK dout1_29 vdout1_29ck148 = 1.8 time = 1490
* CHECK dout1_30 vdout1_30ck148 = 0 time = 1490
* CHECK dout1_31 vdout1_31ck148 = 0 time = 1490
* CHECK dout0_0 vdout0_0ck149 = 0 time = 1500
* CHECK dout0_1 vdout0_1ck149 = 1.8 time = 1500
* CHECK dout0_2 vdout0_2ck149 = 1.8 time = 1500
* CHECK dout0_3 vdout0_3ck149 = 1.8 time = 1500
* CHECK dout0_4 vdout0_4ck149 = 0 time = 1500
* CHECK dout0_5 vdout0_5ck149 = 0 time = 1500
* CHECK dout0_6 vdout0_6ck149 = 1.8 time = 1500
* CHECK dout0_7 vdout0_7ck149 = 1.8 time = 1500
* CHECK dout0_8 vdout0_8ck149 = 1.8 time = 1500
* CHECK dout0_9 vdout0_9ck149 = 1.8 time = 1500
* CHECK dout0_10 vdout0_10ck149 = 1.8 time = 1500
* CHECK dout0_11 vdout0_11ck149 = 0 time = 1500
* CHECK dout0_12 vdout0_12ck149 = 0 time = 1500
* CHECK dout0_13 vdout0_13ck149 = 0 time = 1500
* CHECK dout0_14 vdout0_14ck149 = 0 time = 1500
* CHECK dout0_15 vdout0_15ck149 = 0 time = 1500
* CHECK dout0_16 vdout0_16ck149 = 1.8 time = 1500
* CHECK dout0_17 vdout0_17ck149 = 0 time = 1500
* CHECK dout0_18 vdout0_18ck149 = 1.8 time = 1500
* CHECK dout0_19 vdout0_19ck149 = 1.8 time = 1500
* CHECK dout0_20 vdout0_20ck149 = 1.8 time = 1500
* CHECK dout0_21 vdout0_21ck149 = 0 time = 1500
* CHECK dout0_22 vdout0_22ck149 = 1.8 time = 1500
* CHECK dout0_23 vdout0_23ck149 = 0 time = 1500
* CHECK dout0_24 vdout0_24ck149 = 0 time = 1500
* CHECK dout0_25 vdout0_25ck149 = 0 time = 1500
* CHECK dout0_26 vdout0_26ck149 = 0 time = 1500
* CHECK dout0_27 vdout0_27ck149 = 1.8 time = 1500
* CHECK dout0_28 vdout0_28ck149 = 1.8 time = 1500
* CHECK dout0_29 vdout0_29ck149 = 1.8 time = 1500
* CHECK dout0_30 vdout0_30ck149 = 0 time = 1500
* CHECK dout0_31 vdout0_31ck149 = 0 time = 1500
* CHECK dout0_0 vdout0_0ck150 = 0 time = 1510
* CHECK dout0_1 vdout0_1ck150 = 0 time = 1510
* CHECK dout0_2 vdout0_2ck150 = 1.8 time = 1510
* CHECK dout0_3 vdout0_3ck150 = 1.8 time = 1510
* CHECK dout0_4 vdout0_4ck150 = 1.8 time = 1510
* CHECK dout0_5 vdout0_5ck150 = 1.8 time = 1510
* CHECK dout0_6 vdout0_6ck150 = 0 time = 1510
* CHECK dout0_7 vdout0_7ck150 = 1.8 time = 1510
* CHECK dout0_8 vdout0_8ck150 = 0 time = 1510
* CHECK dout0_9 vdout0_9ck150 = 0 time = 1510
* CHECK dout0_10 vdout0_10ck150 = 0 time = 1510
* CHECK dout0_11 vdout0_11ck150 = 1.8 time = 1510
* CHECK dout0_12 vdout0_12ck150 = 1.8 time = 1510
* CHECK dout0_13 vdout0_13ck150 = 0 time = 1510
* CHECK dout0_14 vdout0_14ck150 = 0 time = 1510
* CHECK dout0_15 vdout0_15ck150 = 1.8 time = 1510
* CHECK dout0_16 vdout0_16ck150 = 0 time = 1510
* CHECK dout0_17 vdout0_17ck150 = 1.8 time = 1510
* CHECK dout0_18 vdout0_18ck150 = 0 time = 1510
* CHECK dout0_19 vdout0_19ck150 = 1.8 time = 1510
* CHECK dout0_20 vdout0_20ck150 = 0 time = 1510
* CHECK dout0_21 vdout0_21ck150 = 1.8 time = 1510
* CHECK dout0_22 vdout0_22ck150 = 1.8 time = 1510
* CHECK dout0_23 vdout0_23ck150 = 1.8 time = 1510
* CHECK dout0_24 vdout0_24ck150 = 1.8 time = 1510
* CHECK dout0_25 vdout0_25ck150 = 0 time = 1510
* CHECK dout0_26 vdout0_26ck150 = 1.8 time = 1510
* CHECK dout0_27 vdout0_27ck150 = 0 time = 1510
* CHECK dout0_28 vdout0_28ck150 = 0 time = 1510
* CHECK dout0_29 vdout0_29ck150 = 1.8 time = 1510
* CHECK dout0_30 vdout0_30ck150 = 0 time = 1510
* CHECK dout0_31 vdout0_31ck150 = 1.8 time = 1510
* CHECK dout1_0 vdout1_0ck151 = 1.8 time = 1520
* CHECK dout1_1 vdout1_1ck151 = 0 time = 1520
* CHECK dout1_2 vdout1_2ck151 = 0 time = 1520
* CHECK dout1_3 vdout1_3ck151 = 0 time = 1520
* CHECK dout1_4 vdout1_4ck151 = 1.8 time = 1520
* CHECK dout1_5 vdout1_5ck151 = 1.8 time = 1520
* CHECK dout1_6 vdout1_6ck151 = 1.8 time = 1520
* CHECK dout1_7 vdout1_7ck151 = 0 time = 1520
* CHECK dout1_8 vdout1_8ck151 = 1.8 time = 1520
* CHECK dout1_9 vdout1_9ck151 = 1.8 time = 1520
* CHECK dout1_10 vdout1_10ck151 = 0 time = 1520
* CHECK dout1_11 vdout1_11ck151 = 1.8 time = 1520
* CHECK dout1_12 vdout1_12ck151 = 0 time = 1520
* CHECK dout1_13 vdout1_13ck151 = 0 time = 1520
* CHECK dout1_14 vdout1_14ck151 = 1.8 time = 1520
* CHECK dout1_15 vdout1_15ck151 = 1.8 time = 1520
* CHECK dout1_16 vdout1_16ck151 = 0 time = 1520
* CHECK dout1_17 vdout1_17ck151 = 1.8 time = 1520
* CHECK dout1_18 vdout1_18ck151 = 0 time = 1520
* CHECK dout1_19 vdout1_19ck151 = 0 time = 1520
* CHECK dout1_20 vdout1_20ck151 = 0 time = 1520
* CHECK dout1_21 vdout1_21ck151 = 1.8 time = 1520
* CHECK dout1_22 vdout1_22ck151 = 0 time = 1520
* CHECK dout1_23 vdout1_23ck151 = 0 time = 1520
* CHECK dout1_24 vdout1_24ck151 = 1.8 time = 1520
* CHECK dout1_25 vdout1_25ck151 = 0 time = 1520
* CHECK dout1_26 vdout1_26ck151 = 1.8 time = 1520
* CHECK dout1_27 vdout1_27ck151 = 1.8 time = 1520
* CHECK dout1_28 vdout1_28ck151 = 0 time = 1520
* CHECK dout1_29 vdout1_29ck151 = 0 time = 1520
* CHECK dout1_30 vdout1_30ck151 = 1.8 time = 1520
* CHECK dout1_31 vdout1_31ck151 = 0 time = 1520
* CHECK dout0_0 vdout0_0ck156 = 1.8 time = 1570
* CHECK dout0_1 vdout0_1ck156 = 1.8 time = 1570
* CHECK dout0_2 vdout0_2ck156 = 1.8 time = 1570
* CHECK dout0_3 vdout0_3ck156 = 0 time = 1570
* CHECK dout0_4 vdout0_4ck156 = 0 time = 1570
* CHECK dout0_5 vdout0_5ck156 = 0 time = 1570
* CHECK dout0_6 vdout0_6ck156 = 0 time = 1570
* CHECK dout0_7 vdout0_7ck156 = 0 time = 1570
* CHECK dout0_8 vdout0_8ck156 = 1.8 time = 1570
* CHECK dout0_9 vdout0_9ck156 = 1.8 time = 1570
* CHECK dout0_10 vdout0_10ck156 = 1.8 time = 1570
* CHECK dout0_11 vdout0_11ck156 = 0 time = 1570
* CHECK dout0_12 vdout0_12ck156 = 1.8 time = 1570
* CHECK dout0_13 vdout0_13ck156 = 0 time = 1570
* CHECK dout0_14 vdout0_14ck156 = 1.8 time = 1570
* CHECK dout0_15 vdout0_15ck156 = 0 time = 1570
* CHECK dout0_16 vdout0_16ck156 = 1.8 time = 1570
* CHECK dout0_17 vdout0_17ck156 = 1.8 time = 1570
* CHECK dout0_18 vdout0_18ck156 = 1.8 time = 1570
* CHECK dout0_19 vdout0_19ck156 = 1.8 time = 1570
* CHECK dout0_20 vdout0_20ck156 = 0 time = 1570
* CHECK dout0_21 vdout0_21ck156 = 0 time = 1570
* CHECK dout0_22 vdout0_22ck156 = 0 time = 1570
* CHECK dout0_23 vdout0_23ck156 = 1.8 time = 1570
* CHECK dout0_24 vdout0_24ck156 = 1.8 time = 1570
* CHECK dout0_25 vdout0_25ck156 = 1.8 time = 1570
* CHECK dout0_26 vdout0_26ck156 = 1.8 time = 1570
* CHECK dout0_27 vdout0_27ck156 = 0 time = 1570
* CHECK dout0_28 vdout0_28ck156 = 0 time = 1570
* CHECK dout0_29 vdout0_29ck156 = 0 time = 1570
* CHECK dout0_30 vdout0_30ck156 = 0 time = 1570
* CHECK dout0_31 vdout0_31ck156 = 0 time = 1570
* CHECK dout1_0 vdout1_0ck158 = 1.8 time = 1590
* CHECK dout1_1 vdout1_1ck158 = 1.8 time = 1590
* CHECK dout1_2 vdout1_2ck158 = 1.8 time = 1590
* CHECK dout1_3 vdout1_3ck158 = 0 time = 1590
* CHECK dout1_4 vdout1_4ck158 = 0 time = 1590
* CHECK dout1_5 vdout1_5ck158 = 0 time = 1590
* CHECK dout1_6 vdout1_6ck158 = 0 time = 1590
* CHECK dout1_7 vdout1_7ck158 = 0 time = 1590
* CHECK dout1_8 vdout1_8ck158 = 1.8 time = 1590
* CHECK dout1_9 vdout1_9ck158 = 1.8 time = 1590
* CHECK dout1_10 vdout1_10ck158 = 1.8 time = 1590
* CHECK dout1_11 vdout1_11ck158 = 0 time = 1590
* CHECK dout1_12 vdout1_12ck158 = 1.8 time = 1590
* CHECK dout1_13 vdout1_13ck158 = 0 time = 1590
* CHECK dout1_14 vdout1_14ck158 = 1.8 time = 1590
* CHECK dout1_15 vdout1_15ck158 = 0 time = 1590
* CHECK dout1_16 vdout1_16ck158 = 1.8 time = 1590
* CHECK dout1_17 vdout1_17ck158 = 1.8 time = 1590
* CHECK dout1_18 vdout1_18ck158 = 1.8 time = 1590
* CHECK dout1_19 vdout1_19ck158 = 1.8 time = 1590
* CHECK dout1_20 vdout1_20ck158 = 0 time = 1590
* CHECK dout1_21 vdout1_21ck158 = 0 time = 1590
* CHECK dout1_22 vdout1_22ck158 = 0 time = 1590
* CHECK dout1_23 vdout1_23ck158 = 1.8 time = 1590
* CHECK dout1_24 vdout1_24ck158 = 1.8 time = 1590
* CHECK dout1_25 vdout1_25ck158 = 1.8 time = 1590
* CHECK dout1_26 vdout1_26ck158 = 1.8 time = 1590
* CHECK dout1_27 vdout1_27ck158 = 0 time = 1590
* CHECK dout1_28 vdout1_28ck158 = 0 time = 1590
* CHECK dout1_29 vdout1_29ck158 = 0 time = 1590
* CHECK dout1_30 vdout1_30ck158 = 0 time = 1590
* CHECK dout1_31 vdout1_31ck158 = 0 time = 1590
* CHECK dout1_0 vdout1_0ck159 = 0 time = 1600
* CHECK dout1_1 vdout1_1ck159 = 0 time = 1600
* CHECK dout1_2 vdout1_2ck159 = 1.8 time = 1600
* CHECK dout1_3 vdout1_3ck159 = 0 time = 1600
* CHECK dout1_4 vdout1_4ck159 = 0 time = 1600
* CHECK dout1_5 vdout1_5ck159 = 0 time = 1600
* CHECK dout1_6 vdout1_6ck159 = 1.8 time = 1600
* CHECK dout1_7 vdout1_7ck159 = 1.8 time = 1600
* CHECK dout1_8 vdout1_8ck159 = 0 time = 1600
* CHECK dout1_9 vdout1_9ck159 = 1.8 time = 1600
* CHECK dout1_10 vdout1_10ck159 = 0 time = 1600
* CHECK dout1_11 vdout1_11ck159 = 1.8 time = 1600
* CHECK dout1_12 vdout1_12ck159 = 1.8 time = 1600
* CHECK dout1_13 vdout1_13ck159 = 0 time = 1600
* CHECK dout1_14 vdout1_14ck159 = 0 time = 1600
* CHECK dout1_15 vdout1_15ck159 = 0 time = 1600
* CHECK dout1_16 vdout1_16ck159 = 1.8 time = 1600
* CHECK dout1_17 vdout1_17ck159 = 0 time = 1600
* CHECK dout1_18 vdout1_18ck159 = 1.8 time = 1600
* CHECK dout1_19 vdout1_19ck159 = 1.8 time = 1600
* CHECK dout1_20 vdout1_20ck159 = 1.8 time = 1600
* CHECK dout1_21 vdout1_21ck159 = 1.8 time = 1600
* CHECK dout1_22 vdout1_22ck159 = 0 time = 1600
* CHECK dout1_23 vdout1_23ck159 = 0 time = 1600
* CHECK dout1_24 vdout1_24ck159 = 0 time = 1600
* CHECK dout1_25 vdout1_25ck159 = 0 time = 1600
* CHECK dout1_26 vdout1_26ck159 = 0 time = 1600
* CHECK dout1_27 vdout1_27ck159 = 1.8 time = 1600
* CHECK dout1_28 vdout1_28ck159 = 1.8 time = 1600
* CHECK dout1_29 vdout1_29ck159 = 1.8 time = 1600
* CHECK dout1_30 vdout1_30ck159 = 0 time = 1600
* CHECK dout1_31 vdout1_31ck159 = 0 time = 1600
* CHECK dout1_0 vdout1_0ck161 = 0 time = 1620
* CHECK dout1_1 vdout1_1ck161 = 0 time = 1620
* CHECK dout1_2 vdout1_2ck161 = 1.8 time = 1620
* CHECK dout1_3 vdout1_3ck161 = 1.8 time = 1620
* CHECK dout1_4 vdout1_4ck161 = 1.8 time = 1620
* CHECK dout1_5 vdout1_5ck161 = 1.8 time = 1620
* CHECK dout1_6 vdout1_6ck161 = 0 time = 1620
* CHECK dout1_7 vdout1_7ck161 = 1.8 time = 1620
* CHECK dout1_8 vdout1_8ck161 = 0 time = 1620
* CHECK dout1_9 vdout1_9ck161 = 0 time = 1620
* CHECK dout1_10 vdout1_10ck161 = 0 time = 1620
* CHECK dout1_11 vdout1_11ck161 = 1.8 time = 1620
* CHECK dout1_12 vdout1_12ck161 = 1.8 time = 1620
* CHECK dout1_13 vdout1_13ck161 = 0 time = 1620
* CHECK dout1_14 vdout1_14ck161 = 0 time = 1620
* CHECK dout1_15 vdout1_15ck161 = 1.8 time = 1620
* CHECK dout1_16 vdout1_16ck161 = 0 time = 1620
* CHECK dout1_17 vdout1_17ck161 = 1.8 time = 1620
* CHECK dout1_18 vdout1_18ck161 = 0 time = 1620
* CHECK dout1_19 vdout1_19ck161 = 1.8 time = 1620
* CHECK dout1_20 vdout1_20ck161 = 0 time = 1620
* CHECK dout1_21 vdout1_21ck161 = 1.8 time = 1620
* CHECK dout1_22 vdout1_22ck161 = 1.8 time = 1620
* CHECK dout1_23 vdout1_23ck161 = 1.8 time = 1620
* CHECK dout1_24 vdout1_24ck161 = 1.8 time = 1620
* CHECK dout1_25 vdout1_25ck161 = 0 time = 1620
* CHECK dout1_26 vdout1_26ck161 = 1.8 time = 1620
* CHECK dout1_27 vdout1_27ck161 = 0 time = 1620
* CHECK dout1_28 vdout1_28ck161 = 0 time = 1620
* CHECK dout1_29 vdout1_29ck161 = 1.8 time = 1620
* CHECK dout1_30 vdout1_30ck161 = 0 time = 1620
* CHECK dout1_31 vdout1_31ck161 = 1.8 time = 1620
* CHECK dout0_0 vdout0_0ck163 = 1.8 time = 1640
* CHECK dout0_1 vdout0_1ck163 = 1.8 time = 1640
* CHECK dout0_2 vdout0_2ck163 = 0 time = 1640
* CHECK dout0_3 vdout0_3ck163 = 0 time = 1640
* CHECK dout0_4 vdout0_4ck163 = 1.8 time = 1640
* CHECK dout0_5 vdout0_5ck163 = 1.8 time = 1640
* CHECK dout0_6 vdout0_6ck163 = 0 time = 1640
* CHECK dout0_7 vdout0_7ck163 = 0 time = 1640
* CHECK dout0_8 vdout0_8ck163 = 0 time = 1640
* CHECK dout0_9 vdout0_9ck163 = 0 time = 1640
* CHECK dout0_10 vdout0_10ck163 = 1.8 time = 1640
* CHECK dout0_11 vdout0_11ck163 = 1.8 time = 1640
* CHECK dout0_12 vdout0_12ck163 = 1.8 time = 1640
* CHECK dout0_13 vdout0_13ck163 = 0 time = 1640
* CHECK dout0_14 vdout0_14ck163 = 0 time = 1640
* CHECK dout0_15 vdout0_15ck163 = 0 time = 1640
* CHECK dout0_16 vdout0_16ck163 = 0 time = 1640
* CHECK dout0_17 vdout0_17ck163 = 1.8 time = 1640
* CHECK dout0_18 vdout0_18ck163 = 0 time = 1640
* CHECK dout0_19 vdout0_19ck163 = 0 time = 1640
* CHECK dout0_20 vdout0_20ck163 = 0 time = 1640
* CHECK dout0_21 vdout0_21ck163 = 1.8 time = 1640
* CHECK dout0_22 vdout0_22ck163 = 0 time = 1640
* CHECK dout0_23 vdout0_23ck163 = 1.8 time = 1640
* CHECK dout0_24 vdout0_24ck163 = 0 time = 1640
* CHECK dout0_25 vdout0_25ck163 = 0 time = 1640
* CHECK dout0_26 vdout0_26ck163 = 0 time = 1640
* CHECK dout0_27 vdout0_27ck163 = 0 time = 1640
* CHECK dout0_28 vdout0_28ck163 = 0 time = 1640
* CHECK dout0_29 vdout0_29ck163 = 0 time = 1640
* CHECK dout0_30 vdout0_30ck163 = 0 time = 1640
* CHECK dout0_31 vdout0_31ck163 = 1.8 time = 1640
* CHECK dout0_0 vdout0_0ck164 = 1.8 time = 1650
* CHECK dout0_1 vdout0_1ck164 = 1.8 time = 1650
* CHECK dout0_2 vdout0_2ck164 = 1.8 time = 1650
* CHECK dout0_3 vdout0_3ck164 = 0 time = 1650
* CHECK dout0_4 vdout0_4ck164 = 0 time = 1650
* CHECK dout0_5 vdout0_5ck164 = 0 time = 1650
* CHECK dout0_6 vdout0_6ck164 = 0 time = 1650
* CHECK dout0_7 vdout0_7ck164 = 0 time = 1650
* CHECK dout0_8 vdout0_8ck164 = 0 time = 1650
* CHECK dout0_9 vdout0_9ck164 = 0 time = 1650
* CHECK dout0_10 vdout0_10ck164 = 1.8 time = 1650
* CHECK dout0_11 vdout0_11ck164 = 0 time = 1650
* CHECK dout0_12 vdout0_12ck164 = 0 time = 1650
* CHECK dout0_13 vdout0_13ck164 = 0 time = 1650
* CHECK dout0_14 vdout0_14ck164 = 1.8 time = 1650
* CHECK dout0_15 vdout0_15ck164 = 0 time = 1650
* CHECK dout0_16 vdout0_16ck164 = 1.8 time = 1650
* CHECK dout0_17 vdout0_17ck164 = 1.8 time = 1650
* CHECK dout0_18 vdout0_18ck164 = 0 time = 1650
* CHECK dout0_19 vdout0_19ck164 = 1.8 time = 1650
* CHECK dout0_20 vdout0_20ck164 = 0 time = 1650
* CHECK dout0_21 vdout0_21ck164 = 1.8 time = 1650
* CHECK dout0_22 vdout0_22ck164 = 0 time = 1650
* CHECK dout0_23 vdout0_23ck164 = 0 time = 1650
* CHECK dout0_24 vdout0_24ck164 = 1.8 time = 1650
* CHECK dout0_25 vdout0_25ck164 = 1.8 time = 1650
* CHECK dout0_26 vdout0_26ck164 = 1.8 time = 1650
* CHECK dout0_27 vdout0_27ck164 = 1.8 time = 1650
* CHECK dout0_28 vdout0_28ck164 = 0 time = 1650
* CHECK dout0_29 vdout0_29ck164 = 1.8 time = 1650
* CHECK dout0_30 vdout0_30ck164 = 1.8 time = 1650
* CHECK dout0_31 vdout0_31ck164 = 0 time = 1650
* CHECK dout1_0 vdout1_0ck164 = 0 time = 1650
* CHECK dout1_1 vdout1_1ck164 = 0 time = 1650
* CHECK dout1_2 vdout1_2ck164 = 1.8 time = 1650
* CHECK dout1_3 vdout1_3ck164 = 0 time = 1650
* CHECK dout1_4 vdout1_4ck164 = 0 time = 1650
* CHECK dout1_5 vdout1_5ck164 = 0 time = 1650
* CHECK dout1_6 vdout1_6ck164 = 1.8 time = 1650
* CHECK dout1_7 vdout1_7ck164 = 1.8 time = 1650
* CHECK dout1_8 vdout1_8ck164 = 0 time = 1650
* CHECK dout1_9 vdout1_9ck164 = 1.8 time = 1650
* CHECK dout1_10 vdout1_10ck164 = 0 time = 1650
* CHECK dout1_11 vdout1_11ck164 = 1.8 time = 1650
* CHECK dout1_12 vdout1_12ck164 = 1.8 time = 1650
* CHECK dout1_13 vdout1_13ck164 = 0 time = 1650
* CHECK dout1_14 vdout1_14ck164 = 0 time = 1650
* CHECK dout1_15 vdout1_15ck164 = 0 time = 1650
* CHECK dout1_16 vdout1_16ck164 = 1.8 time = 1650
* CHECK dout1_17 vdout1_17ck164 = 0 time = 1650
* CHECK dout1_18 vdout1_18ck164 = 1.8 time = 1650
* CHECK dout1_19 vdout1_19ck164 = 1.8 time = 1650
* CHECK dout1_20 vdout1_20ck164 = 1.8 time = 1650
* CHECK dout1_21 vdout1_21ck164 = 1.8 time = 1650
* CHECK dout1_22 vdout1_22ck164 = 0 time = 1650
* CHECK dout1_23 vdout1_23ck164 = 0 time = 1650
* CHECK dout1_24 vdout1_24ck164 = 0 time = 1650
* CHECK dout1_25 vdout1_25ck164 = 0 time = 1650
* CHECK dout1_26 vdout1_26ck164 = 0 time = 1650
* CHECK dout1_27 vdout1_27ck164 = 1.8 time = 1650
* CHECK dout1_28 vdout1_28ck164 = 1.8 time = 1650
* CHECK dout1_29 vdout1_29ck164 = 1.8 time = 1650
* CHECK dout1_30 vdout1_30ck164 = 0 time = 1650
* CHECK dout1_31 vdout1_31ck164 = 0 time = 1650
* CHECK dout1_0 vdout1_0ck165 = 1.8 time = 1660
* CHECK dout1_1 vdout1_1ck165 = 1.8 time = 1660
* CHECK dout1_2 vdout1_2ck165 = 1.8 time = 1660
* CHECK dout1_3 vdout1_3ck165 = 0 time = 1660
* CHECK dout1_4 vdout1_4ck165 = 0 time = 1660
* CHECK dout1_5 vdout1_5ck165 = 0 time = 1660
* CHECK dout1_6 vdout1_6ck165 = 0 time = 1660
* CHECK dout1_7 vdout1_7ck165 = 0 time = 1660
* CHECK dout1_8 vdout1_8ck165 = 0 time = 1660
* CHECK dout1_9 vdout1_9ck165 = 0 time = 1660
* CHECK dout1_10 vdout1_10ck165 = 1.8 time = 1660
* CHECK dout1_11 vdout1_11ck165 = 0 time = 1660
* CHECK dout1_12 vdout1_12ck165 = 0 time = 1660
* CHECK dout1_13 vdout1_13ck165 = 0 time = 1660
* CHECK dout1_14 vdout1_14ck165 = 1.8 time = 1660
* CHECK dout1_15 vdout1_15ck165 = 0 time = 1660
* CHECK dout1_16 vdout1_16ck165 = 1.8 time = 1660
* CHECK dout1_17 vdout1_17ck165 = 1.8 time = 1660
* CHECK dout1_18 vdout1_18ck165 = 0 time = 1660
* CHECK dout1_19 vdout1_19ck165 = 1.8 time = 1660
* CHECK dout1_20 vdout1_20ck165 = 0 time = 1660
* CHECK dout1_21 vdout1_21ck165 = 1.8 time = 1660
* CHECK dout1_22 vdout1_22ck165 = 0 time = 1660
* CHECK dout1_23 vdout1_23ck165 = 0 time = 1660
* CHECK dout1_24 vdout1_24ck165 = 1.8 time = 1660
* CHECK dout1_25 vdout1_25ck165 = 1.8 time = 1660
* CHECK dout1_26 vdout1_26ck165 = 1.8 time = 1660
* CHECK dout1_27 vdout1_27ck165 = 1.8 time = 1660
* CHECK dout1_28 vdout1_28ck165 = 0 time = 1660
* CHECK dout1_29 vdout1_29ck165 = 1.8 time = 1660
* CHECK dout1_30 vdout1_30ck165 = 1.8 time = 1660
* CHECK dout1_31 vdout1_31ck165 = 0 time = 1660
* CHECK dout0_0 vdout0_0ck167 = 1.8 time = 1680
* CHECK dout0_1 vdout0_1ck167 = 1.8 time = 1680
* CHECK dout0_2 vdout0_2ck167 = 1.8 time = 1680
* CHECK dout0_3 vdout0_3ck167 = 0 time = 1680
* CHECK dout0_4 vdout0_4ck167 = 0 time = 1680
* CHECK dout0_5 vdout0_5ck167 = 0 time = 1680
* CHECK dout0_6 vdout0_6ck167 = 0 time = 1680
* CHECK dout0_7 vdout0_7ck167 = 0 time = 1680
* CHECK dout0_8 vdout0_8ck167 = 0 time = 1680
* CHECK dout0_9 vdout0_9ck167 = 0 time = 1680
* CHECK dout0_10 vdout0_10ck167 = 1.8 time = 1680
* CHECK dout0_11 vdout0_11ck167 = 0 time = 1680
* CHECK dout0_12 vdout0_12ck167 = 0 time = 1680
* CHECK dout0_13 vdout0_13ck167 = 0 time = 1680
* CHECK dout0_14 vdout0_14ck167 = 1.8 time = 1680
* CHECK dout0_15 vdout0_15ck167 = 0 time = 1680
* CHECK dout0_16 vdout0_16ck167 = 1.8 time = 1680
* CHECK dout0_17 vdout0_17ck167 = 1.8 time = 1680
* CHECK dout0_18 vdout0_18ck167 = 0 time = 1680
* CHECK dout0_19 vdout0_19ck167 = 1.8 time = 1680
* CHECK dout0_20 vdout0_20ck167 = 0 time = 1680
* CHECK dout0_21 vdout0_21ck167 = 1.8 time = 1680
* CHECK dout0_22 vdout0_22ck167 = 0 time = 1680
* CHECK dout0_23 vdout0_23ck167 = 0 time = 1680
* CHECK dout0_24 vdout0_24ck167 = 1.8 time = 1680
* CHECK dout0_25 vdout0_25ck167 = 1.8 time = 1680
* CHECK dout0_26 vdout0_26ck167 = 1.8 time = 1680
* CHECK dout0_27 vdout0_27ck167 = 1.8 time = 1680
* CHECK dout0_28 vdout0_28ck167 = 0 time = 1680
* CHECK dout0_29 vdout0_29ck167 = 1.8 time = 1680
* CHECK dout0_30 vdout0_30ck167 = 1.8 time = 1680
* CHECK dout0_31 vdout0_31ck167 = 0 time = 1680
* CHECK dout1_0 vdout1_0ck168 = 1.8 time = 1690
* CHECK dout1_1 vdout1_1ck168 = 1.8 time = 1690
* CHECK dout1_2 vdout1_2ck168 = 0 time = 1690
* CHECK dout1_3 vdout1_3ck168 = 0 time = 1690
* CHECK dout1_4 vdout1_4ck168 = 1.8 time = 1690
* CHECK dout1_5 vdout1_5ck168 = 1.8 time = 1690
* CHECK dout1_6 vdout1_6ck168 = 0 time = 1690
* CHECK dout1_7 vdout1_7ck168 = 0 time = 1690
* CHECK dout1_8 vdout1_8ck168 = 0 time = 1690
* CHECK dout1_9 vdout1_9ck168 = 0 time = 1690
* CHECK dout1_10 vdout1_10ck168 = 1.8 time = 1690
* CHECK dout1_11 vdout1_11ck168 = 1.8 time = 1690
* CHECK dout1_12 vdout1_12ck168 = 1.8 time = 1690
* CHECK dout1_13 vdout1_13ck168 = 0 time = 1690
* CHECK dout1_14 vdout1_14ck168 = 0 time = 1690
* CHECK dout1_15 vdout1_15ck168 = 0 time = 1690
* CHECK dout1_16 vdout1_16ck168 = 0 time = 1690
* CHECK dout1_17 vdout1_17ck168 = 1.8 time = 1690
* CHECK dout1_18 vdout1_18ck168 = 0 time = 1690
* CHECK dout1_19 vdout1_19ck168 = 0 time = 1690
* CHECK dout1_20 vdout1_20ck168 = 0 time = 1690
* CHECK dout1_21 vdout1_21ck168 = 1.8 time = 1690
* CHECK dout1_22 vdout1_22ck168 = 0 time = 1690
* CHECK dout1_23 vdout1_23ck168 = 1.8 time = 1690
* CHECK dout1_24 vdout1_24ck168 = 0 time = 1690
* CHECK dout1_25 vdout1_25ck168 = 0 time = 1690
* CHECK dout1_26 vdout1_26ck168 = 0 time = 1690
* CHECK dout1_27 vdout1_27ck168 = 0 time = 1690
* CHECK dout1_28 vdout1_28ck168 = 0 time = 1690
* CHECK dout1_29 vdout1_29ck168 = 0 time = 1690
* CHECK dout1_30 vdout1_30ck168 = 0 time = 1690
* CHECK dout1_31 vdout1_31ck168 = 1.8 time = 1690
* CHECK dout0_0 vdout0_0ck170 = 0 time = 1710
* CHECK dout0_1 vdout0_1ck170 = 0 time = 1710
* CHECK dout0_2 vdout0_2ck170 = 1.8 time = 1710
* CHECK dout0_3 vdout0_3ck170 = 0 time = 1710
* CHECK dout0_4 vdout0_4ck170 = 0 time = 1710
* CHECK dout0_5 vdout0_5ck170 = 0 time = 1710
* CHECK dout0_6 vdout0_6ck170 = 1.8 time = 1710
* CHECK dout0_7 vdout0_7ck170 = 1.8 time = 1710
* CHECK dout0_8 vdout0_8ck170 = 0 time = 1710
* CHECK dout0_9 vdout0_9ck170 = 1.8 time = 1710
* CHECK dout0_10 vdout0_10ck170 = 0 time = 1710
* CHECK dout0_11 vdout0_11ck170 = 1.8 time = 1710
* CHECK dout0_12 vdout0_12ck170 = 1.8 time = 1710
* CHECK dout0_13 vdout0_13ck170 = 0 time = 1710
* CHECK dout0_14 vdout0_14ck170 = 0 time = 1710
* CHECK dout0_15 vdout0_15ck170 = 0 time = 1710
* CHECK dout0_16 vdout0_16ck170 = 1.8 time = 1710
* CHECK dout0_17 vdout0_17ck170 = 0 time = 1710
* CHECK dout0_18 vdout0_18ck170 = 1.8 time = 1710
* CHECK dout0_19 vdout0_19ck170 = 1.8 time = 1710
* CHECK dout0_20 vdout0_20ck170 = 1.8 time = 1710
* CHECK dout0_21 vdout0_21ck170 = 1.8 time = 1710
* CHECK dout0_22 vdout0_22ck170 = 0 time = 1710
* CHECK dout0_23 vdout0_23ck170 = 0 time = 1710
* CHECK dout0_24 vdout0_24ck170 = 0 time = 1710
* CHECK dout0_25 vdout0_25ck170 = 0 time = 1710
* CHECK dout0_26 vdout0_26ck170 = 0 time = 1710
* CHECK dout0_27 vdout0_27ck170 = 1.8 time = 1710
* CHECK dout0_28 vdout0_28ck170 = 1.8 time = 1710
* CHECK dout0_29 vdout0_29ck170 = 1.8 time = 1710
* CHECK dout0_30 vdout0_30ck170 = 0 time = 1710
* CHECK dout0_31 vdout0_31ck170 = 0 time = 1710
* CHECK dout1_0 vdout1_0ck170 = 0 time = 1710
* CHECK dout1_1 vdout1_1ck170 = 0 time = 1710
* CHECK dout1_2 vdout1_2ck170 = 0 time = 1710
* CHECK dout1_3 vdout1_3ck170 = 1.8 time = 1710
* CHECK dout1_4 vdout1_4ck170 = 0 time = 1710
* CHECK dout1_5 vdout1_5ck170 = 1.8 time = 1710
* CHECK dout1_6 vdout1_6ck170 = 0 time = 1710
* CHECK dout1_7 vdout1_7ck170 = 1.8 time = 1710
* CHECK dout1_8 vdout1_8ck170 = 1.8 time = 1710
* CHECK dout1_9 vdout1_9ck170 = 1.8 time = 1710
* CHECK dout1_10 vdout1_10ck170 = 0 time = 1710
* CHECK dout1_11 vdout1_11ck170 = 1.8 time = 1710
* CHECK dout1_12 vdout1_12ck170 = 0 time = 1710
* CHECK dout1_13 vdout1_13ck170 = 0 time = 1710
* CHECK dout1_14 vdout1_14ck170 = 1.8 time = 1710
* CHECK dout1_15 vdout1_15ck170 = 1.8 time = 1710
* CHECK dout1_16 vdout1_16ck170 = 0 time = 1710
* CHECK dout1_17 vdout1_17ck170 = 1.8 time = 1710
* CHECK dout1_18 vdout1_18ck170 = 1.8 time = 1710
* CHECK dout1_19 vdout1_19ck170 = 0 time = 1710
* CHECK dout1_20 vdout1_20ck170 = 0 time = 1710
* CHECK dout1_21 vdout1_21ck170 = 1.8 time = 1710
* CHECK dout1_22 vdout1_22ck170 = 0 time = 1710
* CHECK dout1_23 vdout1_23ck170 = 1.8 time = 1710
* CHECK dout1_24 vdout1_24ck170 = 1.8 time = 1710
* CHECK dout1_25 vdout1_25ck170 = 0 time = 1710
* CHECK dout1_26 vdout1_26ck170 = 1.8 time = 1710
* CHECK dout1_27 vdout1_27ck170 = 0 time = 1710
* CHECK dout1_28 vdout1_28ck170 = 0 time = 1710
* CHECK dout1_29 vdout1_29ck170 = 1.8 time = 1710
* CHECK dout1_30 vdout1_30ck170 = 1.8 time = 1710
* CHECK dout1_31 vdout1_31ck170 = 1.8 time = 1710
* CHECK dout1_0 vdout1_0ck171 = 0 time = 1720
* CHECK dout1_1 vdout1_1ck171 = 0 time = 1720
* CHECK dout1_2 vdout1_2ck171 = 1.8 time = 1720
* CHECK dout1_3 vdout1_3ck171 = 0 time = 1720
* CHECK dout1_4 vdout1_4ck171 = 0 time = 1720
* CHECK dout1_5 vdout1_5ck171 = 0 time = 1720
* CHECK dout1_6 vdout1_6ck171 = 1.8 time = 1720
* CHECK dout1_7 vdout1_7ck171 = 1.8 time = 1720
* CHECK dout1_8 vdout1_8ck171 = 0 time = 1720
* CHECK dout1_9 vdout1_9ck171 = 1.8 time = 1720
* CHECK dout1_10 vdout1_10ck171 = 0 time = 1720
* CHECK dout1_11 vdout1_11ck171 = 1.8 time = 1720
* CHECK dout1_12 vdout1_12ck171 = 1.8 time = 1720
* CHECK dout1_13 vdout1_13ck171 = 0 time = 1720
* CHECK dout1_14 vdout1_14ck171 = 0 time = 1720
* CHECK dout1_15 vdout1_15ck171 = 0 time = 1720
* CHECK dout1_16 vdout1_16ck171 = 1.8 time = 1720
* CHECK dout1_17 vdout1_17ck171 = 0 time = 1720
* CHECK dout1_18 vdout1_18ck171 = 1.8 time = 1720
* CHECK dout1_19 vdout1_19ck171 = 1.8 time = 1720
* CHECK dout1_20 vdout1_20ck171 = 1.8 time = 1720
* CHECK dout1_21 vdout1_21ck171 = 1.8 time = 1720
* CHECK dout1_22 vdout1_22ck171 = 0 time = 1720
* CHECK dout1_23 vdout1_23ck171 = 0 time = 1720
* CHECK dout1_24 vdout1_24ck171 = 0 time = 1720
* CHECK dout1_25 vdout1_25ck171 = 0 time = 1720
* CHECK dout1_26 vdout1_26ck171 = 0 time = 1720
* CHECK dout1_27 vdout1_27ck171 = 1.8 time = 1720
* CHECK dout1_28 vdout1_28ck171 = 1.8 time = 1720
* CHECK dout1_29 vdout1_29ck171 = 1.8 time = 1720
* CHECK dout1_30 vdout1_30ck171 = 0 time = 1720
* CHECK dout1_31 vdout1_31ck171 = 0 time = 1720
* CHECK dout0_0 vdout0_0ck172 = 0 time = 1730
* CHECK dout0_1 vdout0_1ck172 = 0 time = 1730
* CHECK dout0_2 vdout0_2ck172 = 1.8 time = 1730
* CHECK dout0_3 vdout0_3ck172 = 0 time = 1730
* CHECK dout0_4 vdout0_4ck172 = 0 time = 1730
* CHECK dout0_5 vdout0_5ck172 = 0 time = 1730
* CHECK dout0_6 vdout0_6ck172 = 1.8 time = 1730
* CHECK dout0_7 vdout0_7ck172 = 1.8 time = 1730
* CHECK dout0_8 vdout0_8ck172 = 0 time = 1730
* CHECK dout0_9 vdout0_9ck172 = 1.8 time = 1730
* CHECK dout0_10 vdout0_10ck172 = 0 time = 1730
* CHECK dout0_11 vdout0_11ck172 = 1.8 time = 1730
* CHECK dout0_12 vdout0_12ck172 = 1.8 time = 1730
* CHECK dout0_13 vdout0_13ck172 = 0 time = 1730
* CHECK dout0_14 vdout0_14ck172 = 0 time = 1730
* CHECK dout0_15 vdout0_15ck172 = 0 time = 1730
* CHECK dout0_16 vdout0_16ck172 = 1.8 time = 1730
* CHECK dout0_17 vdout0_17ck172 = 0 time = 1730
* CHECK dout0_18 vdout0_18ck172 = 1.8 time = 1730
* CHECK dout0_19 vdout0_19ck172 = 1.8 time = 1730
* CHECK dout0_20 vdout0_20ck172 = 1.8 time = 1730
* CHECK dout0_21 vdout0_21ck172 = 1.8 time = 1730
* CHECK dout0_22 vdout0_22ck172 = 0 time = 1730
* CHECK dout0_23 vdout0_23ck172 = 0 time = 1730
* CHECK dout0_24 vdout0_24ck172 = 0 time = 1730
* CHECK dout0_25 vdout0_25ck172 = 0 time = 1730
* CHECK dout0_26 vdout0_26ck172 = 0 time = 1730
* CHECK dout0_27 vdout0_27ck172 = 1.8 time = 1730
* CHECK dout0_28 vdout0_28ck172 = 1.8 time = 1730
* CHECK dout0_29 vdout0_29ck172 = 1.8 time = 1730
* CHECK dout0_30 vdout0_30ck172 = 0 time = 1730
* CHECK dout0_31 vdout0_31ck172 = 0 time = 1730
* CHECK dout1_0 vdout1_0ck172 = 1.8 time = 1730
* CHECK dout1_1 vdout1_1ck172 = 1.8 time = 1730
* CHECK dout1_2 vdout1_2ck172 = 1.8 time = 1730
* CHECK dout1_3 vdout1_3ck172 = 0 time = 1730
* CHECK dout1_4 vdout1_4ck172 = 0 time = 1730
* CHECK dout1_5 vdout1_5ck172 = 0 time = 1730
* CHECK dout1_6 vdout1_6ck172 = 0 time = 1730
* CHECK dout1_7 vdout1_7ck172 = 0 time = 1730
* CHECK dout1_8 vdout1_8ck172 = 0 time = 1730
* CHECK dout1_9 vdout1_9ck172 = 0 time = 1730
* CHECK dout1_10 vdout1_10ck172 = 1.8 time = 1730
* CHECK dout1_11 vdout1_11ck172 = 0 time = 1730
* CHECK dout1_12 vdout1_12ck172 = 0 time = 1730
* CHECK dout1_13 vdout1_13ck172 = 0 time = 1730
* CHECK dout1_14 vdout1_14ck172 = 1.8 time = 1730
* CHECK dout1_15 vdout1_15ck172 = 0 time = 1730
* CHECK dout1_16 vdout1_16ck172 = 1.8 time = 1730
* CHECK dout1_17 vdout1_17ck172 = 1.8 time = 1730
* CHECK dout1_18 vdout1_18ck172 = 0 time = 1730
* CHECK dout1_19 vdout1_19ck172 = 1.8 time = 1730
* CHECK dout1_20 vdout1_20ck172 = 0 time = 1730
* CHECK dout1_21 vdout1_21ck172 = 1.8 time = 1730
* CHECK dout1_22 vdout1_22ck172 = 0 time = 1730
* CHECK dout1_23 vdout1_23ck172 = 0 time = 1730
* CHECK dout1_24 vdout1_24ck172 = 1.8 time = 1730
* CHECK dout1_25 vdout1_25ck172 = 1.8 time = 1730
* CHECK dout1_26 vdout1_26ck172 = 1.8 time = 1730
* CHECK dout1_27 vdout1_27ck172 = 1.8 time = 1730
* CHECK dout1_28 vdout1_28ck172 = 0 time = 1730
* CHECK dout1_29 vdout1_29ck172 = 1.8 time = 1730
* CHECK dout1_30 vdout1_30ck172 = 1.8 time = 1730
* CHECK dout1_31 vdout1_31ck172 = 0 time = 1730
* CHECK dout0_0 vdout0_0ck174 = 0 time = 1750
* CHECK dout0_1 vdout0_1ck174 = 1.8 time = 1750
* CHECK dout0_2 vdout0_2ck174 = 1.8 time = 1750
* CHECK dout0_3 vdout0_3ck174 = 1.8 time = 1750
* CHECK dout0_4 vdout0_4ck174 = 0 time = 1750
* CHECK dout0_5 vdout0_5ck174 = 1.8 time = 1750
* CHECK dout0_6 vdout0_6ck174 = 0 time = 1750
* CHECK dout0_7 vdout0_7ck174 = 1.8 time = 1750
* CHECK dout0_8 vdout0_8ck174 = 1.8 time = 1750
* CHECK dout0_9 vdout0_9ck174 = 0 time = 1750
* CHECK dout0_10 vdout0_10ck174 = 0 time = 1750
* CHECK dout0_11 vdout0_11ck174 = 0 time = 1750
* CHECK dout0_12 vdout0_12ck174 = 0 time = 1750
* CHECK dout0_13 vdout0_13ck174 = 1.8 time = 1750
* CHECK dout0_14 vdout0_14ck174 = 1.8 time = 1750
* CHECK dout0_15 vdout0_15ck174 = 1.8 time = 1750
* CHECK dout0_16 vdout0_16ck174 = 1.8 time = 1750
* CHECK dout0_17 vdout0_17ck174 = 0 time = 1750
* CHECK dout0_18 vdout0_18ck174 = 0 time = 1750
* CHECK dout0_19 vdout0_19ck174 = 0 time = 1750
* CHECK dout0_20 vdout0_20ck174 = 0 time = 1750
* CHECK dout0_21 vdout0_21ck174 = 0 time = 1750
* CHECK dout0_22 vdout0_22ck174 = 0 time = 1750
* CHECK dout0_23 vdout0_23ck174 = 1.8 time = 1750
* CHECK dout0_24 vdout0_24ck174 = 1.8 time = 1750
* CHECK dout0_25 vdout0_25ck174 = 1.8 time = 1750
* CHECK dout0_26 vdout0_26ck174 = 0 time = 1750
* CHECK dout0_27 vdout0_27ck174 = 1.8 time = 1750
* CHECK dout0_28 vdout0_28ck174 = 0 time = 1750
* CHECK dout0_29 vdout0_29ck174 = 0 time = 1750
* CHECK dout0_30 vdout0_30ck174 = 1.8 time = 1750
* CHECK dout0_31 vdout0_31ck174 = 0 time = 1750
* CHECK dout1_0 vdout1_0ck174 = 0 time = 1750
* CHECK dout1_1 vdout1_1ck174 = 1.8 time = 1750
* CHECK dout1_2 vdout1_2ck174 = 1.8 time = 1750
* CHECK dout1_3 vdout1_3ck174 = 1.8 time = 1750
* CHECK dout1_4 vdout1_4ck174 = 0 time = 1750
* CHECK dout1_5 vdout1_5ck174 = 1.8 time = 1750
* CHECK dout1_6 vdout1_6ck174 = 0 time = 1750
* CHECK dout1_7 vdout1_7ck174 = 1.8 time = 1750
* CHECK dout1_8 vdout1_8ck174 = 1.8 time = 1750
* CHECK dout1_9 vdout1_9ck174 = 0 time = 1750
* CHECK dout1_10 vdout1_10ck174 = 0 time = 1750
* CHECK dout1_11 vdout1_11ck174 = 0 time = 1750
* CHECK dout1_12 vdout1_12ck174 = 0 time = 1750
* CHECK dout1_13 vdout1_13ck174 = 1.8 time = 1750
* CHECK dout1_14 vdout1_14ck174 = 1.8 time = 1750
* CHECK dout1_15 vdout1_15ck174 = 1.8 time = 1750
* CHECK dout1_16 vdout1_16ck174 = 1.8 time = 1750
* CHECK dout1_17 vdout1_17ck174 = 0 time = 1750
* CHECK dout1_18 vdout1_18ck174 = 0 time = 1750
* CHECK dout1_19 vdout1_19ck174 = 0 time = 1750
* CHECK dout1_20 vdout1_20ck174 = 0 time = 1750
* CHECK dout1_21 vdout1_21ck174 = 0 time = 1750
* CHECK dout1_22 vdout1_22ck174 = 0 time = 1750
* CHECK dout1_23 vdout1_23ck174 = 1.8 time = 1750
* CHECK dout1_24 vdout1_24ck174 = 1.8 time = 1750
* CHECK dout1_25 vdout1_25ck174 = 1.8 time = 1750
* CHECK dout1_26 vdout1_26ck174 = 0 time = 1750
* CHECK dout1_27 vdout1_27ck174 = 1.8 time = 1750
* CHECK dout1_28 vdout1_28ck174 = 0 time = 1750
* CHECK dout1_29 vdout1_29ck174 = 0 time = 1750
* CHECK dout1_30 vdout1_30ck174 = 1.8 time = 1750
* CHECK dout1_31 vdout1_31ck174 = 0 time = 1750
* CHECK dout0_0 vdout0_0ck175 = 1.8 time = 1760
* CHECK dout0_1 vdout0_1ck175 = 1.8 time = 1760
* CHECK dout0_2 vdout0_2ck175 = 0 time = 1760
* CHECK dout0_3 vdout0_3ck175 = 0 time = 1760
* CHECK dout0_4 vdout0_4ck175 = 0 time = 1760
* CHECK dout0_5 vdout0_5ck175 = 1.8 time = 1760
* CHECK dout0_6 vdout0_6ck175 = 1.8 time = 1760
* CHECK dout0_7 vdout0_7ck175 = 1.8 time = 1760
* CHECK dout0_8 vdout0_8ck175 = 1.8 time = 1760
* CHECK dout0_9 vdout0_9ck175 = 1.8 time = 1760
* CHECK dout0_10 vdout0_10ck175 = 1.8 time = 1760
* CHECK dout0_11 vdout0_11ck175 = 1.8 time = 1760
* CHECK dout0_12 vdout0_12ck175 = 1.8 time = 1760
* CHECK dout0_13 vdout0_13ck175 = 1.8 time = 1760
* CHECK dout0_14 vdout0_14ck175 = 1.8 time = 1760
* CHECK dout0_15 vdout0_15ck175 = 1.8 time = 1760
* CHECK dout0_16 vdout0_16ck175 = 0 time = 1760
* CHECK dout0_17 vdout0_17ck175 = 0 time = 1760
* CHECK dout0_18 vdout0_18ck175 = 1.8 time = 1760
* CHECK dout0_19 vdout0_19ck175 = 0 time = 1760
* CHECK dout0_20 vdout0_20ck175 = 0 time = 1760
* CHECK dout0_21 vdout0_21ck175 = 1.8 time = 1760
* CHECK dout0_22 vdout0_22ck175 = 1.8 time = 1760
* CHECK dout0_23 vdout0_23ck175 = 1.8 time = 1760
* CHECK dout0_24 vdout0_24ck175 = 0 time = 1760
* CHECK dout0_25 vdout0_25ck175 = 1.8 time = 1760
* CHECK dout0_26 vdout0_26ck175 = 0 time = 1760
* CHECK dout0_27 vdout0_27ck175 = 1.8 time = 1760
* CHECK dout0_28 vdout0_28ck175 = 1.8 time = 1760
* CHECK dout0_29 vdout0_29ck175 = 1.8 time = 1760
* CHECK dout0_30 vdout0_30ck175 = 0 time = 1760
* CHECK dout0_31 vdout0_31ck175 = 0 time = 1760
* CHECK dout1_0 vdout1_0ck175 = 1.8 time = 1760
* CHECK dout1_1 vdout1_1ck175 = 1.8 time = 1760
* CHECK dout1_2 vdout1_2ck175 = 1.8 time = 1760
* CHECK dout1_3 vdout1_3ck175 = 0 time = 1760
* CHECK dout1_4 vdout1_4ck175 = 0 time = 1760
* CHECK dout1_5 vdout1_5ck175 = 0 time = 1760
* CHECK dout1_6 vdout1_6ck175 = 0 time = 1760
* CHECK dout1_7 vdout1_7ck175 = 0 time = 1760
* CHECK dout1_8 vdout1_8ck175 = 0 time = 1760
* CHECK dout1_9 vdout1_9ck175 = 0 time = 1760
* CHECK dout1_10 vdout1_10ck175 = 1.8 time = 1760
* CHECK dout1_11 vdout1_11ck175 = 0 time = 1760
* CHECK dout1_12 vdout1_12ck175 = 0 time = 1760
* CHECK dout1_13 vdout1_13ck175 = 0 time = 1760
* CHECK dout1_14 vdout1_14ck175 = 1.8 time = 1760
* CHECK dout1_15 vdout1_15ck175 = 0 time = 1760
* CHECK dout1_16 vdout1_16ck175 = 1.8 time = 1760
* CHECK dout1_17 vdout1_17ck175 = 1.8 time = 1760
* CHECK dout1_18 vdout1_18ck175 = 0 time = 1760
* CHECK dout1_19 vdout1_19ck175 = 1.8 time = 1760
* CHECK dout1_20 vdout1_20ck175 = 0 time = 1760
* CHECK dout1_21 vdout1_21ck175 = 1.8 time = 1760
* CHECK dout1_22 vdout1_22ck175 = 0 time = 1760
* CHECK dout1_23 vdout1_23ck175 = 0 time = 1760
* CHECK dout1_24 vdout1_24ck175 = 1.8 time = 1760
* CHECK dout1_25 vdout1_25ck175 = 1.8 time = 1760
* CHECK dout1_26 vdout1_26ck175 = 1.8 time = 1760
* CHECK dout1_27 vdout1_27ck175 = 1.8 time = 1760
* CHECK dout1_28 vdout1_28ck175 = 0 time = 1760
* CHECK dout1_29 vdout1_29ck175 = 1.8 time = 1760
* CHECK dout1_30 vdout1_30ck175 = 1.8 time = 1760
* CHECK dout1_31 vdout1_31ck175 = 0 time = 1760
* CHECK dout0_0 vdout0_0ck176 = 0 time = 1770
* CHECK dout0_1 vdout0_1ck176 = 1.8 time = 1770
* CHECK dout0_2 vdout0_2ck176 = 1.8 time = 1770
* CHECK dout0_3 vdout0_3ck176 = 1.8 time = 1770
* CHECK dout0_4 vdout0_4ck176 = 0 time = 1770
* CHECK dout0_5 vdout0_5ck176 = 1.8 time = 1770
* CHECK dout0_6 vdout0_6ck176 = 0 time = 1770
* CHECK dout0_7 vdout0_7ck176 = 1.8 time = 1770
* CHECK dout0_8 vdout0_8ck176 = 1.8 time = 1770
* CHECK dout0_9 vdout0_9ck176 = 0 time = 1770
* CHECK dout0_10 vdout0_10ck176 = 0 time = 1770
* CHECK dout0_11 vdout0_11ck176 = 0 time = 1770
* CHECK dout0_12 vdout0_12ck176 = 0 time = 1770
* CHECK dout0_13 vdout0_13ck176 = 1.8 time = 1770
* CHECK dout0_14 vdout0_14ck176 = 1.8 time = 1770
* CHECK dout0_15 vdout0_15ck176 = 1.8 time = 1770
* CHECK dout0_16 vdout0_16ck176 = 1.8 time = 1770
* CHECK dout0_17 vdout0_17ck176 = 0 time = 1770
* CHECK dout0_18 vdout0_18ck176 = 0 time = 1770
* CHECK dout0_19 vdout0_19ck176 = 0 time = 1770
* CHECK dout0_20 vdout0_20ck176 = 0 time = 1770
* CHECK dout0_21 vdout0_21ck176 = 0 time = 1770
* CHECK dout0_22 vdout0_22ck176 = 0 time = 1770
* CHECK dout0_23 vdout0_23ck176 = 1.8 time = 1770
* CHECK dout0_24 vdout0_24ck176 = 1.8 time = 1770
* CHECK dout0_25 vdout0_25ck176 = 1.8 time = 1770
* CHECK dout0_26 vdout0_26ck176 = 0 time = 1770
* CHECK dout0_27 vdout0_27ck176 = 1.8 time = 1770
* CHECK dout0_28 vdout0_28ck176 = 0 time = 1770
* CHECK dout0_29 vdout0_29ck176 = 0 time = 1770
* CHECK dout0_30 vdout0_30ck176 = 1.8 time = 1770
* CHECK dout0_31 vdout0_31ck176 = 0 time = 1770
* CHECK dout1_0 vdout1_0ck176 = 1.8 time = 1770
* CHECK dout1_1 vdout1_1ck176 = 1.8 time = 1770
* CHECK dout1_2 vdout1_2ck176 = 0 time = 1770
* CHECK dout1_3 vdout1_3ck176 = 0 time = 1770
* CHECK dout1_4 vdout1_4ck176 = 0 time = 1770
* CHECK dout1_5 vdout1_5ck176 = 1.8 time = 1770
* CHECK dout1_6 vdout1_6ck176 = 1.8 time = 1770
* CHECK dout1_7 vdout1_7ck176 = 1.8 time = 1770
* CHECK dout1_8 vdout1_8ck176 = 1.8 time = 1770
* CHECK dout1_9 vdout1_9ck176 = 1.8 time = 1770
* CHECK dout1_10 vdout1_10ck176 = 1.8 time = 1770
* CHECK dout1_11 vdout1_11ck176 = 1.8 time = 1770
* CHECK dout1_12 vdout1_12ck176 = 1.8 time = 1770
* CHECK dout1_13 vdout1_13ck176 = 1.8 time = 1770
* CHECK dout1_14 vdout1_14ck176 = 1.8 time = 1770
* CHECK dout1_15 vdout1_15ck176 = 1.8 time = 1770
* CHECK dout1_16 vdout1_16ck176 = 0 time = 1770
* CHECK dout1_17 vdout1_17ck176 = 0 time = 1770
* CHECK dout1_18 vdout1_18ck176 = 1.8 time = 1770
* CHECK dout1_19 vdout1_19ck176 = 0 time = 1770
* CHECK dout1_20 vdout1_20ck176 = 0 time = 1770
* CHECK dout1_21 vdout1_21ck176 = 1.8 time = 1770
* CHECK dout1_22 vdout1_22ck176 = 1.8 time = 1770
* CHECK dout1_23 vdout1_23ck176 = 1.8 time = 1770
* CHECK dout1_24 vdout1_24ck176 = 0 time = 1770
* CHECK dout1_25 vdout1_25ck176 = 1.8 time = 1770
* CHECK dout1_26 vdout1_26ck176 = 0 time = 1770
* CHECK dout1_27 vdout1_27ck176 = 1.8 time = 1770
* CHECK dout1_28 vdout1_28ck176 = 1.8 time = 1770
* CHECK dout1_29 vdout1_29ck176 = 1.8 time = 1770
* CHECK dout1_30 vdout1_30ck176 = 0 time = 1770
* CHECK dout1_31 vdout1_31ck176 = 0 time = 1770
* CHECK dout0_0 vdout0_0ck177 = 0 time = 1780
* CHECK dout0_1 vdout0_1ck177 = 1.8 time = 1780
* CHECK dout0_2 vdout0_2ck177 = 1.8 time = 1780
* CHECK dout0_3 vdout0_3ck177 = 1.8 time = 1780
* CHECK dout0_4 vdout0_4ck177 = 0 time = 1780
* CHECK dout0_5 vdout0_5ck177 = 1.8 time = 1780
* CHECK dout0_6 vdout0_6ck177 = 0 time = 1780
* CHECK dout0_7 vdout0_7ck177 = 1.8 time = 1780
* CHECK dout0_8 vdout0_8ck177 = 1.8 time = 1780
* CHECK dout0_9 vdout0_9ck177 = 0 time = 1780
* CHECK dout0_10 vdout0_10ck177 = 0 time = 1780
* CHECK dout0_11 vdout0_11ck177 = 0 time = 1780
* CHECK dout0_12 vdout0_12ck177 = 0 time = 1780
* CHECK dout0_13 vdout0_13ck177 = 1.8 time = 1780
* CHECK dout0_14 vdout0_14ck177 = 1.8 time = 1780
* CHECK dout0_15 vdout0_15ck177 = 1.8 time = 1780
* CHECK dout0_16 vdout0_16ck177 = 1.8 time = 1780
* CHECK dout0_17 vdout0_17ck177 = 0 time = 1780
* CHECK dout0_18 vdout0_18ck177 = 0 time = 1780
* CHECK dout0_19 vdout0_19ck177 = 0 time = 1780
* CHECK dout0_20 vdout0_20ck177 = 0 time = 1780
* CHECK dout0_21 vdout0_21ck177 = 0 time = 1780
* CHECK dout0_22 vdout0_22ck177 = 0 time = 1780
* CHECK dout0_23 vdout0_23ck177 = 1.8 time = 1780
* CHECK dout0_24 vdout0_24ck177 = 1.8 time = 1780
* CHECK dout0_25 vdout0_25ck177 = 1.8 time = 1780
* CHECK dout0_26 vdout0_26ck177 = 0 time = 1780
* CHECK dout0_27 vdout0_27ck177 = 1.8 time = 1780
* CHECK dout0_28 vdout0_28ck177 = 0 time = 1780
* CHECK dout0_29 vdout0_29ck177 = 0 time = 1780
* CHECK dout0_30 vdout0_30ck177 = 1.8 time = 1780
* CHECK dout0_31 vdout0_31ck177 = 0 time = 1780
* CHECK dout1_0 vdout1_0ck177 = 1.8 time = 1780
* CHECK dout1_1 vdout1_1ck177 = 1.8 time = 1780
* CHECK dout1_2 vdout1_2ck177 = 0 time = 1780
* CHECK dout1_3 vdout1_3ck177 = 0 time = 1780
* CHECK dout1_4 vdout1_4ck177 = 0 time = 1780
* CHECK dout1_5 vdout1_5ck177 = 1.8 time = 1780
* CHECK dout1_6 vdout1_6ck177 = 1.8 time = 1780
* CHECK dout1_7 vdout1_7ck177 = 1.8 time = 1780
* CHECK dout1_8 vdout1_8ck177 = 1.8 time = 1780
* CHECK dout1_9 vdout1_9ck177 = 1.8 time = 1780
* CHECK dout1_10 vdout1_10ck177 = 1.8 time = 1780
* CHECK dout1_11 vdout1_11ck177 = 1.8 time = 1780
* CHECK dout1_12 vdout1_12ck177 = 1.8 time = 1780
* CHECK dout1_13 vdout1_13ck177 = 1.8 time = 1780
* CHECK dout1_14 vdout1_14ck177 = 1.8 time = 1780
* CHECK dout1_15 vdout1_15ck177 = 1.8 time = 1780
* CHECK dout1_16 vdout1_16ck177 = 0 time = 1780
* CHECK dout1_17 vdout1_17ck177 = 0 time = 1780
* CHECK dout1_18 vdout1_18ck177 = 1.8 time = 1780
* CHECK dout1_19 vdout1_19ck177 = 0 time = 1780
* CHECK dout1_20 vdout1_20ck177 = 0 time = 1780
* CHECK dout1_21 vdout1_21ck177 = 1.8 time = 1780
* CHECK dout1_22 vdout1_22ck177 = 1.8 time = 1780
* CHECK dout1_23 vdout1_23ck177 = 1.8 time = 1780
* CHECK dout1_24 vdout1_24ck177 = 0 time = 1780
* CHECK dout1_25 vdout1_25ck177 = 1.8 time = 1780
* CHECK dout1_26 vdout1_26ck177 = 0 time = 1780
* CHECK dout1_27 vdout1_27ck177 = 1.8 time = 1780
* CHECK dout1_28 vdout1_28ck177 = 1.8 time = 1780
* CHECK dout1_29 vdout1_29ck177 = 1.8 time = 1780
* CHECK dout1_30 vdout1_30ck177 = 0 time = 1780
* CHECK dout1_31 vdout1_31ck177 = 0 time = 1780
* CHECK dout0_0 vdout0_0ck179 = 1.8 time = 1800
* CHECK dout0_1 vdout0_1ck179 = 1.8 time = 1800
* CHECK dout0_2 vdout0_2ck179 = 0 time = 1800
* CHECK dout0_3 vdout0_3ck179 = 0 time = 1800
* CHECK dout0_4 vdout0_4ck179 = 0 time = 1800
* CHECK dout0_5 vdout0_5ck179 = 1.8 time = 1800
* CHECK dout0_6 vdout0_6ck179 = 1.8 time = 1800
* CHECK dout0_7 vdout0_7ck179 = 1.8 time = 1800
* CHECK dout0_8 vdout0_8ck179 = 1.8 time = 1800
* CHECK dout0_9 vdout0_9ck179 = 1.8 time = 1800
* CHECK dout0_10 vdout0_10ck179 = 1.8 time = 1800
* CHECK dout0_11 vdout0_11ck179 = 1.8 time = 1800
* CHECK dout0_12 vdout0_12ck179 = 1.8 time = 1800
* CHECK dout0_13 vdout0_13ck179 = 1.8 time = 1800
* CHECK dout0_14 vdout0_14ck179 = 1.8 time = 1800
* CHECK dout0_15 vdout0_15ck179 = 1.8 time = 1800
* CHECK dout0_16 vdout0_16ck179 = 0 time = 1800
* CHECK dout0_17 vdout0_17ck179 = 0 time = 1800
* CHECK dout0_18 vdout0_18ck179 = 1.8 time = 1800
* CHECK dout0_19 vdout0_19ck179 = 0 time = 1800
* CHECK dout0_20 vdout0_20ck179 = 0 time = 1800
* CHECK dout0_21 vdout0_21ck179 = 1.8 time = 1800
* CHECK dout0_22 vdout0_22ck179 = 1.8 time = 1800
* CHECK dout0_23 vdout0_23ck179 = 1.8 time = 1800
* CHECK dout0_24 vdout0_24ck179 = 0 time = 1800
* CHECK dout0_25 vdout0_25ck179 = 1.8 time = 1800
* CHECK dout0_26 vdout0_26ck179 = 0 time = 1800
* CHECK dout0_27 vdout0_27ck179 = 1.8 time = 1800
* CHECK dout0_28 vdout0_28ck179 = 1.8 time = 1800
* CHECK dout0_29 vdout0_29ck179 = 1.8 time = 1800
* CHECK dout0_30 vdout0_30ck179 = 0 time = 1800
* CHECK dout0_31 vdout0_31ck179 = 0 time = 1800
* CHECK dout1_0 vdout1_0ck180 = 0 time = 1810
* CHECK dout1_1 vdout1_1ck180 = 0 time = 1810
* CHECK dout1_2 vdout1_2ck180 = 1.8 time = 1810
* CHECK dout1_3 vdout1_3ck180 = 1.8 time = 1810
* CHECK dout1_4 vdout1_4ck180 = 0 time = 1810
* CHECK dout1_5 vdout1_5ck180 = 1.8 time = 1810
* CHECK dout1_6 vdout1_6ck180 = 1.8 time = 1810
* CHECK dout1_7 vdout1_7ck180 = 1.8 time = 1810
* CHECK dout1_8 vdout1_8ck180 = 0 time = 1810
* CHECK dout1_9 vdout1_9ck180 = 0 time = 1810
* CHECK dout1_10 vdout1_10ck180 = 1.8 time = 1810
* CHECK dout1_11 vdout1_11ck180 = 0 time = 1810
* CHECK dout1_12 vdout1_12ck180 = 1.8 time = 1810
* CHECK dout1_13 vdout1_13ck180 = 1.8 time = 1810
* CHECK dout1_14 vdout1_14ck180 = 0 time = 1810
* CHECK dout1_15 vdout1_15ck180 = 1.8 time = 1810
* CHECK dout1_16 vdout1_16ck180 = 0 time = 1810
* CHECK dout1_17 vdout1_17ck180 = 1.8 time = 1810
* CHECK dout1_18 vdout1_18ck180 = 1.8 time = 1810
* CHECK dout1_19 vdout1_19ck180 = 0 time = 1810
* CHECK dout1_20 vdout1_20ck180 = 1.8 time = 1810
* CHECK dout1_21 vdout1_21ck180 = 1.8 time = 1810
* CHECK dout1_22 vdout1_22ck180 = 0 time = 1810
* CHECK dout1_23 vdout1_23ck180 = 0 time = 1810
* CHECK dout1_24 vdout1_24ck180 = 0 time = 1810
* CHECK dout1_25 vdout1_25ck180 = 1.8 time = 1810
* CHECK dout1_26 vdout1_26ck180 = 1.8 time = 1810
* CHECK dout1_27 vdout1_27ck180 = 1.8 time = 1810
* CHECK dout1_28 vdout1_28ck180 = 0 time = 1810
* CHECK dout1_29 vdout1_29ck180 = 0 time = 1810
* CHECK dout1_30 vdout1_30ck180 = 0 time = 1810
* CHECK dout1_31 vdout1_31ck180 = 1.8 time = 1810
* CHECK dout0_0 vdout0_0ck181 = 0 time = 1820
* CHECK dout0_1 vdout0_1ck181 = 0 time = 1820
* CHECK dout0_2 vdout0_2ck181 = 0 time = 1820
* CHECK dout0_3 vdout0_3ck181 = 1.8 time = 1820
* CHECK dout0_4 vdout0_4ck181 = 1.8 time = 1820
* CHECK dout0_5 vdout0_5ck181 = 0 time = 1820
* CHECK dout0_6 vdout0_6ck181 = 0 time = 1820
* CHECK dout0_7 vdout0_7ck181 = 1.8 time = 1820
* CHECK dout0_8 vdout0_8ck181 = 0 time = 1820
* CHECK dout0_9 vdout0_9ck181 = 0 time = 1820
* CHECK dout0_10 vdout0_10ck181 = 1.8 time = 1820
* CHECK dout0_11 vdout0_11ck181 = 0 time = 1820
* CHECK dout0_12 vdout0_12ck181 = 0 time = 1820
* CHECK dout0_13 vdout0_13ck181 = 1.8 time = 1820
* CHECK dout0_14 vdout0_14ck181 = 0 time = 1820
* CHECK dout0_15 vdout0_15ck181 = 0 time = 1820
* CHECK dout0_16 vdout0_16ck181 = 0 time = 1820
* CHECK dout0_17 vdout0_17ck181 = 0 time = 1820
* CHECK dout0_18 vdout0_18ck181 = 0 time = 1820
* CHECK dout0_19 vdout0_19ck181 = 0 time = 1820
* CHECK dout0_20 vdout0_20ck181 = 0 time = 1820
* CHECK dout0_21 vdout0_21ck181 = 0 time = 1820
* CHECK dout0_22 vdout0_22ck181 = 1.8 time = 1820
* CHECK dout0_23 vdout0_23ck181 = 0 time = 1820
* CHECK dout0_24 vdout0_24ck181 = 0 time = 1820
* CHECK dout0_25 vdout0_25ck181 = 0 time = 1820
* CHECK dout0_26 vdout0_26ck181 = 0 time = 1820
* CHECK dout0_27 vdout0_27ck181 = 0 time = 1820
* CHECK dout0_28 vdout0_28ck181 = 0 time = 1820
* CHECK dout0_29 vdout0_29ck181 = 0 time = 1820
* CHECK dout0_30 vdout0_30ck181 = 0 time = 1820
* CHECK dout0_31 vdout0_31ck181 = 0 time = 1820
* CHECK dout0_0 vdout0_0ck182 = 0 time = 1830
* CHECK dout0_1 vdout0_1ck182 = 0 time = 1830
* CHECK dout0_2 vdout0_2ck182 = 1.8 time = 1830
* CHECK dout0_3 vdout0_3ck182 = 1.8 time = 1830
* CHECK dout0_4 vdout0_4ck182 = 0 time = 1830
* CHECK dout0_5 vdout0_5ck182 = 1.8 time = 1830
* CHECK dout0_6 vdout0_6ck182 = 1.8 time = 1830
* CHECK dout0_7 vdout0_7ck182 = 1.8 time = 1830
* CHECK dout0_8 vdout0_8ck182 = 0 time = 1830
* CHECK dout0_9 vdout0_9ck182 = 0 time = 1830
* CHECK dout0_10 vdout0_10ck182 = 1.8 time = 1830
* CHECK dout0_11 vdout0_11ck182 = 0 time = 1830
* CHECK dout0_12 vdout0_12ck182 = 1.8 time = 1830
* CHECK dout0_13 vdout0_13ck182 = 1.8 time = 1830
* CHECK dout0_14 vdout0_14ck182 = 0 time = 1830
* CHECK dout0_15 vdout0_15ck182 = 1.8 time = 1830
* CHECK dout0_16 vdout0_16ck182 = 0 time = 1830
* CHECK dout0_17 vdout0_17ck182 = 1.8 time = 1830
* CHECK dout0_18 vdout0_18ck182 = 1.8 time = 1830
* CHECK dout0_19 vdout0_19ck182 = 0 time = 1830
* CHECK dout0_20 vdout0_20ck182 = 1.8 time = 1830
* CHECK dout0_21 vdout0_21ck182 = 1.8 time = 1830
* CHECK dout0_22 vdout0_22ck182 = 0 time = 1830
* CHECK dout0_23 vdout0_23ck182 = 0 time = 1830
* CHECK dout0_24 vdout0_24ck182 = 0 time = 1830
* CHECK dout0_25 vdout0_25ck182 = 1.8 time = 1830
* CHECK dout0_26 vdout0_26ck182 = 1.8 time = 1830
* CHECK dout0_27 vdout0_27ck182 = 1.8 time = 1830
* CHECK dout0_28 vdout0_28ck182 = 0 time = 1830
* CHECK dout0_29 vdout0_29ck182 = 0 time = 1830
* CHECK dout0_30 vdout0_30ck182 = 0 time = 1830
* CHECK dout0_31 vdout0_31ck182 = 1.8 time = 1830
* CHECK dout1_0 vdout1_0ck183 = 0 time = 1840
* CHECK dout1_1 vdout1_1ck183 = 1.8 time = 1840
* CHECK dout1_2 vdout1_2ck183 = 0 time = 1840
* CHECK dout1_3 vdout1_3ck183 = 0 time = 1840
* CHECK dout1_4 vdout1_4ck183 = 1.8 time = 1840
* CHECK dout1_5 vdout1_5ck183 = 0 time = 1840
* CHECK dout1_6 vdout1_6ck183 = 0 time = 1840
* CHECK dout1_7 vdout1_7ck183 = 0 time = 1840
* CHECK dout1_8 vdout1_8ck183 = 0 time = 1840
* CHECK dout1_9 vdout1_9ck183 = 0 time = 1840
* CHECK dout1_10 vdout1_10ck183 = 0 time = 1840
* CHECK dout1_11 vdout1_11ck183 = 1.8 time = 1840
* CHECK dout1_12 vdout1_12ck183 = 1.8 time = 1840
* CHECK dout1_13 vdout1_13ck183 = 0 time = 1840
* CHECK dout1_14 vdout1_14ck183 = 1.8 time = 1840
* CHECK dout1_15 vdout1_15ck183 = 1.8 time = 1840
* CHECK dout1_16 vdout1_16ck183 = 1.8 time = 1840
* CHECK dout1_17 vdout1_17ck183 = 0 time = 1840
* CHECK dout1_18 vdout1_18ck183 = 1.8 time = 1840
* CHECK dout1_19 vdout1_19ck183 = 0 time = 1840
* CHECK dout1_20 vdout1_20ck183 = 0 time = 1840
* CHECK dout1_21 vdout1_21ck183 = 1.8 time = 1840
* CHECK dout1_22 vdout1_22ck183 = 1.8 time = 1840
* CHECK dout1_23 vdout1_23ck183 = 1.8 time = 1840
* CHECK dout1_24 vdout1_24ck183 = 1.8 time = 1840
* CHECK dout1_25 vdout1_25ck183 = 1.8 time = 1840
* CHECK dout1_26 vdout1_26ck183 = 1.8 time = 1840
* CHECK dout1_27 vdout1_27ck183 = 0 time = 1840
* CHECK dout1_28 vdout1_28ck183 = 1.8 time = 1840
* CHECK dout1_29 vdout1_29ck183 = 1.8 time = 1840
* CHECK dout1_30 vdout1_30ck183 = 1.8 time = 1840
* CHECK dout1_31 vdout1_31ck183 = 0 time = 1840
* CHECK dout0_0 vdout0_0ck186 = 0 time = 1870
* CHECK dout0_1 vdout0_1ck186 = 0 time = 1870
* CHECK dout0_2 vdout0_2ck186 = 0 time = 1870
* CHECK dout0_3 vdout0_3ck186 = 1.8 time = 1870
* CHECK dout0_4 vdout0_4ck186 = 1.8 time = 1870
* CHECK dout0_5 vdout0_5ck186 = 0 time = 1870
* CHECK dout0_6 vdout0_6ck186 = 0 time = 1870
* CHECK dout0_7 vdout0_7ck186 = 1.8 time = 1870
* CHECK dout0_8 vdout0_8ck186 = 0 time = 1870
* CHECK dout0_9 vdout0_9ck186 = 0 time = 1870
* CHECK dout0_10 vdout0_10ck186 = 1.8 time = 1870
* CHECK dout0_11 vdout0_11ck186 = 0 time = 1870
* CHECK dout0_12 vdout0_12ck186 = 0 time = 1870
* CHECK dout0_13 vdout0_13ck186 = 1.8 time = 1870
* CHECK dout0_14 vdout0_14ck186 = 0 time = 1870
* CHECK dout0_15 vdout0_15ck186 = 0 time = 1870
* CHECK dout0_16 vdout0_16ck186 = 0 time = 1870
* CHECK dout0_17 vdout0_17ck186 = 0 time = 1870
* CHECK dout0_18 vdout0_18ck186 = 0 time = 1870
* CHECK dout0_19 vdout0_19ck186 = 0 time = 1870
* CHECK dout0_20 vdout0_20ck186 = 0 time = 1870
* CHECK dout0_21 vdout0_21ck186 = 0 time = 1870
* CHECK dout0_22 vdout0_22ck186 = 1.8 time = 1870
* CHECK dout0_23 vdout0_23ck186 = 0 time = 1870
* CHECK dout0_24 vdout0_24ck186 = 0 time = 1870
* CHECK dout0_25 vdout0_25ck186 = 0 time = 1870
* CHECK dout0_26 vdout0_26ck186 = 0 time = 1870
* CHECK dout0_27 vdout0_27ck186 = 0 time = 1870
* CHECK dout0_28 vdout0_28ck186 = 0 time = 1870
* CHECK dout0_29 vdout0_29ck186 = 0 time = 1870
* CHECK dout0_30 vdout0_30ck186 = 0 time = 1870
* CHECK dout0_31 vdout0_31ck186 = 0 time = 1870
* CHECK dout0_0 vdout0_0ck187 = 0 time = 1880
* CHECK dout0_1 vdout0_1ck187 = 0 time = 1880
* CHECK dout0_2 vdout0_2ck187 = 0 time = 1880
* CHECK dout0_3 vdout0_3ck187 = 1.8 time = 1880
* CHECK dout0_4 vdout0_4ck187 = 1.8 time = 1880
* CHECK dout0_5 vdout0_5ck187 = 0 time = 1880
* CHECK dout0_6 vdout0_6ck187 = 0 time = 1880
* CHECK dout0_7 vdout0_7ck187 = 1.8 time = 1880
* CHECK dout0_8 vdout0_8ck187 = 0 time = 1880
* CHECK dout0_9 vdout0_9ck187 = 0 time = 1880
* CHECK dout0_10 vdout0_10ck187 = 1.8 time = 1880
* CHECK dout0_11 vdout0_11ck187 = 0 time = 1880
* CHECK dout0_12 vdout0_12ck187 = 0 time = 1880
* CHECK dout0_13 vdout0_13ck187 = 1.8 time = 1880
* CHECK dout0_14 vdout0_14ck187 = 0 time = 1880
* CHECK dout0_15 vdout0_15ck187 = 0 time = 1880
* CHECK dout0_16 vdout0_16ck187 = 0 time = 1880
* CHECK dout0_17 vdout0_17ck187 = 0 time = 1880
* CHECK dout0_18 vdout0_18ck187 = 0 time = 1880
* CHECK dout0_19 vdout0_19ck187 = 0 time = 1880
* CHECK dout0_20 vdout0_20ck187 = 0 time = 1880
* CHECK dout0_21 vdout0_21ck187 = 0 time = 1880
* CHECK dout0_22 vdout0_22ck187 = 1.8 time = 1880
* CHECK dout0_23 vdout0_23ck187 = 0 time = 1880
* CHECK dout0_24 vdout0_24ck187 = 0 time = 1880
* CHECK dout0_25 vdout0_25ck187 = 0 time = 1880
* CHECK dout0_26 vdout0_26ck187 = 0 time = 1880
* CHECK dout0_27 vdout0_27ck187 = 0 time = 1880
* CHECK dout0_28 vdout0_28ck187 = 0 time = 1880
* CHECK dout0_29 vdout0_29ck187 = 0 time = 1880
* CHECK dout0_30 vdout0_30ck187 = 0 time = 1880
* CHECK dout0_31 vdout0_31ck187 = 0 time = 1880
* CHECK dout1_0 vdout1_0ck187 = 0 time = 1880
* CHECK dout1_1 vdout1_1ck187 = 1.8 time = 1880
* CHECK dout1_2 vdout1_2ck187 = 0 time = 1880
* CHECK dout1_3 vdout1_3ck187 = 0 time = 1880
* CHECK dout1_4 vdout1_4ck187 = 1.8 time = 1880
* CHECK dout1_5 vdout1_5ck187 = 1.8 time = 1880
* CHECK dout1_6 vdout1_6ck187 = 0 time = 1880
* CHECK dout1_7 vdout1_7ck187 = 0 time = 1880
* CHECK dout1_8 vdout1_8ck187 = 0 time = 1880
* CHECK dout1_9 vdout1_9ck187 = 0 time = 1880
* CHECK dout1_10 vdout1_10ck187 = 0 time = 1880
* CHECK dout1_11 vdout1_11ck187 = 1.8 time = 1880
* CHECK dout1_12 vdout1_12ck187 = 1.8 time = 1880
* CHECK dout1_13 vdout1_13ck187 = 0 time = 1880
* CHECK dout1_14 vdout1_14ck187 = 1.8 time = 1880
* CHECK dout1_15 vdout1_15ck187 = 0 time = 1880
* CHECK dout1_16 vdout1_16ck187 = 1.8 time = 1880
* CHECK dout1_17 vdout1_17ck187 = 0 time = 1880
* CHECK dout1_18 vdout1_18ck187 = 1.8 time = 1880
* CHECK dout1_19 vdout1_19ck187 = 0 time = 1880
* CHECK dout1_20 vdout1_20ck187 = 0 time = 1880
* CHECK dout1_21 vdout1_21ck187 = 1.8 time = 1880
* CHECK dout1_22 vdout1_22ck187 = 1.8 time = 1880
* CHECK dout1_23 vdout1_23ck187 = 1.8 time = 1880
* CHECK dout1_24 vdout1_24ck187 = 1.8 time = 1880
* CHECK dout1_25 vdout1_25ck187 = 1.8 time = 1880
* CHECK dout1_26 vdout1_26ck187 = 1.8 time = 1880
* CHECK dout1_27 vdout1_27ck187 = 0 time = 1880
* CHECK dout1_28 vdout1_28ck187 = 1.8 time = 1880
* CHECK dout1_29 vdout1_29ck187 = 1.8 time = 1880
* CHECK dout1_30 vdout1_30ck187 = 1.8 time = 1880
* CHECK dout1_31 vdout1_31ck187 = 0 time = 1880
* CHECK dout0_0 vdout0_0ck188 = 1.8 time = 1890
* CHECK dout0_1 vdout0_1ck188 = 1.8 time = 1890
* CHECK dout0_2 vdout0_2ck188 = 1.8 time = 1890
* CHECK dout0_3 vdout0_3ck188 = 0 time = 1890
* CHECK dout0_4 vdout0_4ck188 = 1.8 time = 1890
* CHECK dout0_5 vdout0_5ck188 = 1.8 time = 1890
* CHECK dout0_6 vdout0_6ck188 = 0 time = 1890
* CHECK dout0_7 vdout0_7ck188 = 1.8 time = 1890
* CHECK dout0_8 vdout0_8ck188 = 0 time = 1890
* CHECK dout0_9 vdout0_9ck188 = 1.8 time = 1890
* CHECK dout0_10 vdout0_10ck188 = 0 time = 1890
* CHECK dout0_11 vdout0_11ck188 = 1.8 time = 1890
* CHECK dout0_12 vdout0_12ck188 = 0 time = 1890
* CHECK dout0_13 vdout0_13ck188 = 0 time = 1890
* CHECK dout0_14 vdout0_14ck188 = 0 time = 1890
* CHECK dout0_15 vdout0_15ck188 = 1.8 time = 1890
* CHECK dout0_16 vdout0_16ck188 = 0 time = 1890
* CHECK dout0_17 vdout0_17ck188 = 1.8 time = 1890
* CHECK dout0_18 vdout0_18ck188 = 0 time = 1890
* CHECK dout0_19 vdout0_19ck188 = 1.8 time = 1890
* CHECK dout0_20 vdout0_20ck188 = 1.8 time = 1890
* CHECK dout0_21 vdout0_21ck188 = 0 time = 1890
* CHECK dout0_22 vdout0_22ck188 = 1.8 time = 1890
* CHECK dout0_23 vdout0_23ck188 = 0 time = 1890
* CHECK dout0_24 vdout0_24ck188 = 1.8 time = 1890
* CHECK dout0_25 vdout0_25ck188 = 0 time = 1890
* CHECK dout0_26 vdout0_26ck188 = 0 time = 1890
* CHECK dout0_27 vdout0_27ck188 = 0 time = 1890
* CHECK dout0_28 vdout0_28ck188 = 1.8 time = 1890
* CHECK dout0_29 vdout0_29ck188 = 0 time = 1890
* CHECK dout0_30 vdout0_30ck188 = 1.8 time = 1890
* CHECK dout0_31 vdout0_31ck188 = 0 time = 1890
* CHECK dout1_0 vdout1_0ck189 = 1.8 time = 1900
* CHECK dout1_1 vdout1_1ck189 = 1.8 time = 1900
* CHECK dout1_2 vdout1_2ck189 = 1.8 time = 1900
* CHECK dout1_3 vdout1_3ck189 = 0 time = 1900
* CHECK dout1_4 vdout1_4ck189 = 1.8 time = 1900
* CHECK dout1_5 vdout1_5ck189 = 1.8 time = 1900
* CHECK dout1_6 vdout1_6ck189 = 0 time = 1900
* CHECK dout1_7 vdout1_7ck189 = 1.8 time = 1900
* CHECK dout1_8 vdout1_8ck189 = 0 time = 1900
* CHECK dout1_9 vdout1_9ck189 = 1.8 time = 1900
* CHECK dout1_10 vdout1_10ck189 = 0 time = 1900
* CHECK dout1_11 vdout1_11ck189 = 1.8 time = 1900
* CHECK dout1_12 vdout1_12ck189 = 0 time = 1900
* CHECK dout1_13 vdout1_13ck189 = 0 time = 1900
* CHECK dout1_14 vdout1_14ck189 = 0 time = 1900
* CHECK dout1_15 vdout1_15ck189 = 1.8 time = 1900
* CHECK dout1_16 vdout1_16ck189 = 0 time = 1900
* CHECK dout1_17 vdout1_17ck189 = 1.8 time = 1900
* CHECK dout1_18 vdout1_18ck189 = 0 time = 1900
* CHECK dout1_19 vdout1_19ck189 = 1.8 time = 1900
* CHECK dout1_20 vdout1_20ck189 = 1.8 time = 1900
* CHECK dout1_21 vdout1_21ck189 = 0 time = 1900
* CHECK dout1_22 vdout1_22ck189 = 1.8 time = 1900
* CHECK dout1_23 vdout1_23ck189 = 0 time = 1900
* CHECK dout1_24 vdout1_24ck189 = 1.8 time = 1900
* CHECK dout1_25 vdout1_25ck189 = 0 time = 1900
* CHECK dout1_26 vdout1_26ck189 = 0 time = 1900
* CHECK dout1_27 vdout1_27ck189 = 0 time = 1900
* CHECK dout1_28 vdout1_28ck189 = 1.8 time = 1900
* CHECK dout1_29 vdout1_29ck189 = 0 time = 1900
* CHECK dout1_30 vdout1_30ck189 = 1.8 time = 1900
* CHECK dout1_31 vdout1_31ck189 = 0 time = 1900
* CHECK dout1_0 vdout1_0ck190 = 0 time = 1910
* CHECK dout1_1 vdout1_1ck190 = 1.8 time = 1910
* CHECK dout1_2 vdout1_2ck190 = 0 time = 1910
* CHECK dout1_3 vdout1_3ck190 = 0 time = 1910
* CHECK dout1_4 vdout1_4ck190 = 1.8 time = 1910
* CHECK dout1_5 vdout1_5ck190 = 1.8 time = 1910
* CHECK dout1_6 vdout1_6ck190 = 0 time = 1910
* CHECK dout1_7 vdout1_7ck190 = 0 time = 1910
* CHECK dout1_8 vdout1_8ck190 = 0 time = 1910
* CHECK dout1_9 vdout1_9ck190 = 0 time = 1910
* CHECK dout1_10 vdout1_10ck190 = 0 time = 1910
* CHECK dout1_11 vdout1_11ck190 = 1.8 time = 1910
* CHECK dout1_12 vdout1_12ck190 = 1.8 time = 1910
* CHECK dout1_13 vdout1_13ck190 = 0 time = 1910
* CHECK dout1_14 vdout1_14ck190 = 1.8 time = 1910
* CHECK dout1_15 vdout1_15ck190 = 0 time = 1910
* CHECK dout1_16 vdout1_16ck190 = 1.8 time = 1910
* CHECK dout1_17 vdout1_17ck190 = 0 time = 1910
* CHECK dout1_18 vdout1_18ck190 = 1.8 time = 1910
* CHECK dout1_19 vdout1_19ck190 = 0 time = 1910
* CHECK dout1_20 vdout1_20ck190 = 0 time = 1910
* CHECK dout1_21 vdout1_21ck190 = 1.8 time = 1910
* CHECK dout1_22 vdout1_22ck190 = 1.8 time = 1910
* CHECK dout1_23 vdout1_23ck190 = 1.8 time = 1910
* CHECK dout1_24 vdout1_24ck190 = 1.8 time = 1910
* CHECK dout1_25 vdout1_25ck190 = 1.8 time = 1910
* CHECK dout1_26 vdout1_26ck190 = 1.8 time = 1910
* CHECK dout1_27 vdout1_27ck190 = 0 time = 1910
* CHECK dout1_28 vdout1_28ck190 = 1.8 time = 1910
* CHECK dout1_29 vdout1_29ck190 = 1.8 time = 1910
* CHECK dout1_30 vdout1_30ck190 = 1.8 time = 1910
* CHECK dout1_31 vdout1_31ck190 = 0 time = 1910
* CHECK dout0_0 vdout0_0ck191 = 1.8 time = 1920
* CHECK dout0_1 vdout0_1ck191 = 1.8 time = 1920
* CHECK dout0_2 vdout0_2ck191 = 1.8 time = 1920
* CHECK dout0_3 vdout0_3ck191 = 0 time = 1920
* CHECK dout0_4 vdout0_4ck191 = 1.8 time = 1920
* CHECK dout0_5 vdout0_5ck191 = 1.8 time = 1920
* CHECK dout0_6 vdout0_6ck191 = 0 time = 1920
* CHECK dout0_7 vdout0_7ck191 = 1.8 time = 1920
* CHECK dout0_8 vdout0_8ck191 = 0 time = 1920
* CHECK dout0_9 vdout0_9ck191 = 1.8 time = 1920
* CHECK dout0_10 vdout0_10ck191 = 0 time = 1920
* CHECK dout0_11 vdout0_11ck191 = 1.8 time = 1920
* CHECK dout0_12 vdout0_12ck191 = 0 time = 1920
* CHECK dout0_13 vdout0_13ck191 = 0 time = 1920
* CHECK dout0_14 vdout0_14ck191 = 0 time = 1920
* CHECK dout0_15 vdout0_15ck191 = 1.8 time = 1920
* CHECK dout0_16 vdout0_16ck191 = 0 time = 1920
* CHECK dout0_17 vdout0_17ck191 = 1.8 time = 1920
* CHECK dout0_18 vdout0_18ck191 = 0 time = 1920
* CHECK dout0_19 vdout0_19ck191 = 1.8 time = 1920
* CHECK dout0_20 vdout0_20ck191 = 1.8 time = 1920
* CHECK dout0_21 vdout0_21ck191 = 0 time = 1920
* CHECK dout0_22 vdout0_22ck191 = 1.8 time = 1920
* CHECK dout0_23 vdout0_23ck191 = 0 time = 1920
* CHECK dout0_24 vdout0_24ck191 = 1.8 time = 1920
* CHECK dout0_25 vdout0_25ck191 = 0 time = 1920
* CHECK dout0_26 vdout0_26ck191 = 0 time = 1920
* CHECK dout0_27 vdout0_27ck191 = 0 time = 1920
* CHECK dout0_28 vdout0_28ck191 = 1.8 time = 1920
* CHECK dout0_29 vdout0_29ck191 = 0 time = 1920
* CHECK dout0_30 vdout0_30ck191 = 1.8 time = 1920
* CHECK dout0_31 vdout0_31ck191 = 0 time = 1920
* CHECK dout1_0 vdout1_0ck191 = 0 time = 1920
* CHECK dout1_1 vdout1_1ck191 = 1.8 time = 1920
* CHECK dout1_2 vdout1_2ck191 = 0 time = 1920
* CHECK dout1_3 vdout1_3ck191 = 0 time = 1920
* CHECK dout1_4 vdout1_4ck191 = 1.8 time = 1920
* CHECK dout1_5 vdout1_5ck191 = 1.8 time = 1920
* CHECK dout1_6 vdout1_6ck191 = 0 time = 1920
* CHECK dout1_7 vdout1_7ck191 = 0 time = 1920
* CHECK dout1_8 vdout1_8ck191 = 1.8 time = 1920
* CHECK dout1_9 vdout1_9ck191 = 1.8 time = 1920
* CHECK dout1_10 vdout1_10ck191 = 1.8 time = 1920
* CHECK dout1_11 vdout1_11ck191 = 0 time = 1920
* CHECK dout1_12 vdout1_12ck191 = 0 time = 1920
* CHECK dout1_13 vdout1_13ck191 = 0 time = 1920
* CHECK dout1_14 vdout1_14ck191 = 1.8 time = 1920
* CHECK dout1_15 vdout1_15ck191 = 1.8 time = 1920
* CHECK dout1_16 vdout1_16ck191 = 1.8 time = 1920
* CHECK dout1_17 vdout1_17ck191 = 1.8 time = 1920
* CHECK dout1_18 vdout1_18ck191 = 0 time = 1920
* CHECK dout1_19 vdout1_19ck191 = 0 time = 1920
* CHECK dout1_20 vdout1_20ck191 = 1.8 time = 1920
* CHECK dout1_21 vdout1_21ck191 = 1.8 time = 1920
* CHECK dout1_22 vdout1_22ck191 = 1.8 time = 1920
* CHECK dout1_23 vdout1_23ck191 = 0 time = 1920
* CHECK dout1_24 vdout1_24ck191 = 0 time = 1920
* CHECK dout1_25 vdout1_25ck191 = 0 time = 1920
* CHECK dout1_26 vdout1_26ck191 = 1.8 time = 1920
* CHECK dout1_27 vdout1_27ck191 = 1.8 time = 1920
* CHECK dout1_28 vdout1_28ck191 = 0 time = 1920
* CHECK dout1_29 vdout1_29ck191 = 1.8 time = 1920
* CHECK dout1_30 vdout1_30ck191 = 1.8 time = 1920
* CHECK dout1_31 vdout1_31ck191 = 0 time = 1920
* CHECK dout0_0 vdout0_0ck192 = 0 time = 1930
* CHECK dout0_1 vdout0_1ck192 = 0 time = 1930
* CHECK dout0_2 vdout0_2ck192 = 0 time = 1930
* CHECK dout0_3 vdout0_3ck192 = 1.8 time = 1930
* CHECK dout0_4 vdout0_4ck192 = 1.8 time = 1930
* CHECK dout0_5 vdout0_5ck192 = 0 time = 1930
* CHECK dout0_6 vdout0_6ck192 = 0 time = 1930
* CHECK dout0_7 vdout0_7ck192 = 1.8 time = 1930
* CHECK dout0_8 vdout0_8ck192 = 0 time = 1930
* CHECK dout0_9 vdout0_9ck192 = 0 time = 1930
* CHECK dout0_10 vdout0_10ck192 = 1.8 time = 1930
* CHECK dout0_11 vdout0_11ck192 = 0 time = 1930
* CHECK dout0_12 vdout0_12ck192 = 0 time = 1930
* CHECK dout0_13 vdout0_13ck192 = 1.8 time = 1930
* CHECK dout0_14 vdout0_14ck192 = 0 time = 1930
* CHECK dout0_15 vdout0_15ck192 = 0 time = 1930
* CHECK dout0_16 vdout0_16ck192 = 0 time = 1930
* CHECK dout0_17 vdout0_17ck192 = 0 time = 1930
* CHECK dout0_18 vdout0_18ck192 = 0 time = 1930
* CHECK dout0_19 vdout0_19ck192 = 0 time = 1930
* CHECK dout0_20 vdout0_20ck192 = 0 time = 1930
* CHECK dout0_21 vdout0_21ck192 = 0 time = 1930
* CHECK dout0_22 vdout0_22ck192 = 1.8 time = 1930
* CHECK dout0_23 vdout0_23ck192 = 0 time = 1930
* CHECK dout0_24 vdout0_24ck192 = 0 time = 1930
* CHECK dout0_25 vdout0_25ck192 = 0 time = 1930
* CHECK dout0_26 vdout0_26ck192 = 0 time = 1930
* CHECK dout0_27 vdout0_27ck192 = 0 time = 1930
* CHECK dout0_28 vdout0_28ck192 = 0 time = 1930
* CHECK dout0_29 vdout0_29ck192 = 0 time = 1930
* CHECK dout0_30 vdout0_30ck192 = 0 time = 1930
* CHECK dout0_31 vdout0_31ck192 = 0 time = 1930
* CHECK dout0_0 vdout0_0ck193 = 1.8 time = 1940
* CHECK dout0_1 vdout0_1ck193 = 1.8 time = 1940
* CHECK dout0_2 vdout0_2ck193 = 1.8 time = 1940
* CHECK dout0_3 vdout0_3ck193 = 0 time = 1940
* CHECK dout0_4 vdout0_4ck193 = 1.8 time = 1940
* CHECK dout0_5 vdout0_5ck193 = 1.8 time = 1940
* CHECK dout0_6 vdout0_6ck193 = 0 time = 1940
* CHECK dout0_7 vdout0_7ck193 = 1.8 time = 1940
* CHECK dout0_8 vdout0_8ck193 = 0 time = 1940
* CHECK dout0_9 vdout0_9ck193 = 1.8 time = 1940
* CHECK dout0_10 vdout0_10ck193 = 0 time = 1940
* CHECK dout0_11 vdout0_11ck193 = 1.8 time = 1940
* CHECK dout0_12 vdout0_12ck193 = 0 time = 1940
* CHECK dout0_13 vdout0_13ck193 = 0 time = 1940
* CHECK dout0_14 vdout0_14ck193 = 0 time = 1940
* CHECK dout0_15 vdout0_15ck193 = 1.8 time = 1940
* CHECK dout0_16 vdout0_16ck193 = 0 time = 1940
* CHECK dout0_17 vdout0_17ck193 = 1.8 time = 1940
* CHECK dout0_18 vdout0_18ck193 = 0 time = 1940
* CHECK dout0_19 vdout0_19ck193 = 1.8 time = 1940
* CHECK dout0_20 vdout0_20ck193 = 1.8 time = 1940
* CHECK dout0_21 vdout0_21ck193 = 0 time = 1940
* CHECK dout0_22 vdout0_22ck193 = 1.8 time = 1940
* CHECK dout0_23 vdout0_23ck193 = 0 time = 1940
* CHECK dout0_24 vdout0_24ck193 = 1.8 time = 1940
* CHECK dout0_25 vdout0_25ck193 = 0 time = 1940
* CHECK dout0_26 vdout0_26ck193 = 0 time = 1940
* CHECK dout0_27 vdout0_27ck193 = 0 time = 1940
* CHECK dout0_28 vdout0_28ck193 = 1.8 time = 1940
* CHECK dout0_29 vdout0_29ck193 = 0 time = 1940
* CHECK dout0_30 vdout0_30ck193 = 1.8 time = 1940
* CHECK dout0_31 vdout0_31ck193 = 0 time = 1940
* CHECK dout1_0 vdout1_0ck193 = 0 time = 1940
* CHECK dout1_1 vdout1_1ck193 = 0 time = 1940
* CHECK dout1_2 vdout1_2ck193 = 0 time = 1940
* CHECK dout1_3 vdout1_3ck193 = 1.8 time = 1940
* CHECK dout1_4 vdout1_4ck193 = 1.8 time = 1940
* CHECK dout1_5 vdout1_5ck193 = 0 time = 1940
* CHECK dout1_6 vdout1_6ck193 = 0 time = 1940
* CHECK dout1_7 vdout1_7ck193 = 1.8 time = 1940
* CHECK dout1_8 vdout1_8ck193 = 0 time = 1940
* CHECK dout1_9 vdout1_9ck193 = 0 time = 1940
* CHECK dout1_10 vdout1_10ck193 = 1.8 time = 1940
* CHECK dout1_11 vdout1_11ck193 = 0 time = 1940
* CHECK dout1_12 vdout1_12ck193 = 0 time = 1940
* CHECK dout1_13 vdout1_13ck193 = 1.8 time = 1940
* CHECK dout1_14 vdout1_14ck193 = 0 time = 1940
* CHECK dout1_15 vdout1_15ck193 = 0 time = 1940
* CHECK dout1_16 vdout1_16ck193 = 0 time = 1940
* CHECK dout1_17 vdout1_17ck193 = 0 time = 1940
* CHECK dout1_18 vdout1_18ck193 = 0 time = 1940
* CHECK dout1_19 vdout1_19ck193 = 0 time = 1940
* CHECK dout1_20 vdout1_20ck193 = 0 time = 1940
* CHECK dout1_21 vdout1_21ck193 = 0 time = 1940
* CHECK dout1_22 vdout1_22ck193 = 1.8 time = 1940
* CHECK dout1_23 vdout1_23ck193 = 0 time = 1940
* CHECK dout1_24 vdout1_24ck193 = 0 time = 1940
* CHECK dout1_25 vdout1_25ck193 = 0 time = 1940
* CHECK dout1_26 vdout1_26ck193 = 0 time = 1940
* CHECK dout1_27 vdout1_27ck193 = 0 time = 1940
* CHECK dout1_28 vdout1_28ck193 = 0 time = 1940
* CHECK dout1_29 vdout1_29ck193 = 0 time = 1940
* CHECK dout1_30 vdout1_30ck193 = 0 time = 1940
* CHECK dout1_31 vdout1_31ck193 = 0 time = 1940
* CHECK dout0_0 vdout0_0ck196 = 1.8 time = 1970
* CHECK dout0_1 vdout0_1ck196 = 1.8 time = 1970
* CHECK dout0_2 vdout0_2ck196 = 0 time = 1970
* CHECK dout0_3 vdout0_3ck196 = 1.8 time = 1970
* CHECK dout0_4 vdout0_4ck196 = 0 time = 1970
* CHECK dout0_5 vdout0_5ck196 = 1.8 time = 1970
* CHECK dout0_6 vdout0_6ck196 = 1.8 time = 1970
* CHECK dout0_7 vdout0_7ck196 = 1.8 time = 1970
* CHECK dout0_8 vdout0_8ck196 = 1.8 time = 1970
* CHECK dout0_9 vdout0_9ck196 = 1.8 time = 1970
* CHECK dout0_10 vdout0_10ck196 = 1.8 time = 1970
* CHECK dout0_11 vdout0_11ck196 = 1.8 time = 1970
* CHECK dout0_12 vdout0_12ck196 = 0 time = 1970
* CHECK dout0_13 vdout0_13ck196 = 1.8 time = 1970
* CHECK dout0_14 vdout0_14ck196 = 1.8 time = 1970
* CHECK dout0_15 vdout0_15ck196 = 0 time = 1970
* CHECK dout0_16 vdout0_16ck196 = 1.8 time = 1970
* CHECK dout0_17 vdout0_17ck196 = 1.8 time = 1970
* CHECK dout0_18 vdout0_18ck196 = 0 time = 1970
* CHECK dout0_19 vdout0_19ck196 = 1.8 time = 1970
* CHECK dout0_20 vdout0_20ck196 = 1.8 time = 1970
* CHECK dout0_21 vdout0_21ck196 = 1.8 time = 1970
* CHECK dout0_22 vdout0_22ck196 = 1.8 time = 1970
* CHECK dout0_23 vdout0_23ck196 = 1.8 time = 1970
* CHECK dout0_24 vdout0_24ck196 = 1.8 time = 1970
* CHECK dout0_25 vdout0_25ck196 = 1.8 time = 1970
* CHECK dout0_26 vdout0_26ck196 = 1.8 time = 1970
* CHECK dout0_27 vdout0_27ck196 = 0 time = 1970
* CHECK dout0_28 vdout0_28ck196 = 0 time = 1970
* CHECK dout0_29 vdout0_29ck196 = 0 time = 1970
* CHECK dout0_30 vdout0_30ck196 = 0 time = 1970
* CHECK dout0_31 vdout0_31ck196 = 0 time = 1970
* CHECK dout1_0 vdout1_0ck197 = 0 time = 1980
* CHECK dout1_1 vdout1_1ck197 = 1.8 time = 1980
* CHECK dout1_2 vdout1_2ck197 = 0 time = 1980
* CHECK dout1_3 vdout1_3ck197 = 0 time = 1980
* CHECK dout1_4 vdout1_4ck197 = 1.8 time = 1980
* CHECK dout1_5 vdout1_5ck197 = 1.8 time = 1980
* CHECK dout1_6 vdout1_6ck197 = 0 time = 1980
* CHECK dout1_7 vdout1_7ck197 = 0 time = 1980
* CHECK dout1_8 vdout1_8ck197 = 1.8 time = 1980
* CHECK dout1_9 vdout1_9ck197 = 1.8 time = 1980
* CHECK dout1_10 vdout1_10ck197 = 1.8 time = 1980
* CHECK dout1_11 vdout1_11ck197 = 0 time = 1980
* CHECK dout1_12 vdout1_12ck197 = 0 time = 1980
* CHECK dout1_13 vdout1_13ck197 = 0 time = 1980
* CHECK dout1_14 vdout1_14ck197 = 1.8 time = 1980
* CHECK dout1_15 vdout1_15ck197 = 1.8 time = 1980
* CHECK dout1_16 vdout1_16ck197 = 1.8 time = 1980
* CHECK dout1_17 vdout1_17ck197 = 1.8 time = 1980
* CHECK dout1_18 vdout1_18ck197 = 0 time = 1980
* CHECK dout1_19 vdout1_19ck197 = 0 time = 1980
* CHECK dout1_20 vdout1_20ck197 = 1.8 time = 1980
* CHECK dout1_21 vdout1_21ck197 = 1.8 time = 1980
* CHECK dout1_22 vdout1_22ck197 = 1.8 time = 1980
* CHECK dout1_23 vdout1_23ck197 = 0 time = 1980
* CHECK dout1_24 vdout1_24ck197 = 0 time = 1980
* CHECK dout1_25 vdout1_25ck197 = 0 time = 1980
* CHECK dout1_26 vdout1_26ck197 = 1.8 time = 1980
* CHECK dout1_27 vdout1_27ck197 = 1.8 time = 1980
* CHECK dout1_28 vdout1_28ck197 = 0 time = 1980
* CHECK dout1_29 vdout1_29ck197 = 1.8 time = 1980
* CHECK dout1_30 vdout1_30ck197 = 1.8 time = 1980
* CHECK dout1_31 vdout1_31ck197 = 0 time = 1980
* CHECK dout0_0 vdout0_0ck198 = 1.8 time = 1990
* CHECK dout0_1 vdout0_1ck198 = 1.8 time = 1990
* CHECK dout0_2 vdout0_2ck198 = 0 time = 1990
* CHECK dout0_3 vdout0_3ck198 = 0 time = 1990
* CHECK dout0_4 vdout0_4ck198 = 1.8 time = 1990
* CHECK dout0_5 vdout0_5ck198 = 1.8 time = 1990
* CHECK dout0_6 vdout0_6ck198 = 1.8 time = 1990
* CHECK dout0_7 vdout0_7ck198 = 1.8 time = 1990
* CHECK dout0_8 vdout0_8ck198 = 0 time = 1990
* CHECK dout0_9 vdout0_9ck198 = 1.8 time = 1990
* CHECK dout0_10 vdout0_10ck198 = 1.8 time = 1990
* CHECK dout0_11 vdout0_11ck198 = 1.8 time = 1990
* CHECK dout0_12 vdout0_12ck198 = 0 time = 1990
* CHECK dout0_13 vdout0_13ck198 = 0 time = 1990
* CHECK dout0_14 vdout0_14ck198 = 1.8 time = 1990
* CHECK dout0_15 vdout0_15ck198 = 1.8 time = 1990
* CHECK dout0_16 vdout0_16ck198 = 1.8 time = 1990
* CHECK dout0_17 vdout0_17ck198 = 1.8 time = 1990
* CHECK dout0_18 vdout0_18ck198 = 0 time = 1990
* CHECK dout0_19 vdout0_19ck198 = 0 time = 1990
* CHECK dout0_20 vdout0_20ck198 = 0 time = 1990
* CHECK dout0_21 vdout0_21ck198 = 0 time = 1990
* CHECK dout0_22 vdout0_22ck198 = 0 time = 1990
* CHECK dout0_23 vdout0_23ck198 = 0 time = 1990
* CHECK dout0_24 vdout0_24ck198 = 0 time = 1990
* CHECK dout0_25 vdout0_25ck198 = 1.8 time = 1990
* CHECK dout0_26 vdout0_26ck198 = 1.8 time = 1990
* CHECK dout0_27 vdout0_27ck198 = 0 time = 1990
* CHECK dout0_28 vdout0_28ck198 = 0 time = 1990
* CHECK dout0_29 vdout0_29ck198 = 0 time = 1990
* CHECK dout0_30 vdout0_30ck198 = 0 time = 1990
* CHECK dout0_31 vdout0_31ck198 = 1.8 time = 1990
* CHECK dout1_0 vdout1_0ck199 = 0 time = 2000
* CHECK dout1_1 vdout1_1ck199 = 0 time = 2000
* CHECK dout1_2 vdout1_2ck199 = 0 time = 2000
* CHECK dout1_3 vdout1_3ck199 = 1.8 time = 2000
* CHECK dout1_4 vdout1_4ck199 = 1.8 time = 2000
* CHECK dout1_5 vdout1_5ck199 = 0 time = 2000
* CHECK dout1_6 vdout1_6ck199 = 0 time = 2000
* CHECK dout1_7 vdout1_7ck199 = 1.8 time = 2000
* CHECK dout1_8 vdout1_8ck199 = 0 time = 2000
* CHECK dout1_9 vdout1_9ck199 = 0 time = 2000
* CHECK dout1_10 vdout1_10ck199 = 1.8 time = 2000
* CHECK dout1_11 vdout1_11ck199 = 0 time = 2000
* CHECK dout1_12 vdout1_12ck199 = 0 time = 2000
* CHECK dout1_13 vdout1_13ck199 = 1.8 time = 2000
* CHECK dout1_14 vdout1_14ck199 = 0 time = 2000
* CHECK dout1_15 vdout1_15ck199 = 0 time = 2000
* CHECK dout1_16 vdout1_16ck199 = 0 time = 2000
* CHECK dout1_17 vdout1_17ck199 = 0 time = 2000
* CHECK dout1_18 vdout1_18ck199 = 0 time = 2000
* CHECK dout1_19 vdout1_19ck199 = 0 time = 2000
* CHECK dout1_20 vdout1_20ck199 = 0 time = 2000
* CHECK dout1_21 vdout1_21ck199 = 0 time = 2000
* CHECK dout1_22 vdout1_22ck199 = 1.8 time = 2000
* CHECK dout1_23 vdout1_23ck199 = 0 time = 2000
* CHECK dout1_24 vdout1_24ck199 = 0 time = 2000
* CHECK dout1_25 vdout1_25ck199 = 0 time = 2000
* CHECK dout1_26 vdout1_26ck199 = 0 time = 2000
* CHECK dout1_27 vdout1_27ck199 = 0 time = 2000
* CHECK dout1_28 vdout1_28ck199 = 0 time = 2000
* CHECK dout1_29 vdout1_29ck199 = 0 time = 2000
* CHECK dout1_30 vdout1_30ck199 = 0 time = 2000
* CHECK dout1_31 vdout1_31ck199 = 0 time = 2000
* CHECK dout0_0 vdout0_0ck200 = 1.8 time = 2010
* CHECK dout0_1 vdout0_1ck200 = 1.8 time = 2010
* CHECK dout0_2 vdout0_2ck200 = 0 time = 2010
* CHECK dout0_3 vdout0_3ck200 = 0 time = 2010
* CHECK dout0_4 vdout0_4ck200 = 1.8 time = 2010
* CHECK dout0_5 vdout0_5ck200 = 1.8 time = 2010
* CHECK dout0_6 vdout0_6ck200 = 1.8 time = 2010
* CHECK dout0_7 vdout0_7ck200 = 1.8 time = 2010
* CHECK dout0_8 vdout0_8ck200 = 0 time = 2010
* CHECK dout0_9 vdout0_9ck200 = 1.8 time = 2010
* CHECK dout0_10 vdout0_10ck200 = 1.8 time = 2010
* CHECK dout0_11 vdout0_11ck200 = 0 time = 2010
* CHECK dout0_12 vdout0_12ck200 = 0 time = 2010
* CHECK dout0_13 vdout0_13ck200 = 0 time = 2010
* CHECK dout0_14 vdout0_14ck200 = 0 time = 2010
* CHECK dout0_15 vdout0_15ck200 = 0 time = 2010
* CHECK dout0_16 vdout0_16ck200 = 1.8 time = 2010
* CHECK dout0_17 vdout0_17ck200 = 1.8 time = 2010
* CHECK dout0_18 vdout0_18ck200 = 0 time = 2010
* CHECK dout0_19 vdout0_19ck200 = 0 time = 2010
* CHECK dout0_20 vdout0_20ck200 = 0 time = 2010
* CHECK dout0_21 vdout0_21ck200 = 0 time = 2010
* CHECK dout0_22 vdout0_22ck200 = 0 time = 2010
* CHECK dout0_23 vdout0_23ck200 = 0 time = 2010
* CHECK dout0_24 vdout0_24ck200 = 1.8 time = 2010
* CHECK dout0_25 vdout0_25ck200 = 0 time = 2010
* CHECK dout0_26 vdout0_26ck200 = 0 time = 2010
* CHECK dout0_27 vdout0_27ck200 = 1.8 time = 2010
* CHECK dout0_28 vdout0_28ck200 = 1.8 time = 2010
* CHECK dout0_29 vdout0_29ck200 = 1.8 time = 2010
* CHECK dout0_30 vdout0_30ck200 = 0 time = 2010
* CHECK dout0_31 vdout0_31ck200 = 1.8 time = 2010
* CHECK dout1_0 vdout1_0ck200 = 1.8 time = 2010
* CHECK dout1_1 vdout1_1ck200 = 1.8 time = 2010
* CHECK dout1_2 vdout1_2ck200 = 1.8 time = 2010
* CHECK dout1_3 vdout1_3ck200 = 0 time = 2010
* CHECK dout1_4 vdout1_4ck200 = 1.8 time = 2010
* CHECK dout1_5 vdout1_5ck200 = 1.8 time = 2010
* CHECK dout1_6 vdout1_6ck200 = 0 time = 2010
* CHECK dout1_7 vdout1_7ck200 = 1.8 time = 2010
* CHECK dout1_8 vdout1_8ck200 = 0 time = 2010
* CHECK dout1_9 vdout1_9ck200 = 1.8 time = 2010
* CHECK dout1_10 vdout1_10ck200 = 0 time = 2010
* CHECK dout1_11 vdout1_11ck200 = 1.8 time = 2010
* CHECK dout1_12 vdout1_12ck200 = 0 time = 2010
* CHECK dout1_13 vdout1_13ck200 = 0 time = 2010
* CHECK dout1_14 vdout1_14ck200 = 0 time = 2010
* CHECK dout1_15 vdout1_15ck200 = 1.8 time = 2010
* CHECK dout1_16 vdout1_16ck200 = 0 time = 2010
* CHECK dout1_17 vdout1_17ck200 = 1.8 time = 2010
* CHECK dout1_18 vdout1_18ck200 = 0 time = 2010
* CHECK dout1_19 vdout1_19ck200 = 1.8 time = 2010
* CHECK dout1_20 vdout1_20ck200 = 1.8 time = 2010
* CHECK dout1_21 vdout1_21ck200 = 0 time = 2010
* CHECK dout1_22 vdout1_22ck200 = 1.8 time = 2010
* CHECK dout1_23 vdout1_23ck200 = 0 time = 2010
* CHECK dout1_24 vdout1_24ck200 = 1.8 time = 2010
* CHECK dout1_25 vdout1_25ck200 = 0 time = 2010
* CHECK dout1_26 vdout1_26ck200 = 0 time = 2010
* CHECK dout1_27 vdout1_27ck200 = 0 time = 2010
* CHECK dout1_28 vdout1_28ck200 = 1.8 time = 2010
* CHECK dout1_29 vdout1_29ck200 = 0 time = 2010
* CHECK dout1_30 vdout1_30ck200 = 1.8 time = 2010
* CHECK dout1_31 vdout1_31ck200 = 0 time = 2010
* CHECK dout0_0 vdout0_0ck201 = 0 time = 2020
* CHECK dout0_1 vdout0_1ck201 = 0 time = 2020
* CHECK dout0_2 vdout0_2ck201 = 0 time = 2020
* CHECK dout0_3 vdout0_3ck201 = 1.8 time = 2020
* CHECK dout0_4 vdout0_4ck201 = 1.8 time = 2020
* CHECK dout0_5 vdout0_5ck201 = 0 time = 2020
* CHECK dout0_6 vdout0_6ck201 = 0 time = 2020
* CHECK dout0_7 vdout0_7ck201 = 1.8 time = 2020
* CHECK dout0_8 vdout0_8ck201 = 0 time = 2020
* CHECK dout0_9 vdout0_9ck201 = 0 time = 2020
* CHECK dout0_10 vdout0_10ck201 = 1.8 time = 2020
* CHECK dout0_11 vdout0_11ck201 = 0 time = 2020
* CHECK dout0_12 vdout0_12ck201 = 0 time = 2020
* CHECK dout0_13 vdout0_13ck201 = 1.8 time = 2020
* CHECK dout0_14 vdout0_14ck201 = 0 time = 2020
* CHECK dout0_15 vdout0_15ck201 = 0 time = 2020
* CHECK dout0_16 vdout0_16ck201 = 0 time = 2020
* CHECK dout0_17 vdout0_17ck201 = 0 time = 2020
* CHECK dout0_18 vdout0_18ck201 = 0 time = 2020
* CHECK dout0_19 vdout0_19ck201 = 0 time = 2020
* CHECK dout0_20 vdout0_20ck201 = 0 time = 2020
* CHECK dout0_21 vdout0_21ck201 = 0 time = 2020
* CHECK dout0_22 vdout0_22ck201 = 1.8 time = 2020
* CHECK dout0_23 vdout0_23ck201 = 0 time = 2020
* CHECK dout0_24 vdout0_24ck201 = 0 time = 2020
* CHECK dout0_25 vdout0_25ck201 = 0 time = 2020
* CHECK dout0_26 vdout0_26ck201 = 0 time = 2020
* CHECK dout0_27 vdout0_27ck201 = 0 time = 2020
* CHECK dout0_28 vdout0_28ck201 = 0 time = 2020
* CHECK dout0_29 vdout0_29ck201 = 0 time = 2020
* CHECK dout0_30 vdout0_30ck201 = 0 time = 2020
* CHECK dout0_31 vdout0_31ck201 = 0 time = 2020
* CHECK dout0_0 vdout0_0ck202 = 0 time = 2030
* CHECK dout0_1 vdout0_1ck202 = 1.8 time = 2030
* CHECK dout0_2 vdout0_2ck202 = 0 time = 2030
* CHECK dout0_3 vdout0_3ck202 = 0 time = 2030
* CHECK dout0_4 vdout0_4ck202 = 1.8 time = 2030
* CHECK dout0_5 vdout0_5ck202 = 1.8 time = 2030
* CHECK dout0_6 vdout0_6ck202 = 0 time = 2030
* CHECK dout0_7 vdout0_7ck202 = 0 time = 2030
* CHECK dout0_8 vdout0_8ck202 = 1.8 time = 2030
* CHECK dout0_9 vdout0_9ck202 = 1.8 time = 2030
* CHECK dout0_10 vdout0_10ck202 = 1.8 time = 2030
* CHECK dout0_11 vdout0_11ck202 = 0 time = 2030
* CHECK dout0_12 vdout0_12ck202 = 0 time = 2030
* CHECK dout0_13 vdout0_13ck202 = 0 time = 2030
* CHECK dout0_14 vdout0_14ck202 = 1.8 time = 2030
* CHECK dout0_15 vdout0_15ck202 = 1.8 time = 2030
* CHECK dout0_16 vdout0_16ck202 = 1.8 time = 2030
* CHECK dout0_17 vdout0_17ck202 = 1.8 time = 2030
* CHECK dout0_18 vdout0_18ck202 = 0 time = 2030
* CHECK dout0_19 vdout0_19ck202 = 0 time = 2030
* CHECK dout0_20 vdout0_20ck202 = 1.8 time = 2030
* CHECK dout0_21 vdout0_21ck202 = 1.8 time = 2030
* CHECK dout0_22 vdout0_22ck202 = 1.8 time = 2030
* CHECK dout0_23 vdout0_23ck202 = 0 time = 2030
* CHECK dout0_24 vdout0_24ck202 = 0 time = 2030
* CHECK dout0_25 vdout0_25ck202 = 0 time = 2030
* CHECK dout0_26 vdout0_26ck202 = 1.8 time = 2030
* CHECK dout0_27 vdout0_27ck202 = 1.8 time = 2030
* CHECK dout0_28 vdout0_28ck202 = 0 time = 2030
* CHECK dout0_29 vdout0_29ck202 = 1.8 time = 2030
* CHECK dout0_30 vdout0_30ck202 = 1.8 time = 2030
* CHECK dout0_31 vdout0_31ck202 = 0 time = 2030
* CHECK dout0_0 vdout0_0ck203 = 0 time = 2040
* CHECK dout0_1 vdout0_1ck203 = 0 time = 2040
* CHECK dout0_2 vdout0_2ck203 = 0 time = 2040
* CHECK dout0_3 vdout0_3ck203 = 1.8 time = 2040
* CHECK dout0_4 vdout0_4ck203 = 1.8 time = 2040
* CHECK dout0_5 vdout0_5ck203 = 0 time = 2040
* CHECK dout0_6 vdout0_6ck203 = 0 time = 2040
* CHECK dout0_7 vdout0_7ck203 = 1.8 time = 2040
* CHECK dout0_8 vdout0_8ck203 = 0 time = 2040
* CHECK dout0_9 vdout0_9ck203 = 0 time = 2040
* CHECK dout0_10 vdout0_10ck203 = 1.8 time = 2040
* CHECK dout0_11 vdout0_11ck203 = 0 time = 2040
* CHECK dout0_12 vdout0_12ck203 = 0 time = 2040
* CHECK dout0_13 vdout0_13ck203 = 1.8 time = 2040
* CHECK dout0_14 vdout0_14ck203 = 0 time = 2040
* CHECK dout0_15 vdout0_15ck203 = 0 time = 2040
* CHECK dout0_16 vdout0_16ck203 = 0 time = 2040
* CHECK dout0_17 vdout0_17ck203 = 0 time = 2040
* CHECK dout0_18 vdout0_18ck203 = 0 time = 2040
* CHECK dout0_19 vdout0_19ck203 = 0 time = 2040
* CHECK dout0_20 vdout0_20ck203 = 0 time = 2040
* CHECK dout0_21 vdout0_21ck203 = 0 time = 2040
* CHECK dout0_22 vdout0_22ck203 = 1.8 time = 2040
* CHECK dout0_23 vdout0_23ck203 = 0 time = 2040
* CHECK dout0_24 vdout0_24ck203 = 0 time = 2040
* CHECK dout0_25 vdout0_25ck203 = 0 time = 2040
* CHECK dout0_26 vdout0_26ck203 = 0 time = 2040
* CHECK dout0_27 vdout0_27ck203 = 0 time = 2040
* CHECK dout0_28 vdout0_28ck203 = 0 time = 2040
* CHECK dout0_29 vdout0_29ck203 = 0 time = 2040
* CHECK dout0_30 vdout0_30ck203 = 0 time = 2040
* CHECK dout0_31 vdout0_31ck203 = 0 time = 2040
* CHECK dout1_0 vdout1_0ck203 = 0 time = 2040
* CHECK dout1_1 vdout1_1ck203 = 0 time = 2040
* CHECK dout1_2 vdout1_2ck203 = 0 time = 2040
* CHECK dout1_3 vdout1_3ck203 = 1.8 time = 2040
* CHECK dout1_4 vdout1_4ck203 = 1.8 time = 2040
* CHECK dout1_5 vdout1_5ck203 = 0 time = 2040
* CHECK dout1_6 vdout1_6ck203 = 0 time = 2040
* CHECK dout1_7 vdout1_7ck203 = 1.8 time = 2040
* CHECK dout1_8 vdout1_8ck203 = 0 time = 2040
* CHECK dout1_9 vdout1_9ck203 = 0 time = 2040
* CHECK dout1_10 vdout1_10ck203 = 1.8 time = 2040
* CHECK dout1_11 vdout1_11ck203 = 0 time = 2040
* CHECK dout1_12 vdout1_12ck203 = 0 time = 2040
* CHECK dout1_13 vdout1_13ck203 = 1.8 time = 2040
* CHECK dout1_14 vdout1_14ck203 = 0 time = 2040
* CHECK dout1_15 vdout1_15ck203 = 0 time = 2040
* CHECK dout1_16 vdout1_16ck203 = 0 time = 2040
* CHECK dout1_17 vdout1_17ck203 = 0 time = 2040
* CHECK dout1_18 vdout1_18ck203 = 0 time = 2040
* CHECK dout1_19 vdout1_19ck203 = 0 time = 2040
* CHECK dout1_20 vdout1_20ck203 = 0 time = 2040
* CHECK dout1_21 vdout1_21ck203 = 0 time = 2040
* CHECK dout1_22 vdout1_22ck203 = 1.8 time = 2040
* CHECK dout1_23 vdout1_23ck203 = 0 time = 2040
* CHECK dout1_24 vdout1_24ck203 = 0 time = 2040
* CHECK dout1_25 vdout1_25ck203 = 0 time = 2040
* CHECK dout1_26 vdout1_26ck203 = 0 time = 2040
* CHECK dout1_27 vdout1_27ck203 = 0 time = 2040
* CHECK dout1_28 vdout1_28ck203 = 0 time = 2040
* CHECK dout1_29 vdout1_29ck203 = 0 time = 2040
* CHECK dout1_30 vdout1_30ck203 = 0 time = 2040
* CHECK dout1_31 vdout1_31ck203 = 0 time = 2040
* CHECK dout1_0 vdout1_0ck204 = 1.8 time = 2050
* CHECK dout1_1 vdout1_1ck204 = 1.8 time = 2050
* CHECK dout1_2 vdout1_2ck204 = 1.8 time = 2050
* CHECK dout1_3 vdout1_3ck204 = 0 time = 2050
* CHECK dout1_4 vdout1_4ck204 = 1.8 time = 2050
* CHECK dout1_5 vdout1_5ck204 = 1.8 time = 2050
* CHECK dout1_6 vdout1_6ck204 = 0 time = 2050
* CHECK dout1_7 vdout1_7ck204 = 1.8 time = 2050
* CHECK dout1_8 vdout1_8ck204 = 0 time = 2050
* CHECK dout1_9 vdout1_9ck204 = 1.8 time = 2050
* CHECK dout1_10 vdout1_10ck204 = 0 time = 2050
* CHECK dout1_11 vdout1_11ck204 = 1.8 time = 2050
* CHECK dout1_12 vdout1_12ck204 = 0 time = 2050
* CHECK dout1_13 vdout1_13ck204 = 0 time = 2050
* CHECK dout1_14 vdout1_14ck204 = 0 time = 2050
* CHECK dout1_15 vdout1_15ck204 = 1.8 time = 2050
* CHECK dout1_16 vdout1_16ck204 = 0 time = 2050
* CHECK dout1_17 vdout1_17ck204 = 1.8 time = 2050
* CHECK dout1_18 vdout1_18ck204 = 0 time = 2050
* CHECK dout1_19 vdout1_19ck204 = 1.8 time = 2050
* CHECK dout1_20 vdout1_20ck204 = 1.8 time = 2050
* CHECK dout1_21 vdout1_21ck204 = 0 time = 2050
* CHECK dout1_22 vdout1_22ck204 = 1.8 time = 2050
* CHECK dout1_23 vdout1_23ck204 = 0 time = 2050
* CHECK dout1_24 vdout1_24ck204 = 1.8 time = 2050
* CHECK dout1_25 vdout1_25ck204 = 0 time = 2050
* CHECK dout1_26 vdout1_26ck204 = 0 time = 2050
* CHECK dout1_27 vdout1_27ck204 = 0 time = 2050
* CHECK dout1_28 vdout1_28ck204 = 1.8 time = 2050
* CHECK dout1_29 vdout1_29ck204 = 0 time = 2050
* CHECK dout1_30 vdout1_30ck204 = 1.8 time = 2050
* CHECK dout1_31 vdout1_31ck204 = 0 time = 2050
.include /home/link/eda/OpenRAM/config2/functional_meas.sp
* probe is used for hspice/xa, while plot is used in ngspice
*.probe V(*)
*.plot V(*)
.end
