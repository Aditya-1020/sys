.meas tran vdout0_0ck40 FIND v(dout0_0) AT=50.05n

.meas tran vdout0_1ck40 FIND v(dout0_1) AT=50.05n

.meas tran vdout0_2ck40 FIND v(dout0_2) AT=50.05n

.meas tran vdout0_3ck40 FIND v(dout0_3) AT=50.05n

.meas tran vdout0_4ck40 FIND v(dout0_4) AT=50.05n

.meas tran vdout0_5ck40 FIND v(dout0_5) AT=50.05n

.meas tran vdout0_6ck40 FIND v(dout0_6) AT=50.05n

.meas tran vdout0_7ck40 FIND v(dout0_7) AT=50.05n

.meas tran vdout0_8ck40 FIND v(dout0_8) AT=50.05n

.meas tran vdout0_9ck40 FIND v(dout0_9) AT=50.05n

.meas tran vdout0_10ck40 FIND v(dout0_10) AT=50.05n

.meas tran vdout0_11ck40 FIND v(dout0_11) AT=50.05n

.meas tran vdout0_12ck40 FIND v(dout0_12) AT=50.05n

.meas tran vdout0_13ck40 FIND v(dout0_13) AT=50.05n

.meas tran vdout0_14ck40 FIND v(dout0_14) AT=50.05n

.meas tran vdout0_15ck40 FIND v(dout0_15) AT=50.05n

.meas tran vdout0_16ck40 FIND v(dout0_16) AT=50.05n

.meas tran vdout0_17ck40 FIND v(dout0_17) AT=50.05n

.meas tran vdout0_18ck40 FIND v(dout0_18) AT=50.05n

.meas tran vdout0_19ck40 FIND v(dout0_19) AT=50.05n

.meas tran vdout0_20ck40 FIND v(dout0_20) AT=50.05n

.meas tran vdout0_21ck40 FIND v(dout0_21) AT=50.05n

.meas tran vdout0_22ck40 FIND v(dout0_22) AT=50.05n

.meas tran vdout0_23ck40 FIND v(dout0_23) AT=50.05n

.meas tran vdout0_24ck40 FIND v(dout0_24) AT=50.05n

.meas tran vdout0_25ck40 FIND v(dout0_25) AT=50.05n

.meas tran vdout0_26ck40 FIND v(dout0_26) AT=50.05n

.meas tran vdout0_27ck40 FIND v(dout0_27) AT=50.05n

.meas tran vdout0_28ck40 FIND v(dout0_28) AT=50.05n

.meas tran vdout0_29ck40 FIND v(dout0_29) AT=50.05n

.meas tran vdout0_30ck40 FIND v(dout0_30) AT=50.05n

.meas tran vdout0_31ck40 FIND v(dout0_31) AT=50.05n

.meas tran vdout1_0ck40 FIND v(dout1_0) AT=50.05n

.meas tran vdout1_1ck40 FIND v(dout1_1) AT=50.05n

.meas tran vdout1_2ck40 FIND v(dout1_2) AT=50.05n

.meas tran vdout1_3ck40 FIND v(dout1_3) AT=50.05n

.meas tran vdout1_4ck40 FIND v(dout1_4) AT=50.05n

.meas tran vdout1_5ck40 FIND v(dout1_5) AT=50.05n

.meas tran vdout1_6ck40 FIND v(dout1_6) AT=50.05n

.meas tran vdout1_7ck40 FIND v(dout1_7) AT=50.05n

.meas tran vdout1_8ck40 FIND v(dout1_8) AT=50.05n

.meas tran vdout1_9ck40 FIND v(dout1_9) AT=50.05n

.meas tran vdout1_10ck40 FIND v(dout1_10) AT=50.05n

.meas tran vdout1_11ck40 FIND v(dout1_11) AT=50.05n

.meas tran vdout1_12ck40 FIND v(dout1_12) AT=50.05n

.meas tran vdout1_13ck40 FIND v(dout1_13) AT=50.05n

.meas tran vdout1_14ck40 FIND v(dout1_14) AT=50.05n

.meas tran vdout1_15ck40 FIND v(dout1_15) AT=50.05n

.meas tran vdout1_16ck40 FIND v(dout1_16) AT=50.05n

.meas tran vdout1_17ck40 FIND v(dout1_17) AT=50.05n

.meas tran vdout1_18ck40 FIND v(dout1_18) AT=50.05n

.meas tran vdout1_19ck40 FIND v(dout1_19) AT=50.05n

.meas tran vdout1_20ck40 FIND v(dout1_20) AT=50.05n

.meas tran vdout1_21ck40 FIND v(dout1_21) AT=50.05n

.meas tran vdout1_22ck40 FIND v(dout1_22) AT=50.05n

.meas tran vdout1_23ck40 FIND v(dout1_23) AT=50.05n

.meas tran vdout1_24ck40 FIND v(dout1_24) AT=50.05n

.meas tran vdout1_25ck40 FIND v(dout1_25) AT=50.05n

.meas tran vdout1_26ck40 FIND v(dout1_26) AT=50.05n

.meas tran vdout1_27ck40 FIND v(dout1_27) AT=50.05n

.meas tran vdout1_28ck40 FIND v(dout1_28) AT=50.05n

.meas tran vdout1_29ck40 FIND v(dout1_29) AT=50.05n

.meas tran vdout1_30ck40 FIND v(dout1_30) AT=50.05n

.meas tran vdout1_31ck40 FIND v(dout1_31) AT=50.05n

.meas tran vdout1_0ck50 FIND v(dout1_0) AT=60.05n

.meas tran vdout1_1ck50 FIND v(dout1_1) AT=60.05n

.meas tran vdout1_2ck50 FIND v(dout1_2) AT=60.05n

.meas tran vdout1_3ck50 FIND v(dout1_3) AT=60.05n

.meas tran vdout1_4ck50 FIND v(dout1_4) AT=60.05n

.meas tran vdout1_5ck50 FIND v(dout1_5) AT=60.05n

.meas tran vdout1_6ck50 FIND v(dout1_6) AT=60.05n

.meas tran vdout1_7ck50 FIND v(dout1_7) AT=60.05n

.meas tran vdout1_8ck50 FIND v(dout1_8) AT=60.05n

.meas tran vdout1_9ck50 FIND v(dout1_9) AT=60.05n

.meas tran vdout1_10ck50 FIND v(dout1_10) AT=60.05n

.meas tran vdout1_11ck50 FIND v(dout1_11) AT=60.05n

.meas tran vdout1_12ck50 FIND v(dout1_12) AT=60.05n

.meas tran vdout1_13ck50 FIND v(dout1_13) AT=60.05n

.meas tran vdout1_14ck50 FIND v(dout1_14) AT=60.05n

.meas tran vdout1_15ck50 FIND v(dout1_15) AT=60.05n

.meas tran vdout1_16ck50 FIND v(dout1_16) AT=60.05n

.meas tran vdout1_17ck50 FIND v(dout1_17) AT=60.05n

.meas tran vdout1_18ck50 FIND v(dout1_18) AT=60.05n

.meas tran vdout1_19ck50 FIND v(dout1_19) AT=60.05n

.meas tran vdout1_20ck50 FIND v(dout1_20) AT=60.05n

.meas tran vdout1_21ck50 FIND v(dout1_21) AT=60.05n

.meas tran vdout1_22ck50 FIND v(dout1_22) AT=60.05n

.meas tran vdout1_23ck50 FIND v(dout1_23) AT=60.05n

.meas tran vdout1_24ck50 FIND v(dout1_24) AT=60.05n

.meas tran vdout1_25ck50 FIND v(dout1_25) AT=60.05n

.meas tran vdout1_26ck50 FIND v(dout1_26) AT=60.05n

.meas tran vdout1_27ck50 FIND v(dout1_27) AT=60.05n

.meas tran vdout1_28ck50 FIND v(dout1_28) AT=60.05n

.meas tran vdout1_29ck50 FIND v(dout1_29) AT=60.05n

.meas tran vdout1_30ck50 FIND v(dout1_30) AT=60.05n

.meas tran vdout1_31ck50 FIND v(dout1_31) AT=60.05n

.meas tran vdout0_0ck70 FIND v(dout0_0) AT=80.05n

.meas tran vdout0_1ck70 FIND v(dout0_1) AT=80.05n

.meas tran vdout0_2ck70 FIND v(dout0_2) AT=80.05n

.meas tran vdout0_3ck70 FIND v(dout0_3) AT=80.05n

.meas tran vdout0_4ck70 FIND v(dout0_4) AT=80.05n

.meas tran vdout0_5ck70 FIND v(dout0_5) AT=80.05n

.meas tran vdout0_6ck70 FIND v(dout0_6) AT=80.05n

.meas tran vdout0_7ck70 FIND v(dout0_7) AT=80.05n

.meas tran vdout0_8ck70 FIND v(dout0_8) AT=80.05n

.meas tran vdout0_9ck70 FIND v(dout0_9) AT=80.05n

.meas tran vdout0_10ck70 FIND v(dout0_10) AT=80.05n

.meas tran vdout0_11ck70 FIND v(dout0_11) AT=80.05n

.meas tran vdout0_12ck70 FIND v(dout0_12) AT=80.05n

.meas tran vdout0_13ck70 FIND v(dout0_13) AT=80.05n

.meas tran vdout0_14ck70 FIND v(dout0_14) AT=80.05n

.meas tran vdout0_15ck70 FIND v(dout0_15) AT=80.05n

.meas tran vdout0_16ck70 FIND v(dout0_16) AT=80.05n

.meas tran vdout0_17ck70 FIND v(dout0_17) AT=80.05n

.meas tran vdout0_18ck70 FIND v(dout0_18) AT=80.05n

.meas tran vdout0_19ck70 FIND v(dout0_19) AT=80.05n

.meas tran vdout0_20ck70 FIND v(dout0_20) AT=80.05n

.meas tran vdout0_21ck70 FIND v(dout0_21) AT=80.05n

.meas tran vdout0_22ck70 FIND v(dout0_22) AT=80.05n

.meas tran vdout0_23ck70 FIND v(dout0_23) AT=80.05n

.meas tran vdout0_24ck70 FIND v(dout0_24) AT=80.05n

.meas tran vdout0_25ck70 FIND v(dout0_25) AT=80.05n

.meas tran vdout0_26ck70 FIND v(dout0_26) AT=80.05n

.meas tran vdout0_27ck70 FIND v(dout0_27) AT=80.05n

.meas tran vdout0_28ck70 FIND v(dout0_28) AT=80.05n

.meas tran vdout0_29ck70 FIND v(dout0_29) AT=80.05n

.meas tran vdout0_30ck70 FIND v(dout0_30) AT=80.05n

.meas tran vdout0_31ck70 FIND v(dout0_31) AT=80.05n

.meas tran vdout1_0ck80 FIND v(dout1_0) AT=90.05n

.meas tran vdout1_1ck80 FIND v(dout1_1) AT=90.05n

.meas tran vdout1_2ck80 FIND v(dout1_2) AT=90.05n

.meas tran vdout1_3ck80 FIND v(dout1_3) AT=90.05n

.meas tran vdout1_4ck80 FIND v(dout1_4) AT=90.05n

.meas tran vdout1_5ck80 FIND v(dout1_5) AT=90.05n

.meas tran vdout1_6ck80 FIND v(dout1_6) AT=90.05n

.meas tran vdout1_7ck80 FIND v(dout1_7) AT=90.05n

.meas tran vdout1_8ck80 FIND v(dout1_8) AT=90.05n

.meas tran vdout1_9ck80 FIND v(dout1_9) AT=90.05n

.meas tran vdout1_10ck80 FIND v(dout1_10) AT=90.05n

.meas tran vdout1_11ck80 FIND v(dout1_11) AT=90.05n

.meas tran vdout1_12ck80 FIND v(dout1_12) AT=90.05n

.meas tran vdout1_13ck80 FIND v(dout1_13) AT=90.05n

.meas tran vdout1_14ck80 FIND v(dout1_14) AT=90.05n

.meas tran vdout1_15ck80 FIND v(dout1_15) AT=90.05n

.meas tran vdout1_16ck80 FIND v(dout1_16) AT=90.05n

.meas tran vdout1_17ck80 FIND v(dout1_17) AT=90.05n

.meas tran vdout1_18ck80 FIND v(dout1_18) AT=90.05n

.meas tran vdout1_19ck80 FIND v(dout1_19) AT=90.05n

.meas tran vdout1_20ck80 FIND v(dout1_20) AT=90.05n

.meas tran vdout1_21ck80 FIND v(dout1_21) AT=90.05n

.meas tran vdout1_22ck80 FIND v(dout1_22) AT=90.05n

.meas tran vdout1_23ck80 FIND v(dout1_23) AT=90.05n

.meas tran vdout1_24ck80 FIND v(dout1_24) AT=90.05n

.meas tran vdout1_25ck80 FIND v(dout1_25) AT=90.05n

.meas tran vdout1_26ck80 FIND v(dout1_26) AT=90.05n

.meas tran vdout1_27ck80 FIND v(dout1_27) AT=90.05n

.meas tran vdout1_28ck80 FIND v(dout1_28) AT=90.05n

.meas tran vdout1_29ck80 FIND v(dout1_29) AT=90.05n

.meas tran vdout1_30ck80 FIND v(dout1_30) AT=90.05n

.meas tran vdout1_31ck80 FIND v(dout1_31) AT=90.05n

.meas tran vdout0_0ck90 FIND v(dout0_0) AT=100.05n

.meas tran vdout0_1ck90 FIND v(dout0_1) AT=100.05n

.meas tran vdout0_2ck90 FIND v(dout0_2) AT=100.05n

.meas tran vdout0_3ck90 FIND v(dout0_3) AT=100.05n

.meas tran vdout0_4ck90 FIND v(dout0_4) AT=100.05n

.meas tran vdout0_5ck90 FIND v(dout0_5) AT=100.05n

.meas tran vdout0_6ck90 FIND v(dout0_6) AT=100.05n

.meas tran vdout0_7ck90 FIND v(dout0_7) AT=100.05n

.meas tran vdout0_8ck90 FIND v(dout0_8) AT=100.05n

.meas tran vdout0_9ck90 FIND v(dout0_9) AT=100.05n

.meas tran vdout0_10ck90 FIND v(dout0_10) AT=100.05n

.meas tran vdout0_11ck90 FIND v(dout0_11) AT=100.05n

.meas tran vdout0_12ck90 FIND v(dout0_12) AT=100.05n

.meas tran vdout0_13ck90 FIND v(dout0_13) AT=100.05n

.meas tran vdout0_14ck90 FIND v(dout0_14) AT=100.05n

.meas tran vdout0_15ck90 FIND v(dout0_15) AT=100.05n

.meas tran vdout0_16ck90 FIND v(dout0_16) AT=100.05n

.meas tran vdout0_17ck90 FIND v(dout0_17) AT=100.05n

.meas tran vdout0_18ck90 FIND v(dout0_18) AT=100.05n

.meas tran vdout0_19ck90 FIND v(dout0_19) AT=100.05n

.meas tran vdout0_20ck90 FIND v(dout0_20) AT=100.05n

.meas tran vdout0_21ck90 FIND v(dout0_21) AT=100.05n

.meas tran vdout0_22ck90 FIND v(dout0_22) AT=100.05n

.meas tran vdout0_23ck90 FIND v(dout0_23) AT=100.05n

.meas tran vdout0_24ck90 FIND v(dout0_24) AT=100.05n

.meas tran vdout0_25ck90 FIND v(dout0_25) AT=100.05n

.meas tran vdout0_26ck90 FIND v(dout0_26) AT=100.05n

.meas tran vdout0_27ck90 FIND v(dout0_27) AT=100.05n

.meas tran vdout0_28ck90 FIND v(dout0_28) AT=100.05n

.meas tran vdout0_29ck90 FIND v(dout0_29) AT=100.05n

.meas tran vdout0_30ck90 FIND v(dout0_30) AT=100.05n

.meas tran vdout0_31ck90 FIND v(dout0_31) AT=100.05n

.meas tran vdout0_0ck100 FIND v(dout0_0) AT=110.05n

.meas tran vdout0_1ck100 FIND v(dout0_1) AT=110.05n

.meas tran vdout0_2ck100 FIND v(dout0_2) AT=110.05n

.meas tran vdout0_3ck100 FIND v(dout0_3) AT=110.05n

.meas tran vdout0_4ck100 FIND v(dout0_4) AT=110.05n

.meas tran vdout0_5ck100 FIND v(dout0_5) AT=110.05n

.meas tran vdout0_6ck100 FIND v(dout0_6) AT=110.05n

.meas tran vdout0_7ck100 FIND v(dout0_7) AT=110.05n

.meas tran vdout0_8ck100 FIND v(dout0_8) AT=110.05n

.meas tran vdout0_9ck100 FIND v(dout0_9) AT=110.05n

.meas tran vdout0_10ck100 FIND v(dout0_10) AT=110.05n

.meas tran vdout0_11ck100 FIND v(dout0_11) AT=110.05n

.meas tran vdout0_12ck100 FIND v(dout0_12) AT=110.05n

.meas tran vdout0_13ck100 FIND v(dout0_13) AT=110.05n

.meas tran vdout0_14ck100 FIND v(dout0_14) AT=110.05n

.meas tran vdout0_15ck100 FIND v(dout0_15) AT=110.05n

.meas tran vdout0_16ck100 FIND v(dout0_16) AT=110.05n

.meas tran vdout0_17ck100 FIND v(dout0_17) AT=110.05n

.meas tran vdout0_18ck100 FIND v(dout0_18) AT=110.05n

.meas tran vdout0_19ck100 FIND v(dout0_19) AT=110.05n

.meas tran vdout0_20ck100 FIND v(dout0_20) AT=110.05n

.meas tran vdout0_21ck100 FIND v(dout0_21) AT=110.05n

.meas tran vdout0_22ck100 FIND v(dout0_22) AT=110.05n

.meas tran vdout0_23ck100 FIND v(dout0_23) AT=110.05n

.meas tran vdout0_24ck100 FIND v(dout0_24) AT=110.05n

.meas tran vdout0_25ck100 FIND v(dout0_25) AT=110.05n

.meas tran vdout0_26ck100 FIND v(dout0_26) AT=110.05n

.meas tran vdout0_27ck100 FIND v(dout0_27) AT=110.05n

.meas tran vdout0_28ck100 FIND v(dout0_28) AT=110.05n

.meas tran vdout0_29ck100 FIND v(dout0_29) AT=110.05n

.meas tran vdout0_30ck100 FIND v(dout0_30) AT=110.05n

.meas tran vdout0_31ck100 FIND v(dout0_31) AT=110.05n

.meas tran vdout1_0ck100 FIND v(dout1_0) AT=110.05n

.meas tran vdout1_1ck100 FIND v(dout1_1) AT=110.05n

.meas tran vdout1_2ck100 FIND v(dout1_2) AT=110.05n

.meas tran vdout1_3ck100 FIND v(dout1_3) AT=110.05n

.meas tran vdout1_4ck100 FIND v(dout1_4) AT=110.05n

.meas tran vdout1_5ck100 FIND v(dout1_5) AT=110.05n

.meas tran vdout1_6ck100 FIND v(dout1_6) AT=110.05n

.meas tran vdout1_7ck100 FIND v(dout1_7) AT=110.05n

.meas tran vdout1_8ck100 FIND v(dout1_8) AT=110.05n

.meas tran vdout1_9ck100 FIND v(dout1_9) AT=110.05n

.meas tran vdout1_10ck100 FIND v(dout1_10) AT=110.05n

.meas tran vdout1_11ck100 FIND v(dout1_11) AT=110.05n

.meas tran vdout1_12ck100 FIND v(dout1_12) AT=110.05n

.meas tran vdout1_13ck100 FIND v(dout1_13) AT=110.05n

.meas tran vdout1_14ck100 FIND v(dout1_14) AT=110.05n

.meas tran vdout1_15ck100 FIND v(dout1_15) AT=110.05n

.meas tran vdout1_16ck100 FIND v(dout1_16) AT=110.05n

.meas tran vdout1_17ck100 FIND v(dout1_17) AT=110.05n

.meas tran vdout1_18ck100 FIND v(dout1_18) AT=110.05n

.meas tran vdout1_19ck100 FIND v(dout1_19) AT=110.05n

.meas tran vdout1_20ck100 FIND v(dout1_20) AT=110.05n

.meas tran vdout1_21ck100 FIND v(dout1_21) AT=110.05n

.meas tran vdout1_22ck100 FIND v(dout1_22) AT=110.05n

.meas tran vdout1_23ck100 FIND v(dout1_23) AT=110.05n

.meas tran vdout1_24ck100 FIND v(dout1_24) AT=110.05n

.meas tran vdout1_25ck100 FIND v(dout1_25) AT=110.05n

.meas tran vdout1_26ck100 FIND v(dout1_26) AT=110.05n

.meas tran vdout1_27ck100 FIND v(dout1_27) AT=110.05n

.meas tran vdout1_28ck100 FIND v(dout1_28) AT=110.05n

.meas tran vdout1_29ck100 FIND v(dout1_29) AT=110.05n

.meas tran vdout1_30ck100 FIND v(dout1_30) AT=110.05n

.meas tran vdout1_31ck100 FIND v(dout1_31) AT=110.05n

.meas tran vdout0_0ck110 FIND v(dout0_0) AT=120.05n

.meas tran vdout0_1ck110 FIND v(dout0_1) AT=120.05n

.meas tran vdout0_2ck110 FIND v(dout0_2) AT=120.05n

.meas tran vdout0_3ck110 FIND v(dout0_3) AT=120.05n

.meas tran vdout0_4ck110 FIND v(dout0_4) AT=120.05n

.meas tran vdout0_5ck110 FIND v(dout0_5) AT=120.05n

.meas tran vdout0_6ck110 FIND v(dout0_6) AT=120.05n

.meas tran vdout0_7ck110 FIND v(dout0_7) AT=120.05n

.meas tran vdout0_8ck110 FIND v(dout0_8) AT=120.05n

.meas tran vdout0_9ck110 FIND v(dout0_9) AT=120.05n

.meas tran vdout0_10ck110 FIND v(dout0_10) AT=120.05n

.meas tran vdout0_11ck110 FIND v(dout0_11) AT=120.05n

.meas tran vdout0_12ck110 FIND v(dout0_12) AT=120.05n

.meas tran vdout0_13ck110 FIND v(dout0_13) AT=120.05n

.meas tran vdout0_14ck110 FIND v(dout0_14) AT=120.05n

.meas tran vdout0_15ck110 FIND v(dout0_15) AT=120.05n

.meas tran vdout0_16ck110 FIND v(dout0_16) AT=120.05n

.meas tran vdout0_17ck110 FIND v(dout0_17) AT=120.05n

.meas tran vdout0_18ck110 FIND v(dout0_18) AT=120.05n

.meas tran vdout0_19ck110 FIND v(dout0_19) AT=120.05n

.meas tran vdout0_20ck110 FIND v(dout0_20) AT=120.05n

.meas tran vdout0_21ck110 FIND v(dout0_21) AT=120.05n

.meas tran vdout0_22ck110 FIND v(dout0_22) AT=120.05n

.meas tran vdout0_23ck110 FIND v(dout0_23) AT=120.05n

.meas tran vdout0_24ck110 FIND v(dout0_24) AT=120.05n

.meas tran vdout0_25ck110 FIND v(dout0_25) AT=120.05n

.meas tran vdout0_26ck110 FIND v(dout0_26) AT=120.05n

.meas tran vdout0_27ck110 FIND v(dout0_27) AT=120.05n

.meas tran vdout0_28ck110 FIND v(dout0_28) AT=120.05n

.meas tran vdout0_29ck110 FIND v(dout0_29) AT=120.05n

.meas tran vdout0_30ck110 FIND v(dout0_30) AT=120.05n

.meas tran vdout0_31ck110 FIND v(dout0_31) AT=120.05n

.meas tran vdout0_0ck120 FIND v(dout0_0) AT=130.05n

.meas tran vdout0_1ck120 FIND v(dout0_1) AT=130.05n

.meas tran vdout0_2ck120 FIND v(dout0_2) AT=130.05n

.meas tran vdout0_3ck120 FIND v(dout0_3) AT=130.05n

.meas tran vdout0_4ck120 FIND v(dout0_4) AT=130.05n

.meas tran vdout0_5ck120 FIND v(dout0_5) AT=130.05n

.meas tran vdout0_6ck120 FIND v(dout0_6) AT=130.05n

.meas tran vdout0_7ck120 FIND v(dout0_7) AT=130.05n

.meas tran vdout0_8ck120 FIND v(dout0_8) AT=130.05n

.meas tran vdout0_9ck120 FIND v(dout0_9) AT=130.05n

.meas tran vdout0_10ck120 FIND v(dout0_10) AT=130.05n

.meas tran vdout0_11ck120 FIND v(dout0_11) AT=130.05n

.meas tran vdout0_12ck120 FIND v(dout0_12) AT=130.05n

.meas tran vdout0_13ck120 FIND v(dout0_13) AT=130.05n

.meas tran vdout0_14ck120 FIND v(dout0_14) AT=130.05n

.meas tran vdout0_15ck120 FIND v(dout0_15) AT=130.05n

.meas tran vdout0_16ck120 FIND v(dout0_16) AT=130.05n

.meas tran vdout0_17ck120 FIND v(dout0_17) AT=130.05n

.meas tran vdout0_18ck120 FIND v(dout0_18) AT=130.05n

.meas tran vdout0_19ck120 FIND v(dout0_19) AT=130.05n

.meas tran vdout0_20ck120 FIND v(dout0_20) AT=130.05n

.meas tran vdout0_21ck120 FIND v(dout0_21) AT=130.05n

.meas tran vdout0_22ck120 FIND v(dout0_22) AT=130.05n

.meas tran vdout0_23ck120 FIND v(dout0_23) AT=130.05n

.meas tran vdout0_24ck120 FIND v(dout0_24) AT=130.05n

.meas tran vdout0_25ck120 FIND v(dout0_25) AT=130.05n

.meas tran vdout0_26ck120 FIND v(dout0_26) AT=130.05n

.meas tran vdout0_27ck120 FIND v(dout0_27) AT=130.05n

.meas tran vdout0_28ck120 FIND v(dout0_28) AT=130.05n

.meas tran vdout0_29ck120 FIND v(dout0_29) AT=130.05n

.meas tran vdout0_30ck120 FIND v(dout0_30) AT=130.05n

.meas tran vdout0_31ck120 FIND v(dout0_31) AT=130.05n

.meas tran vdout1_0ck120 FIND v(dout1_0) AT=130.05n

.meas tran vdout1_1ck120 FIND v(dout1_1) AT=130.05n

.meas tran vdout1_2ck120 FIND v(dout1_2) AT=130.05n

.meas tran vdout1_3ck120 FIND v(dout1_3) AT=130.05n

.meas tran vdout1_4ck120 FIND v(dout1_4) AT=130.05n

.meas tran vdout1_5ck120 FIND v(dout1_5) AT=130.05n

.meas tran vdout1_6ck120 FIND v(dout1_6) AT=130.05n

.meas tran vdout1_7ck120 FIND v(dout1_7) AT=130.05n

.meas tran vdout1_8ck120 FIND v(dout1_8) AT=130.05n

.meas tran vdout1_9ck120 FIND v(dout1_9) AT=130.05n

.meas tran vdout1_10ck120 FIND v(dout1_10) AT=130.05n

.meas tran vdout1_11ck120 FIND v(dout1_11) AT=130.05n

.meas tran vdout1_12ck120 FIND v(dout1_12) AT=130.05n

.meas tran vdout1_13ck120 FIND v(dout1_13) AT=130.05n

.meas tran vdout1_14ck120 FIND v(dout1_14) AT=130.05n

.meas tran vdout1_15ck120 FIND v(dout1_15) AT=130.05n

.meas tran vdout1_16ck120 FIND v(dout1_16) AT=130.05n

.meas tran vdout1_17ck120 FIND v(dout1_17) AT=130.05n

.meas tran vdout1_18ck120 FIND v(dout1_18) AT=130.05n

.meas tran vdout1_19ck120 FIND v(dout1_19) AT=130.05n

.meas tran vdout1_20ck120 FIND v(dout1_20) AT=130.05n

.meas tran vdout1_21ck120 FIND v(dout1_21) AT=130.05n

.meas tran vdout1_22ck120 FIND v(dout1_22) AT=130.05n

.meas tran vdout1_23ck120 FIND v(dout1_23) AT=130.05n

.meas tran vdout1_24ck120 FIND v(dout1_24) AT=130.05n

.meas tran vdout1_25ck120 FIND v(dout1_25) AT=130.05n

.meas tran vdout1_26ck120 FIND v(dout1_26) AT=130.05n

.meas tran vdout1_27ck120 FIND v(dout1_27) AT=130.05n

.meas tran vdout1_28ck120 FIND v(dout1_28) AT=130.05n

.meas tran vdout1_29ck120 FIND v(dout1_29) AT=130.05n

.meas tran vdout1_30ck120 FIND v(dout1_30) AT=130.05n

.meas tran vdout1_31ck120 FIND v(dout1_31) AT=130.05n

.meas tran vdout0_0ck130 FIND v(dout0_0) AT=140.05n

.meas tran vdout0_1ck130 FIND v(dout0_1) AT=140.05n

.meas tran vdout0_2ck130 FIND v(dout0_2) AT=140.05n

.meas tran vdout0_3ck130 FIND v(dout0_3) AT=140.05n

.meas tran vdout0_4ck130 FIND v(dout0_4) AT=140.05n

.meas tran vdout0_5ck130 FIND v(dout0_5) AT=140.05n

.meas tran vdout0_6ck130 FIND v(dout0_6) AT=140.05n

.meas tran vdout0_7ck130 FIND v(dout0_7) AT=140.05n

.meas tran vdout0_8ck130 FIND v(dout0_8) AT=140.05n

.meas tran vdout0_9ck130 FIND v(dout0_9) AT=140.05n

.meas tran vdout0_10ck130 FIND v(dout0_10) AT=140.05n

.meas tran vdout0_11ck130 FIND v(dout0_11) AT=140.05n

.meas tran vdout0_12ck130 FIND v(dout0_12) AT=140.05n

.meas tran vdout0_13ck130 FIND v(dout0_13) AT=140.05n

.meas tran vdout0_14ck130 FIND v(dout0_14) AT=140.05n

.meas tran vdout0_15ck130 FIND v(dout0_15) AT=140.05n

.meas tran vdout0_16ck130 FIND v(dout0_16) AT=140.05n

.meas tran vdout0_17ck130 FIND v(dout0_17) AT=140.05n

.meas tran vdout0_18ck130 FIND v(dout0_18) AT=140.05n

.meas tran vdout0_19ck130 FIND v(dout0_19) AT=140.05n

.meas tran vdout0_20ck130 FIND v(dout0_20) AT=140.05n

.meas tran vdout0_21ck130 FIND v(dout0_21) AT=140.05n

.meas tran vdout0_22ck130 FIND v(dout0_22) AT=140.05n

.meas tran vdout0_23ck130 FIND v(dout0_23) AT=140.05n

.meas tran vdout0_24ck130 FIND v(dout0_24) AT=140.05n

.meas tran vdout0_25ck130 FIND v(dout0_25) AT=140.05n

.meas tran vdout0_26ck130 FIND v(dout0_26) AT=140.05n

.meas tran vdout0_27ck130 FIND v(dout0_27) AT=140.05n

.meas tran vdout0_28ck130 FIND v(dout0_28) AT=140.05n

.meas tran vdout0_29ck130 FIND v(dout0_29) AT=140.05n

.meas tran vdout0_30ck130 FIND v(dout0_30) AT=140.05n

.meas tran vdout0_31ck130 FIND v(dout0_31) AT=140.05n

.meas tran vdout1_0ck130 FIND v(dout1_0) AT=140.05n

.meas tran vdout1_1ck130 FIND v(dout1_1) AT=140.05n

.meas tran vdout1_2ck130 FIND v(dout1_2) AT=140.05n

.meas tran vdout1_3ck130 FIND v(dout1_3) AT=140.05n

.meas tran vdout1_4ck130 FIND v(dout1_4) AT=140.05n

.meas tran vdout1_5ck130 FIND v(dout1_5) AT=140.05n

.meas tran vdout1_6ck130 FIND v(dout1_6) AT=140.05n

.meas tran vdout1_7ck130 FIND v(dout1_7) AT=140.05n

.meas tran vdout1_8ck130 FIND v(dout1_8) AT=140.05n

.meas tran vdout1_9ck130 FIND v(dout1_9) AT=140.05n

.meas tran vdout1_10ck130 FIND v(dout1_10) AT=140.05n

.meas tran vdout1_11ck130 FIND v(dout1_11) AT=140.05n

.meas tran vdout1_12ck130 FIND v(dout1_12) AT=140.05n

.meas tran vdout1_13ck130 FIND v(dout1_13) AT=140.05n

.meas tran vdout1_14ck130 FIND v(dout1_14) AT=140.05n

.meas tran vdout1_15ck130 FIND v(dout1_15) AT=140.05n

.meas tran vdout1_16ck130 FIND v(dout1_16) AT=140.05n

.meas tran vdout1_17ck130 FIND v(dout1_17) AT=140.05n

.meas tran vdout1_18ck130 FIND v(dout1_18) AT=140.05n

.meas tran vdout1_19ck130 FIND v(dout1_19) AT=140.05n

.meas tran vdout1_20ck130 FIND v(dout1_20) AT=140.05n

.meas tran vdout1_21ck130 FIND v(dout1_21) AT=140.05n

.meas tran vdout1_22ck130 FIND v(dout1_22) AT=140.05n

.meas tran vdout1_23ck130 FIND v(dout1_23) AT=140.05n

.meas tran vdout1_24ck130 FIND v(dout1_24) AT=140.05n

.meas tran vdout1_25ck130 FIND v(dout1_25) AT=140.05n

.meas tran vdout1_26ck130 FIND v(dout1_26) AT=140.05n

.meas tran vdout1_27ck130 FIND v(dout1_27) AT=140.05n

.meas tran vdout1_28ck130 FIND v(dout1_28) AT=140.05n

.meas tran vdout1_29ck130 FIND v(dout1_29) AT=140.05n

.meas tran vdout1_30ck130 FIND v(dout1_30) AT=140.05n

.meas tran vdout1_31ck130 FIND v(dout1_31) AT=140.05n

.meas tran vdout1_0ck140 FIND v(dout1_0) AT=150.05n

.meas tran vdout1_1ck140 FIND v(dout1_1) AT=150.05n

.meas tran vdout1_2ck140 FIND v(dout1_2) AT=150.05n

.meas tran vdout1_3ck140 FIND v(dout1_3) AT=150.05n

.meas tran vdout1_4ck140 FIND v(dout1_4) AT=150.05n

.meas tran vdout1_5ck140 FIND v(dout1_5) AT=150.05n

.meas tran vdout1_6ck140 FIND v(dout1_6) AT=150.05n

.meas tran vdout1_7ck140 FIND v(dout1_7) AT=150.05n

.meas tran vdout1_8ck140 FIND v(dout1_8) AT=150.05n

.meas tran vdout1_9ck140 FIND v(dout1_9) AT=150.05n

.meas tran vdout1_10ck140 FIND v(dout1_10) AT=150.05n

.meas tran vdout1_11ck140 FIND v(dout1_11) AT=150.05n

.meas tran vdout1_12ck140 FIND v(dout1_12) AT=150.05n

.meas tran vdout1_13ck140 FIND v(dout1_13) AT=150.05n

.meas tran vdout1_14ck140 FIND v(dout1_14) AT=150.05n

.meas tran vdout1_15ck140 FIND v(dout1_15) AT=150.05n

.meas tran vdout1_16ck140 FIND v(dout1_16) AT=150.05n

.meas tran vdout1_17ck140 FIND v(dout1_17) AT=150.05n

.meas tran vdout1_18ck140 FIND v(dout1_18) AT=150.05n

.meas tran vdout1_19ck140 FIND v(dout1_19) AT=150.05n

.meas tran vdout1_20ck140 FIND v(dout1_20) AT=150.05n

.meas tran vdout1_21ck140 FIND v(dout1_21) AT=150.05n

.meas tran vdout1_22ck140 FIND v(dout1_22) AT=150.05n

.meas tran vdout1_23ck140 FIND v(dout1_23) AT=150.05n

.meas tran vdout1_24ck140 FIND v(dout1_24) AT=150.05n

.meas tran vdout1_25ck140 FIND v(dout1_25) AT=150.05n

.meas tran vdout1_26ck140 FIND v(dout1_26) AT=150.05n

.meas tran vdout1_27ck140 FIND v(dout1_27) AT=150.05n

.meas tran vdout1_28ck140 FIND v(dout1_28) AT=150.05n

.meas tran vdout1_29ck140 FIND v(dout1_29) AT=150.05n

.meas tran vdout1_30ck140 FIND v(dout1_30) AT=150.05n

.meas tran vdout1_31ck140 FIND v(dout1_31) AT=150.05n

.meas tran vdout0_0ck160 FIND v(dout0_0) AT=170.05n

.meas tran vdout0_1ck160 FIND v(dout0_1) AT=170.05n

.meas tran vdout0_2ck160 FIND v(dout0_2) AT=170.05n

.meas tran vdout0_3ck160 FIND v(dout0_3) AT=170.05n

.meas tran vdout0_4ck160 FIND v(dout0_4) AT=170.05n

.meas tran vdout0_5ck160 FIND v(dout0_5) AT=170.05n

.meas tran vdout0_6ck160 FIND v(dout0_6) AT=170.05n

.meas tran vdout0_7ck160 FIND v(dout0_7) AT=170.05n

.meas tran vdout0_8ck160 FIND v(dout0_8) AT=170.05n

.meas tran vdout0_9ck160 FIND v(dout0_9) AT=170.05n

.meas tran vdout0_10ck160 FIND v(dout0_10) AT=170.05n

.meas tran vdout0_11ck160 FIND v(dout0_11) AT=170.05n

.meas tran vdout0_12ck160 FIND v(dout0_12) AT=170.05n

.meas tran vdout0_13ck160 FIND v(dout0_13) AT=170.05n

.meas tran vdout0_14ck160 FIND v(dout0_14) AT=170.05n

.meas tran vdout0_15ck160 FIND v(dout0_15) AT=170.05n

.meas tran vdout0_16ck160 FIND v(dout0_16) AT=170.05n

.meas tran vdout0_17ck160 FIND v(dout0_17) AT=170.05n

.meas tran vdout0_18ck160 FIND v(dout0_18) AT=170.05n

.meas tran vdout0_19ck160 FIND v(dout0_19) AT=170.05n

.meas tran vdout0_20ck160 FIND v(dout0_20) AT=170.05n

.meas tran vdout0_21ck160 FIND v(dout0_21) AT=170.05n

.meas tran vdout0_22ck160 FIND v(dout0_22) AT=170.05n

.meas tran vdout0_23ck160 FIND v(dout0_23) AT=170.05n

.meas tran vdout0_24ck160 FIND v(dout0_24) AT=170.05n

.meas tran vdout0_25ck160 FIND v(dout0_25) AT=170.05n

.meas tran vdout0_26ck160 FIND v(dout0_26) AT=170.05n

.meas tran vdout0_27ck160 FIND v(dout0_27) AT=170.05n

.meas tran vdout0_28ck160 FIND v(dout0_28) AT=170.05n

.meas tran vdout0_29ck160 FIND v(dout0_29) AT=170.05n

.meas tran vdout0_30ck160 FIND v(dout0_30) AT=170.05n

.meas tran vdout0_31ck160 FIND v(dout0_31) AT=170.05n

.meas tran vdout0_0ck180 FIND v(dout0_0) AT=190.05n

.meas tran vdout0_1ck180 FIND v(dout0_1) AT=190.05n

.meas tran vdout0_2ck180 FIND v(dout0_2) AT=190.05n

.meas tran vdout0_3ck180 FIND v(dout0_3) AT=190.05n

.meas tran vdout0_4ck180 FIND v(dout0_4) AT=190.05n

.meas tran vdout0_5ck180 FIND v(dout0_5) AT=190.05n

.meas tran vdout0_6ck180 FIND v(dout0_6) AT=190.05n

.meas tran vdout0_7ck180 FIND v(dout0_7) AT=190.05n

.meas tran vdout0_8ck180 FIND v(dout0_8) AT=190.05n

.meas tran vdout0_9ck180 FIND v(dout0_9) AT=190.05n

.meas tran vdout0_10ck180 FIND v(dout0_10) AT=190.05n

.meas tran vdout0_11ck180 FIND v(dout0_11) AT=190.05n

.meas tran vdout0_12ck180 FIND v(dout0_12) AT=190.05n

.meas tran vdout0_13ck180 FIND v(dout0_13) AT=190.05n

.meas tran vdout0_14ck180 FIND v(dout0_14) AT=190.05n

.meas tran vdout0_15ck180 FIND v(dout0_15) AT=190.05n

.meas tran vdout0_16ck180 FIND v(dout0_16) AT=190.05n

.meas tran vdout0_17ck180 FIND v(dout0_17) AT=190.05n

.meas tran vdout0_18ck180 FIND v(dout0_18) AT=190.05n

.meas tran vdout0_19ck180 FIND v(dout0_19) AT=190.05n

.meas tran vdout0_20ck180 FIND v(dout0_20) AT=190.05n

.meas tran vdout0_21ck180 FIND v(dout0_21) AT=190.05n

.meas tran vdout0_22ck180 FIND v(dout0_22) AT=190.05n

.meas tran vdout0_23ck180 FIND v(dout0_23) AT=190.05n

.meas tran vdout0_24ck180 FIND v(dout0_24) AT=190.05n

.meas tran vdout0_25ck180 FIND v(dout0_25) AT=190.05n

.meas tran vdout0_26ck180 FIND v(dout0_26) AT=190.05n

.meas tran vdout0_27ck180 FIND v(dout0_27) AT=190.05n

.meas tran vdout0_28ck180 FIND v(dout0_28) AT=190.05n

.meas tran vdout0_29ck180 FIND v(dout0_29) AT=190.05n

.meas tran vdout0_30ck180 FIND v(dout0_30) AT=190.05n

.meas tran vdout0_31ck180 FIND v(dout0_31) AT=190.05n

.meas tran vdout1_0ck180 FIND v(dout1_0) AT=190.05n

.meas tran vdout1_1ck180 FIND v(dout1_1) AT=190.05n

.meas tran vdout1_2ck180 FIND v(dout1_2) AT=190.05n

.meas tran vdout1_3ck180 FIND v(dout1_3) AT=190.05n

.meas tran vdout1_4ck180 FIND v(dout1_4) AT=190.05n

.meas tran vdout1_5ck180 FIND v(dout1_5) AT=190.05n

.meas tran vdout1_6ck180 FIND v(dout1_6) AT=190.05n

.meas tran vdout1_7ck180 FIND v(dout1_7) AT=190.05n

.meas tran vdout1_8ck180 FIND v(dout1_8) AT=190.05n

.meas tran vdout1_9ck180 FIND v(dout1_9) AT=190.05n

.meas tran vdout1_10ck180 FIND v(dout1_10) AT=190.05n

.meas tran vdout1_11ck180 FIND v(dout1_11) AT=190.05n

.meas tran vdout1_12ck180 FIND v(dout1_12) AT=190.05n

.meas tran vdout1_13ck180 FIND v(dout1_13) AT=190.05n

.meas tran vdout1_14ck180 FIND v(dout1_14) AT=190.05n

.meas tran vdout1_15ck180 FIND v(dout1_15) AT=190.05n

.meas tran vdout1_16ck180 FIND v(dout1_16) AT=190.05n

.meas tran vdout1_17ck180 FIND v(dout1_17) AT=190.05n

.meas tran vdout1_18ck180 FIND v(dout1_18) AT=190.05n

.meas tran vdout1_19ck180 FIND v(dout1_19) AT=190.05n

.meas tran vdout1_20ck180 FIND v(dout1_20) AT=190.05n

.meas tran vdout1_21ck180 FIND v(dout1_21) AT=190.05n

.meas tran vdout1_22ck180 FIND v(dout1_22) AT=190.05n

.meas tran vdout1_23ck180 FIND v(dout1_23) AT=190.05n

.meas tran vdout1_24ck180 FIND v(dout1_24) AT=190.05n

.meas tran vdout1_25ck180 FIND v(dout1_25) AT=190.05n

.meas tran vdout1_26ck180 FIND v(dout1_26) AT=190.05n

.meas tran vdout1_27ck180 FIND v(dout1_27) AT=190.05n

.meas tran vdout1_28ck180 FIND v(dout1_28) AT=190.05n

.meas tran vdout1_29ck180 FIND v(dout1_29) AT=190.05n

.meas tran vdout1_30ck180 FIND v(dout1_30) AT=190.05n

.meas tran vdout1_31ck180 FIND v(dout1_31) AT=190.05n

.meas tran vdout0_0ck200 FIND v(dout0_0) AT=210.05n

.meas tran vdout0_1ck200 FIND v(dout0_1) AT=210.05n

.meas tran vdout0_2ck200 FIND v(dout0_2) AT=210.05n

.meas tran vdout0_3ck200 FIND v(dout0_3) AT=210.05n

.meas tran vdout0_4ck200 FIND v(dout0_4) AT=210.05n

.meas tran vdout0_5ck200 FIND v(dout0_5) AT=210.05n

.meas tran vdout0_6ck200 FIND v(dout0_6) AT=210.05n

.meas tran vdout0_7ck200 FIND v(dout0_7) AT=210.05n

.meas tran vdout0_8ck200 FIND v(dout0_8) AT=210.05n

.meas tran vdout0_9ck200 FIND v(dout0_9) AT=210.05n

.meas tran vdout0_10ck200 FIND v(dout0_10) AT=210.05n

.meas tran vdout0_11ck200 FIND v(dout0_11) AT=210.05n

.meas tran vdout0_12ck200 FIND v(dout0_12) AT=210.05n

.meas tran vdout0_13ck200 FIND v(dout0_13) AT=210.05n

.meas tran vdout0_14ck200 FIND v(dout0_14) AT=210.05n

.meas tran vdout0_15ck200 FIND v(dout0_15) AT=210.05n

.meas tran vdout0_16ck200 FIND v(dout0_16) AT=210.05n

.meas tran vdout0_17ck200 FIND v(dout0_17) AT=210.05n

.meas tran vdout0_18ck200 FIND v(dout0_18) AT=210.05n

.meas tran vdout0_19ck200 FIND v(dout0_19) AT=210.05n

.meas tran vdout0_20ck200 FIND v(dout0_20) AT=210.05n

.meas tran vdout0_21ck200 FIND v(dout0_21) AT=210.05n

.meas tran vdout0_22ck200 FIND v(dout0_22) AT=210.05n

.meas tran vdout0_23ck200 FIND v(dout0_23) AT=210.05n

.meas tran vdout0_24ck200 FIND v(dout0_24) AT=210.05n

.meas tran vdout0_25ck200 FIND v(dout0_25) AT=210.05n

.meas tran vdout0_26ck200 FIND v(dout0_26) AT=210.05n

.meas tran vdout0_27ck200 FIND v(dout0_27) AT=210.05n

.meas tran vdout0_28ck200 FIND v(dout0_28) AT=210.05n

.meas tran vdout0_29ck200 FIND v(dout0_29) AT=210.05n

.meas tran vdout0_30ck200 FIND v(dout0_30) AT=210.05n

.meas tran vdout0_31ck200 FIND v(dout0_31) AT=210.05n

.meas tran vdout0_0ck210 FIND v(dout0_0) AT=220.05n

.meas tran vdout0_1ck210 FIND v(dout0_1) AT=220.05n

.meas tran vdout0_2ck210 FIND v(dout0_2) AT=220.05n

.meas tran vdout0_3ck210 FIND v(dout0_3) AT=220.05n

.meas tran vdout0_4ck210 FIND v(dout0_4) AT=220.05n

.meas tran vdout0_5ck210 FIND v(dout0_5) AT=220.05n

.meas tran vdout0_6ck210 FIND v(dout0_6) AT=220.05n

.meas tran vdout0_7ck210 FIND v(dout0_7) AT=220.05n

.meas tran vdout0_8ck210 FIND v(dout0_8) AT=220.05n

.meas tran vdout0_9ck210 FIND v(dout0_9) AT=220.05n

.meas tran vdout0_10ck210 FIND v(dout0_10) AT=220.05n

.meas tran vdout0_11ck210 FIND v(dout0_11) AT=220.05n

.meas tran vdout0_12ck210 FIND v(dout0_12) AT=220.05n

.meas tran vdout0_13ck210 FIND v(dout0_13) AT=220.05n

.meas tran vdout0_14ck210 FIND v(dout0_14) AT=220.05n

.meas tran vdout0_15ck210 FIND v(dout0_15) AT=220.05n

.meas tran vdout0_16ck210 FIND v(dout0_16) AT=220.05n

.meas tran vdout0_17ck210 FIND v(dout0_17) AT=220.05n

.meas tran vdout0_18ck210 FIND v(dout0_18) AT=220.05n

.meas tran vdout0_19ck210 FIND v(dout0_19) AT=220.05n

.meas tran vdout0_20ck210 FIND v(dout0_20) AT=220.05n

.meas tran vdout0_21ck210 FIND v(dout0_21) AT=220.05n

.meas tran vdout0_22ck210 FIND v(dout0_22) AT=220.05n

.meas tran vdout0_23ck210 FIND v(dout0_23) AT=220.05n

.meas tran vdout0_24ck210 FIND v(dout0_24) AT=220.05n

.meas tran vdout0_25ck210 FIND v(dout0_25) AT=220.05n

.meas tran vdout0_26ck210 FIND v(dout0_26) AT=220.05n

.meas tran vdout0_27ck210 FIND v(dout0_27) AT=220.05n

.meas tran vdout0_28ck210 FIND v(dout0_28) AT=220.05n

.meas tran vdout0_29ck210 FIND v(dout0_29) AT=220.05n

.meas tran vdout0_30ck210 FIND v(dout0_30) AT=220.05n

.meas tran vdout0_31ck210 FIND v(dout0_31) AT=220.05n

.meas tran vdout1_0ck210 FIND v(dout1_0) AT=220.05n

.meas tran vdout1_1ck210 FIND v(dout1_1) AT=220.05n

.meas tran vdout1_2ck210 FIND v(dout1_2) AT=220.05n

.meas tran vdout1_3ck210 FIND v(dout1_3) AT=220.05n

.meas tran vdout1_4ck210 FIND v(dout1_4) AT=220.05n

.meas tran vdout1_5ck210 FIND v(dout1_5) AT=220.05n

.meas tran vdout1_6ck210 FIND v(dout1_6) AT=220.05n

.meas tran vdout1_7ck210 FIND v(dout1_7) AT=220.05n

.meas tran vdout1_8ck210 FIND v(dout1_8) AT=220.05n

.meas tran vdout1_9ck210 FIND v(dout1_9) AT=220.05n

.meas tran vdout1_10ck210 FIND v(dout1_10) AT=220.05n

.meas tran vdout1_11ck210 FIND v(dout1_11) AT=220.05n

.meas tran vdout1_12ck210 FIND v(dout1_12) AT=220.05n

.meas tran vdout1_13ck210 FIND v(dout1_13) AT=220.05n

.meas tran vdout1_14ck210 FIND v(dout1_14) AT=220.05n

.meas tran vdout1_15ck210 FIND v(dout1_15) AT=220.05n

.meas tran vdout1_16ck210 FIND v(dout1_16) AT=220.05n

.meas tran vdout1_17ck210 FIND v(dout1_17) AT=220.05n

.meas tran vdout1_18ck210 FIND v(dout1_18) AT=220.05n

.meas tran vdout1_19ck210 FIND v(dout1_19) AT=220.05n

.meas tran vdout1_20ck210 FIND v(dout1_20) AT=220.05n

.meas tran vdout1_21ck210 FIND v(dout1_21) AT=220.05n

.meas tran vdout1_22ck210 FIND v(dout1_22) AT=220.05n

.meas tran vdout1_23ck210 FIND v(dout1_23) AT=220.05n

.meas tran vdout1_24ck210 FIND v(dout1_24) AT=220.05n

.meas tran vdout1_25ck210 FIND v(dout1_25) AT=220.05n

.meas tran vdout1_26ck210 FIND v(dout1_26) AT=220.05n

.meas tran vdout1_27ck210 FIND v(dout1_27) AT=220.05n

.meas tran vdout1_28ck210 FIND v(dout1_28) AT=220.05n

.meas tran vdout1_29ck210 FIND v(dout1_29) AT=220.05n

.meas tran vdout1_30ck210 FIND v(dout1_30) AT=220.05n

.meas tran vdout1_31ck210 FIND v(dout1_31) AT=220.05n

.meas tran vdout0_0ck220 FIND v(dout0_0) AT=230.05n

.meas tran vdout0_1ck220 FIND v(dout0_1) AT=230.05n

.meas tran vdout0_2ck220 FIND v(dout0_2) AT=230.05n

.meas tran vdout0_3ck220 FIND v(dout0_3) AT=230.05n

.meas tran vdout0_4ck220 FIND v(dout0_4) AT=230.05n

.meas tran vdout0_5ck220 FIND v(dout0_5) AT=230.05n

.meas tran vdout0_6ck220 FIND v(dout0_6) AT=230.05n

.meas tran vdout0_7ck220 FIND v(dout0_7) AT=230.05n

.meas tran vdout0_8ck220 FIND v(dout0_8) AT=230.05n

.meas tran vdout0_9ck220 FIND v(dout0_9) AT=230.05n

.meas tran vdout0_10ck220 FIND v(dout0_10) AT=230.05n

.meas tran vdout0_11ck220 FIND v(dout0_11) AT=230.05n

.meas tran vdout0_12ck220 FIND v(dout0_12) AT=230.05n

.meas tran vdout0_13ck220 FIND v(dout0_13) AT=230.05n

.meas tran vdout0_14ck220 FIND v(dout0_14) AT=230.05n

.meas tran vdout0_15ck220 FIND v(dout0_15) AT=230.05n

.meas tran vdout0_16ck220 FIND v(dout0_16) AT=230.05n

.meas tran vdout0_17ck220 FIND v(dout0_17) AT=230.05n

.meas tran vdout0_18ck220 FIND v(dout0_18) AT=230.05n

.meas tran vdout0_19ck220 FIND v(dout0_19) AT=230.05n

.meas tran vdout0_20ck220 FIND v(dout0_20) AT=230.05n

.meas tran vdout0_21ck220 FIND v(dout0_21) AT=230.05n

.meas tran vdout0_22ck220 FIND v(dout0_22) AT=230.05n

.meas tran vdout0_23ck220 FIND v(dout0_23) AT=230.05n

.meas tran vdout0_24ck220 FIND v(dout0_24) AT=230.05n

.meas tran vdout0_25ck220 FIND v(dout0_25) AT=230.05n

.meas tran vdout0_26ck220 FIND v(dout0_26) AT=230.05n

.meas tran vdout0_27ck220 FIND v(dout0_27) AT=230.05n

.meas tran vdout0_28ck220 FIND v(dout0_28) AT=230.05n

.meas tran vdout0_29ck220 FIND v(dout0_29) AT=230.05n

.meas tran vdout0_30ck220 FIND v(dout0_30) AT=230.05n

.meas tran vdout0_31ck220 FIND v(dout0_31) AT=230.05n

.meas tran vdout1_0ck220 FIND v(dout1_0) AT=230.05n

.meas tran vdout1_1ck220 FIND v(dout1_1) AT=230.05n

.meas tran vdout1_2ck220 FIND v(dout1_2) AT=230.05n

.meas tran vdout1_3ck220 FIND v(dout1_3) AT=230.05n

.meas tran vdout1_4ck220 FIND v(dout1_4) AT=230.05n

.meas tran vdout1_5ck220 FIND v(dout1_5) AT=230.05n

.meas tran vdout1_6ck220 FIND v(dout1_6) AT=230.05n

.meas tran vdout1_7ck220 FIND v(dout1_7) AT=230.05n

.meas tran vdout1_8ck220 FIND v(dout1_8) AT=230.05n

.meas tran vdout1_9ck220 FIND v(dout1_9) AT=230.05n

.meas tran vdout1_10ck220 FIND v(dout1_10) AT=230.05n

.meas tran vdout1_11ck220 FIND v(dout1_11) AT=230.05n

.meas tran vdout1_12ck220 FIND v(dout1_12) AT=230.05n

.meas tran vdout1_13ck220 FIND v(dout1_13) AT=230.05n

.meas tran vdout1_14ck220 FIND v(dout1_14) AT=230.05n

.meas tran vdout1_15ck220 FIND v(dout1_15) AT=230.05n

.meas tran vdout1_16ck220 FIND v(dout1_16) AT=230.05n

.meas tran vdout1_17ck220 FIND v(dout1_17) AT=230.05n

.meas tran vdout1_18ck220 FIND v(dout1_18) AT=230.05n

.meas tran vdout1_19ck220 FIND v(dout1_19) AT=230.05n

.meas tran vdout1_20ck220 FIND v(dout1_20) AT=230.05n

.meas tran vdout1_21ck220 FIND v(dout1_21) AT=230.05n

.meas tran vdout1_22ck220 FIND v(dout1_22) AT=230.05n

.meas tran vdout1_23ck220 FIND v(dout1_23) AT=230.05n

.meas tran vdout1_24ck220 FIND v(dout1_24) AT=230.05n

.meas tran vdout1_25ck220 FIND v(dout1_25) AT=230.05n

.meas tran vdout1_26ck220 FIND v(dout1_26) AT=230.05n

.meas tran vdout1_27ck220 FIND v(dout1_27) AT=230.05n

.meas tran vdout1_28ck220 FIND v(dout1_28) AT=230.05n

.meas tran vdout1_29ck220 FIND v(dout1_29) AT=230.05n

.meas tran vdout1_30ck220 FIND v(dout1_30) AT=230.05n

.meas tran vdout1_31ck220 FIND v(dout1_31) AT=230.05n

.meas tran vdout0_0ck240 FIND v(dout0_0) AT=250.05n

.meas tran vdout0_1ck240 FIND v(dout0_1) AT=250.05n

.meas tran vdout0_2ck240 FIND v(dout0_2) AT=250.05n

.meas tran vdout0_3ck240 FIND v(dout0_3) AT=250.05n

.meas tran vdout0_4ck240 FIND v(dout0_4) AT=250.05n

.meas tran vdout0_5ck240 FIND v(dout0_5) AT=250.05n

.meas tran vdout0_6ck240 FIND v(dout0_6) AT=250.05n

.meas tran vdout0_7ck240 FIND v(dout0_7) AT=250.05n

.meas tran vdout0_8ck240 FIND v(dout0_8) AT=250.05n

.meas tran vdout0_9ck240 FIND v(dout0_9) AT=250.05n

.meas tran vdout0_10ck240 FIND v(dout0_10) AT=250.05n

.meas tran vdout0_11ck240 FIND v(dout0_11) AT=250.05n

.meas tran vdout0_12ck240 FIND v(dout0_12) AT=250.05n

.meas tran vdout0_13ck240 FIND v(dout0_13) AT=250.05n

.meas tran vdout0_14ck240 FIND v(dout0_14) AT=250.05n

.meas tran vdout0_15ck240 FIND v(dout0_15) AT=250.05n

.meas tran vdout0_16ck240 FIND v(dout0_16) AT=250.05n

.meas tran vdout0_17ck240 FIND v(dout0_17) AT=250.05n

.meas tran vdout0_18ck240 FIND v(dout0_18) AT=250.05n

.meas tran vdout0_19ck240 FIND v(dout0_19) AT=250.05n

.meas tran vdout0_20ck240 FIND v(dout0_20) AT=250.05n

.meas tran vdout0_21ck240 FIND v(dout0_21) AT=250.05n

.meas tran vdout0_22ck240 FIND v(dout0_22) AT=250.05n

.meas tran vdout0_23ck240 FIND v(dout0_23) AT=250.05n

.meas tran vdout0_24ck240 FIND v(dout0_24) AT=250.05n

.meas tran vdout0_25ck240 FIND v(dout0_25) AT=250.05n

.meas tran vdout0_26ck240 FIND v(dout0_26) AT=250.05n

.meas tran vdout0_27ck240 FIND v(dout0_27) AT=250.05n

.meas tran vdout0_28ck240 FIND v(dout0_28) AT=250.05n

.meas tran vdout0_29ck240 FIND v(dout0_29) AT=250.05n

.meas tran vdout0_30ck240 FIND v(dout0_30) AT=250.05n

.meas tran vdout0_31ck240 FIND v(dout0_31) AT=250.05n

.meas tran vdout1_0ck240 FIND v(dout1_0) AT=250.05n

.meas tran vdout1_1ck240 FIND v(dout1_1) AT=250.05n

.meas tran vdout1_2ck240 FIND v(dout1_2) AT=250.05n

.meas tran vdout1_3ck240 FIND v(dout1_3) AT=250.05n

.meas tran vdout1_4ck240 FIND v(dout1_4) AT=250.05n

.meas tran vdout1_5ck240 FIND v(dout1_5) AT=250.05n

.meas tran vdout1_6ck240 FIND v(dout1_6) AT=250.05n

.meas tran vdout1_7ck240 FIND v(dout1_7) AT=250.05n

.meas tran vdout1_8ck240 FIND v(dout1_8) AT=250.05n

.meas tran vdout1_9ck240 FIND v(dout1_9) AT=250.05n

.meas tran vdout1_10ck240 FIND v(dout1_10) AT=250.05n

.meas tran vdout1_11ck240 FIND v(dout1_11) AT=250.05n

.meas tran vdout1_12ck240 FIND v(dout1_12) AT=250.05n

.meas tran vdout1_13ck240 FIND v(dout1_13) AT=250.05n

.meas tran vdout1_14ck240 FIND v(dout1_14) AT=250.05n

.meas tran vdout1_15ck240 FIND v(dout1_15) AT=250.05n

.meas tran vdout1_16ck240 FIND v(dout1_16) AT=250.05n

.meas tran vdout1_17ck240 FIND v(dout1_17) AT=250.05n

.meas tran vdout1_18ck240 FIND v(dout1_18) AT=250.05n

.meas tran vdout1_19ck240 FIND v(dout1_19) AT=250.05n

.meas tran vdout1_20ck240 FIND v(dout1_20) AT=250.05n

.meas tran vdout1_21ck240 FIND v(dout1_21) AT=250.05n

.meas tran vdout1_22ck240 FIND v(dout1_22) AT=250.05n

.meas tran vdout1_23ck240 FIND v(dout1_23) AT=250.05n

.meas tran vdout1_24ck240 FIND v(dout1_24) AT=250.05n

.meas tran vdout1_25ck240 FIND v(dout1_25) AT=250.05n

.meas tran vdout1_26ck240 FIND v(dout1_26) AT=250.05n

.meas tran vdout1_27ck240 FIND v(dout1_27) AT=250.05n

.meas tran vdout1_28ck240 FIND v(dout1_28) AT=250.05n

.meas tran vdout1_29ck240 FIND v(dout1_29) AT=250.05n

.meas tran vdout1_30ck240 FIND v(dout1_30) AT=250.05n

.meas tran vdout1_31ck240 FIND v(dout1_31) AT=250.05n

.meas tran vdout0_0ck250 FIND v(dout0_0) AT=260.05n

.meas tran vdout0_1ck250 FIND v(dout0_1) AT=260.05n

.meas tran vdout0_2ck250 FIND v(dout0_2) AT=260.05n

.meas tran vdout0_3ck250 FIND v(dout0_3) AT=260.05n

.meas tran vdout0_4ck250 FIND v(dout0_4) AT=260.05n

.meas tran vdout0_5ck250 FIND v(dout0_5) AT=260.05n

.meas tran vdout0_6ck250 FIND v(dout0_6) AT=260.05n

.meas tran vdout0_7ck250 FIND v(dout0_7) AT=260.05n

.meas tran vdout0_8ck250 FIND v(dout0_8) AT=260.05n

.meas tran vdout0_9ck250 FIND v(dout0_9) AT=260.05n

.meas tran vdout0_10ck250 FIND v(dout0_10) AT=260.05n

.meas tran vdout0_11ck250 FIND v(dout0_11) AT=260.05n

.meas tran vdout0_12ck250 FIND v(dout0_12) AT=260.05n

.meas tran vdout0_13ck250 FIND v(dout0_13) AT=260.05n

.meas tran vdout0_14ck250 FIND v(dout0_14) AT=260.05n

.meas tran vdout0_15ck250 FIND v(dout0_15) AT=260.05n

.meas tran vdout0_16ck250 FIND v(dout0_16) AT=260.05n

.meas tran vdout0_17ck250 FIND v(dout0_17) AT=260.05n

.meas tran vdout0_18ck250 FIND v(dout0_18) AT=260.05n

.meas tran vdout0_19ck250 FIND v(dout0_19) AT=260.05n

.meas tran vdout0_20ck250 FIND v(dout0_20) AT=260.05n

.meas tran vdout0_21ck250 FIND v(dout0_21) AT=260.05n

.meas tran vdout0_22ck250 FIND v(dout0_22) AT=260.05n

.meas tran vdout0_23ck250 FIND v(dout0_23) AT=260.05n

.meas tran vdout0_24ck250 FIND v(dout0_24) AT=260.05n

.meas tran vdout0_25ck250 FIND v(dout0_25) AT=260.05n

.meas tran vdout0_26ck250 FIND v(dout0_26) AT=260.05n

.meas tran vdout0_27ck250 FIND v(dout0_27) AT=260.05n

.meas tran vdout0_28ck250 FIND v(dout0_28) AT=260.05n

.meas tran vdout0_29ck250 FIND v(dout0_29) AT=260.05n

.meas tran vdout0_30ck250 FIND v(dout0_30) AT=260.05n

.meas tran vdout0_31ck250 FIND v(dout0_31) AT=260.05n

.meas tran vdout0_0ck260 FIND v(dout0_0) AT=270.05n

.meas tran vdout0_1ck260 FIND v(dout0_1) AT=270.05n

.meas tran vdout0_2ck260 FIND v(dout0_2) AT=270.05n

.meas tran vdout0_3ck260 FIND v(dout0_3) AT=270.05n

.meas tran vdout0_4ck260 FIND v(dout0_4) AT=270.05n

.meas tran vdout0_5ck260 FIND v(dout0_5) AT=270.05n

.meas tran vdout0_6ck260 FIND v(dout0_6) AT=270.05n

.meas tran vdout0_7ck260 FIND v(dout0_7) AT=270.05n

.meas tran vdout0_8ck260 FIND v(dout0_8) AT=270.05n

.meas tran vdout0_9ck260 FIND v(dout0_9) AT=270.05n

.meas tran vdout0_10ck260 FIND v(dout0_10) AT=270.05n

.meas tran vdout0_11ck260 FIND v(dout0_11) AT=270.05n

.meas tran vdout0_12ck260 FIND v(dout0_12) AT=270.05n

.meas tran vdout0_13ck260 FIND v(dout0_13) AT=270.05n

.meas tran vdout0_14ck260 FIND v(dout0_14) AT=270.05n

.meas tran vdout0_15ck260 FIND v(dout0_15) AT=270.05n

.meas tran vdout0_16ck260 FIND v(dout0_16) AT=270.05n

.meas tran vdout0_17ck260 FIND v(dout0_17) AT=270.05n

.meas tran vdout0_18ck260 FIND v(dout0_18) AT=270.05n

.meas tran vdout0_19ck260 FIND v(dout0_19) AT=270.05n

.meas tran vdout0_20ck260 FIND v(dout0_20) AT=270.05n

.meas tran vdout0_21ck260 FIND v(dout0_21) AT=270.05n

.meas tran vdout0_22ck260 FIND v(dout0_22) AT=270.05n

.meas tran vdout0_23ck260 FIND v(dout0_23) AT=270.05n

.meas tran vdout0_24ck260 FIND v(dout0_24) AT=270.05n

.meas tran vdout0_25ck260 FIND v(dout0_25) AT=270.05n

.meas tran vdout0_26ck260 FIND v(dout0_26) AT=270.05n

.meas tran vdout0_27ck260 FIND v(dout0_27) AT=270.05n

.meas tran vdout0_28ck260 FIND v(dout0_28) AT=270.05n

.meas tran vdout0_29ck260 FIND v(dout0_29) AT=270.05n

.meas tran vdout0_30ck260 FIND v(dout0_30) AT=270.05n

.meas tran vdout0_31ck260 FIND v(dout0_31) AT=270.05n

.meas tran vdout1_0ck270 FIND v(dout1_0) AT=280.05n

.meas tran vdout1_1ck270 FIND v(dout1_1) AT=280.05n

.meas tran vdout1_2ck270 FIND v(dout1_2) AT=280.05n

.meas tran vdout1_3ck270 FIND v(dout1_3) AT=280.05n

.meas tran vdout1_4ck270 FIND v(dout1_4) AT=280.05n

.meas tran vdout1_5ck270 FIND v(dout1_5) AT=280.05n

.meas tran vdout1_6ck270 FIND v(dout1_6) AT=280.05n

.meas tran vdout1_7ck270 FIND v(dout1_7) AT=280.05n

.meas tran vdout1_8ck270 FIND v(dout1_8) AT=280.05n

.meas tran vdout1_9ck270 FIND v(dout1_9) AT=280.05n

.meas tran vdout1_10ck270 FIND v(dout1_10) AT=280.05n

.meas tran vdout1_11ck270 FIND v(dout1_11) AT=280.05n

.meas tran vdout1_12ck270 FIND v(dout1_12) AT=280.05n

.meas tran vdout1_13ck270 FIND v(dout1_13) AT=280.05n

.meas tran vdout1_14ck270 FIND v(dout1_14) AT=280.05n

.meas tran vdout1_15ck270 FIND v(dout1_15) AT=280.05n

.meas tran vdout1_16ck270 FIND v(dout1_16) AT=280.05n

.meas tran vdout1_17ck270 FIND v(dout1_17) AT=280.05n

.meas tran vdout1_18ck270 FIND v(dout1_18) AT=280.05n

.meas tran vdout1_19ck270 FIND v(dout1_19) AT=280.05n

.meas tran vdout1_20ck270 FIND v(dout1_20) AT=280.05n

.meas tran vdout1_21ck270 FIND v(dout1_21) AT=280.05n

.meas tran vdout1_22ck270 FIND v(dout1_22) AT=280.05n

.meas tran vdout1_23ck270 FIND v(dout1_23) AT=280.05n

.meas tran vdout1_24ck270 FIND v(dout1_24) AT=280.05n

.meas tran vdout1_25ck270 FIND v(dout1_25) AT=280.05n

.meas tran vdout1_26ck270 FIND v(dout1_26) AT=280.05n

.meas tran vdout1_27ck270 FIND v(dout1_27) AT=280.05n

.meas tran vdout1_28ck270 FIND v(dout1_28) AT=280.05n

.meas tran vdout1_29ck270 FIND v(dout1_29) AT=280.05n

.meas tran vdout1_30ck270 FIND v(dout1_30) AT=280.05n

.meas tran vdout1_31ck270 FIND v(dout1_31) AT=280.05n

.meas tran vdout0_0ck280 FIND v(dout0_0) AT=290.05n

.meas tran vdout0_1ck280 FIND v(dout0_1) AT=290.05n

.meas tran vdout0_2ck280 FIND v(dout0_2) AT=290.05n

.meas tran vdout0_3ck280 FIND v(dout0_3) AT=290.05n

.meas tran vdout0_4ck280 FIND v(dout0_4) AT=290.05n

.meas tran vdout0_5ck280 FIND v(dout0_5) AT=290.05n

.meas tran vdout0_6ck280 FIND v(dout0_6) AT=290.05n

.meas tran vdout0_7ck280 FIND v(dout0_7) AT=290.05n

.meas tran vdout0_8ck280 FIND v(dout0_8) AT=290.05n

.meas tran vdout0_9ck280 FIND v(dout0_9) AT=290.05n

.meas tran vdout0_10ck280 FIND v(dout0_10) AT=290.05n

.meas tran vdout0_11ck280 FIND v(dout0_11) AT=290.05n

.meas tran vdout0_12ck280 FIND v(dout0_12) AT=290.05n

.meas tran vdout0_13ck280 FIND v(dout0_13) AT=290.05n

.meas tran vdout0_14ck280 FIND v(dout0_14) AT=290.05n

.meas tran vdout0_15ck280 FIND v(dout0_15) AT=290.05n

.meas tran vdout0_16ck280 FIND v(dout0_16) AT=290.05n

.meas tran vdout0_17ck280 FIND v(dout0_17) AT=290.05n

.meas tran vdout0_18ck280 FIND v(dout0_18) AT=290.05n

.meas tran vdout0_19ck280 FIND v(dout0_19) AT=290.05n

.meas tran vdout0_20ck280 FIND v(dout0_20) AT=290.05n

.meas tran vdout0_21ck280 FIND v(dout0_21) AT=290.05n

.meas tran vdout0_22ck280 FIND v(dout0_22) AT=290.05n

.meas tran vdout0_23ck280 FIND v(dout0_23) AT=290.05n

.meas tran vdout0_24ck280 FIND v(dout0_24) AT=290.05n

.meas tran vdout0_25ck280 FIND v(dout0_25) AT=290.05n

.meas tran vdout0_26ck280 FIND v(dout0_26) AT=290.05n

.meas tran vdout0_27ck280 FIND v(dout0_27) AT=290.05n

.meas tran vdout0_28ck280 FIND v(dout0_28) AT=290.05n

.meas tran vdout0_29ck280 FIND v(dout0_29) AT=290.05n

.meas tran vdout0_30ck280 FIND v(dout0_30) AT=290.05n

.meas tran vdout0_31ck280 FIND v(dout0_31) AT=290.05n

.meas tran vdout1_0ck280 FIND v(dout1_0) AT=290.05n

.meas tran vdout1_1ck280 FIND v(dout1_1) AT=290.05n

.meas tran vdout1_2ck280 FIND v(dout1_2) AT=290.05n

.meas tran vdout1_3ck280 FIND v(dout1_3) AT=290.05n

.meas tran vdout1_4ck280 FIND v(dout1_4) AT=290.05n

.meas tran vdout1_5ck280 FIND v(dout1_5) AT=290.05n

.meas tran vdout1_6ck280 FIND v(dout1_6) AT=290.05n

.meas tran vdout1_7ck280 FIND v(dout1_7) AT=290.05n

.meas tran vdout1_8ck280 FIND v(dout1_8) AT=290.05n

.meas tran vdout1_9ck280 FIND v(dout1_9) AT=290.05n

.meas tran vdout1_10ck280 FIND v(dout1_10) AT=290.05n

.meas tran vdout1_11ck280 FIND v(dout1_11) AT=290.05n

.meas tran vdout1_12ck280 FIND v(dout1_12) AT=290.05n

.meas tran vdout1_13ck280 FIND v(dout1_13) AT=290.05n

.meas tran vdout1_14ck280 FIND v(dout1_14) AT=290.05n

.meas tran vdout1_15ck280 FIND v(dout1_15) AT=290.05n

.meas tran vdout1_16ck280 FIND v(dout1_16) AT=290.05n

.meas tran vdout1_17ck280 FIND v(dout1_17) AT=290.05n

.meas tran vdout1_18ck280 FIND v(dout1_18) AT=290.05n

.meas tran vdout1_19ck280 FIND v(dout1_19) AT=290.05n

.meas tran vdout1_20ck280 FIND v(dout1_20) AT=290.05n

.meas tran vdout1_21ck280 FIND v(dout1_21) AT=290.05n

.meas tran vdout1_22ck280 FIND v(dout1_22) AT=290.05n

.meas tran vdout1_23ck280 FIND v(dout1_23) AT=290.05n

.meas tran vdout1_24ck280 FIND v(dout1_24) AT=290.05n

.meas tran vdout1_25ck280 FIND v(dout1_25) AT=290.05n

.meas tran vdout1_26ck280 FIND v(dout1_26) AT=290.05n

.meas tran vdout1_27ck280 FIND v(dout1_27) AT=290.05n

.meas tran vdout1_28ck280 FIND v(dout1_28) AT=290.05n

.meas tran vdout1_29ck280 FIND v(dout1_29) AT=290.05n

.meas tran vdout1_30ck280 FIND v(dout1_30) AT=290.05n

.meas tran vdout1_31ck280 FIND v(dout1_31) AT=290.05n

.meas tran vdout0_0ck290 FIND v(dout0_0) AT=300.05n

.meas tran vdout0_1ck290 FIND v(dout0_1) AT=300.05n

.meas tran vdout0_2ck290 FIND v(dout0_2) AT=300.05n

.meas tran vdout0_3ck290 FIND v(dout0_3) AT=300.05n

.meas tran vdout0_4ck290 FIND v(dout0_4) AT=300.05n

.meas tran vdout0_5ck290 FIND v(dout0_5) AT=300.05n

.meas tran vdout0_6ck290 FIND v(dout0_6) AT=300.05n

.meas tran vdout0_7ck290 FIND v(dout0_7) AT=300.05n

.meas tran vdout0_8ck290 FIND v(dout0_8) AT=300.05n

.meas tran vdout0_9ck290 FIND v(dout0_9) AT=300.05n

.meas tran vdout0_10ck290 FIND v(dout0_10) AT=300.05n

.meas tran vdout0_11ck290 FIND v(dout0_11) AT=300.05n

.meas tran vdout0_12ck290 FIND v(dout0_12) AT=300.05n

.meas tran vdout0_13ck290 FIND v(dout0_13) AT=300.05n

.meas tran vdout0_14ck290 FIND v(dout0_14) AT=300.05n

.meas tran vdout0_15ck290 FIND v(dout0_15) AT=300.05n

.meas tran vdout0_16ck290 FIND v(dout0_16) AT=300.05n

.meas tran vdout0_17ck290 FIND v(dout0_17) AT=300.05n

.meas tran vdout0_18ck290 FIND v(dout0_18) AT=300.05n

.meas tran vdout0_19ck290 FIND v(dout0_19) AT=300.05n

.meas tran vdout0_20ck290 FIND v(dout0_20) AT=300.05n

.meas tran vdout0_21ck290 FIND v(dout0_21) AT=300.05n

.meas tran vdout0_22ck290 FIND v(dout0_22) AT=300.05n

.meas tran vdout0_23ck290 FIND v(dout0_23) AT=300.05n

.meas tran vdout0_24ck290 FIND v(dout0_24) AT=300.05n

.meas tran vdout0_25ck290 FIND v(dout0_25) AT=300.05n

.meas tran vdout0_26ck290 FIND v(dout0_26) AT=300.05n

.meas tran vdout0_27ck290 FIND v(dout0_27) AT=300.05n

.meas tran vdout0_28ck290 FIND v(dout0_28) AT=300.05n

.meas tran vdout0_29ck290 FIND v(dout0_29) AT=300.05n

.meas tran vdout0_30ck290 FIND v(dout0_30) AT=300.05n

.meas tran vdout0_31ck290 FIND v(dout0_31) AT=300.05n

.meas tran vdout0_0ck300 FIND v(dout0_0) AT=310.05n

.meas tran vdout0_1ck300 FIND v(dout0_1) AT=310.05n

.meas tran vdout0_2ck300 FIND v(dout0_2) AT=310.05n

.meas tran vdout0_3ck300 FIND v(dout0_3) AT=310.05n

.meas tran vdout0_4ck300 FIND v(dout0_4) AT=310.05n

.meas tran vdout0_5ck300 FIND v(dout0_5) AT=310.05n

.meas tran vdout0_6ck300 FIND v(dout0_6) AT=310.05n

.meas tran vdout0_7ck300 FIND v(dout0_7) AT=310.05n

.meas tran vdout0_8ck300 FIND v(dout0_8) AT=310.05n

.meas tran vdout0_9ck300 FIND v(dout0_9) AT=310.05n

.meas tran vdout0_10ck300 FIND v(dout0_10) AT=310.05n

.meas tran vdout0_11ck300 FIND v(dout0_11) AT=310.05n

.meas tran vdout0_12ck300 FIND v(dout0_12) AT=310.05n

.meas tran vdout0_13ck300 FIND v(dout0_13) AT=310.05n

.meas tran vdout0_14ck300 FIND v(dout0_14) AT=310.05n

.meas tran vdout0_15ck300 FIND v(dout0_15) AT=310.05n

.meas tran vdout0_16ck300 FIND v(dout0_16) AT=310.05n

.meas tran vdout0_17ck300 FIND v(dout0_17) AT=310.05n

.meas tran vdout0_18ck300 FIND v(dout0_18) AT=310.05n

.meas tran vdout0_19ck300 FIND v(dout0_19) AT=310.05n

.meas tran vdout0_20ck300 FIND v(dout0_20) AT=310.05n

.meas tran vdout0_21ck300 FIND v(dout0_21) AT=310.05n

.meas tran vdout0_22ck300 FIND v(dout0_22) AT=310.05n

.meas tran vdout0_23ck300 FIND v(dout0_23) AT=310.05n

.meas tran vdout0_24ck300 FIND v(dout0_24) AT=310.05n

.meas tran vdout0_25ck300 FIND v(dout0_25) AT=310.05n

.meas tran vdout0_26ck300 FIND v(dout0_26) AT=310.05n

.meas tran vdout0_27ck300 FIND v(dout0_27) AT=310.05n

.meas tran vdout0_28ck300 FIND v(dout0_28) AT=310.05n

.meas tran vdout0_29ck300 FIND v(dout0_29) AT=310.05n

.meas tran vdout0_30ck300 FIND v(dout0_30) AT=310.05n

.meas tran vdout0_31ck300 FIND v(dout0_31) AT=310.05n

.meas tran vdout0_0ck320 FIND v(dout0_0) AT=330.05n

.meas tran vdout0_1ck320 FIND v(dout0_1) AT=330.05n

.meas tran vdout0_2ck320 FIND v(dout0_2) AT=330.05n

.meas tran vdout0_3ck320 FIND v(dout0_3) AT=330.05n

.meas tran vdout0_4ck320 FIND v(dout0_4) AT=330.05n

.meas tran vdout0_5ck320 FIND v(dout0_5) AT=330.05n

.meas tran vdout0_6ck320 FIND v(dout0_6) AT=330.05n

.meas tran vdout0_7ck320 FIND v(dout0_7) AT=330.05n

.meas tran vdout0_8ck320 FIND v(dout0_8) AT=330.05n

.meas tran vdout0_9ck320 FIND v(dout0_9) AT=330.05n

.meas tran vdout0_10ck320 FIND v(dout0_10) AT=330.05n

.meas tran vdout0_11ck320 FIND v(dout0_11) AT=330.05n

.meas tran vdout0_12ck320 FIND v(dout0_12) AT=330.05n

.meas tran vdout0_13ck320 FIND v(dout0_13) AT=330.05n

.meas tran vdout0_14ck320 FIND v(dout0_14) AT=330.05n

.meas tran vdout0_15ck320 FIND v(dout0_15) AT=330.05n

.meas tran vdout0_16ck320 FIND v(dout0_16) AT=330.05n

.meas tran vdout0_17ck320 FIND v(dout0_17) AT=330.05n

.meas tran vdout0_18ck320 FIND v(dout0_18) AT=330.05n

.meas tran vdout0_19ck320 FIND v(dout0_19) AT=330.05n

.meas tran vdout0_20ck320 FIND v(dout0_20) AT=330.05n

.meas tran vdout0_21ck320 FIND v(dout0_21) AT=330.05n

.meas tran vdout0_22ck320 FIND v(dout0_22) AT=330.05n

.meas tran vdout0_23ck320 FIND v(dout0_23) AT=330.05n

.meas tran vdout0_24ck320 FIND v(dout0_24) AT=330.05n

.meas tran vdout0_25ck320 FIND v(dout0_25) AT=330.05n

.meas tran vdout0_26ck320 FIND v(dout0_26) AT=330.05n

.meas tran vdout0_27ck320 FIND v(dout0_27) AT=330.05n

.meas tran vdout0_28ck320 FIND v(dout0_28) AT=330.05n

.meas tran vdout0_29ck320 FIND v(dout0_29) AT=330.05n

.meas tran vdout0_30ck320 FIND v(dout0_30) AT=330.05n

.meas tran vdout0_31ck320 FIND v(dout0_31) AT=330.05n

.meas tran vdout1_0ck330 FIND v(dout1_0) AT=340.05n

.meas tran vdout1_1ck330 FIND v(dout1_1) AT=340.05n

.meas tran vdout1_2ck330 FIND v(dout1_2) AT=340.05n

.meas tran vdout1_3ck330 FIND v(dout1_3) AT=340.05n

.meas tran vdout1_4ck330 FIND v(dout1_4) AT=340.05n

.meas tran vdout1_5ck330 FIND v(dout1_5) AT=340.05n

.meas tran vdout1_6ck330 FIND v(dout1_6) AT=340.05n

.meas tran vdout1_7ck330 FIND v(dout1_7) AT=340.05n

.meas tran vdout1_8ck330 FIND v(dout1_8) AT=340.05n

.meas tran vdout1_9ck330 FIND v(dout1_9) AT=340.05n

.meas tran vdout1_10ck330 FIND v(dout1_10) AT=340.05n

.meas tran vdout1_11ck330 FIND v(dout1_11) AT=340.05n

.meas tran vdout1_12ck330 FIND v(dout1_12) AT=340.05n

.meas tran vdout1_13ck330 FIND v(dout1_13) AT=340.05n

.meas tran vdout1_14ck330 FIND v(dout1_14) AT=340.05n

.meas tran vdout1_15ck330 FIND v(dout1_15) AT=340.05n

.meas tran vdout1_16ck330 FIND v(dout1_16) AT=340.05n

.meas tran vdout1_17ck330 FIND v(dout1_17) AT=340.05n

.meas tran vdout1_18ck330 FIND v(dout1_18) AT=340.05n

.meas tran vdout1_19ck330 FIND v(dout1_19) AT=340.05n

.meas tran vdout1_20ck330 FIND v(dout1_20) AT=340.05n

.meas tran vdout1_21ck330 FIND v(dout1_21) AT=340.05n

.meas tran vdout1_22ck330 FIND v(dout1_22) AT=340.05n

.meas tran vdout1_23ck330 FIND v(dout1_23) AT=340.05n

.meas tran vdout1_24ck330 FIND v(dout1_24) AT=340.05n

.meas tran vdout1_25ck330 FIND v(dout1_25) AT=340.05n

.meas tran vdout1_26ck330 FIND v(dout1_26) AT=340.05n

.meas tran vdout1_27ck330 FIND v(dout1_27) AT=340.05n

.meas tran vdout1_28ck330 FIND v(dout1_28) AT=340.05n

.meas tran vdout1_29ck330 FIND v(dout1_29) AT=340.05n

.meas tran vdout1_30ck330 FIND v(dout1_30) AT=340.05n

.meas tran vdout1_31ck330 FIND v(dout1_31) AT=340.05n

.meas tran vdout1_0ck340 FIND v(dout1_0) AT=350.05n

.meas tran vdout1_1ck340 FIND v(dout1_1) AT=350.05n

.meas tran vdout1_2ck340 FIND v(dout1_2) AT=350.05n

.meas tran vdout1_3ck340 FIND v(dout1_3) AT=350.05n

.meas tran vdout1_4ck340 FIND v(dout1_4) AT=350.05n

.meas tran vdout1_5ck340 FIND v(dout1_5) AT=350.05n

.meas tran vdout1_6ck340 FIND v(dout1_6) AT=350.05n

.meas tran vdout1_7ck340 FIND v(dout1_7) AT=350.05n

.meas tran vdout1_8ck340 FIND v(dout1_8) AT=350.05n

.meas tran vdout1_9ck340 FIND v(dout1_9) AT=350.05n

.meas tran vdout1_10ck340 FIND v(dout1_10) AT=350.05n

.meas tran vdout1_11ck340 FIND v(dout1_11) AT=350.05n

.meas tran vdout1_12ck340 FIND v(dout1_12) AT=350.05n

.meas tran vdout1_13ck340 FIND v(dout1_13) AT=350.05n

.meas tran vdout1_14ck340 FIND v(dout1_14) AT=350.05n

.meas tran vdout1_15ck340 FIND v(dout1_15) AT=350.05n

.meas tran vdout1_16ck340 FIND v(dout1_16) AT=350.05n

.meas tran vdout1_17ck340 FIND v(dout1_17) AT=350.05n

.meas tran vdout1_18ck340 FIND v(dout1_18) AT=350.05n

.meas tran vdout1_19ck340 FIND v(dout1_19) AT=350.05n

.meas tran vdout1_20ck340 FIND v(dout1_20) AT=350.05n

.meas tran vdout1_21ck340 FIND v(dout1_21) AT=350.05n

.meas tran vdout1_22ck340 FIND v(dout1_22) AT=350.05n

.meas tran vdout1_23ck340 FIND v(dout1_23) AT=350.05n

.meas tran vdout1_24ck340 FIND v(dout1_24) AT=350.05n

.meas tran vdout1_25ck340 FIND v(dout1_25) AT=350.05n

.meas tran vdout1_26ck340 FIND v(dout1_26) AT=350.05n

.meas tran vdout1_27ck340 FIND v(dout1_27) AT=350.05n

.meas tran vdout1_28ck340 FIND v(dout1_28) AT=350.05n

.meas tran vdout1_29ck340 FIND v(dout1_29) AT=350.05n

.meas tran vdout1_30ck340 FIND v(dout1_30) AT=350.05n

.meas tran vdout1_31ck340 FIND v(dout1_31) AT=350.05n

.meas tran vdout1_0ck350 FIND v(dout1_0) AT=360.05n

.meas tran vdout1_1ck350 FIND v(dout1_1) AT=360.05n

.meas tran vdout1_2ck350 FIND v(dout1_2) AT=360.05n

.meas tran vdout1_3ck350 FIND v(dout1_3) AT=360.05n

.meas tran vdout1_4ck350 FIND v(dout1_4) AT=360.05n

.meas tran vdout1_5ck350 FIND v(dout1_5) AT=360.05n

.meas tran vdout1_6ck350 FIND v(dout1_6) AT=360.05n

.meas tran vdout1_7ck350 FIND v(dout1_7) AT=360.05n

.meas tran vdout1_8ck350 FIND v(dout1_8) AT=360.05n

.meas tran vdout1_9ck350 FIND v(dout1_9) AT=360.05n

.meas tran vdout1_10ck350 FIND v(dout1_10) AT=360.05n

.meas tran vdout1_11ck350 FIND v(dout1_11) AT=360.05n

.meas tran vdout1_12ck350 FIND v(dout1_12) AT=360.05n

.meas tran vdout1_13ck350 FIND v(dout1_13) AT=360.05n

.meas tran vdout1_14ck350 FIND v(dout1_14) AT=360.05n

.meas tran vdout1_15ck350 FIND v(dout1_15) AT=360.05n

.meas tran vdout1_16ck350 FIND v(dout1_16) AT=360.05n

.meas tran vdout1_17ck350 FIND v(dout1_17) AT=360.05n

.meas tran vdout1_18ck350 FIND v(dout1_18) AT=360.05n

.meas tran vdout1_19ck350 FIND v(dout1_19) AT=360.05n

.meas tran vdout1_20ck350 FIND v(dout1_20) AT=360.05n

.meas tran vdout1_21ck350 FIND v(dout1_21) AT=360.05n

.meas tran vdout1_22ck350 FIND v(dout1_22) AT=360.05n

.meas tran vdout1_23ck350 FIND v(dout1_23) AT=360.05n

.meas tran vdout1_24ck350 FIND v(dout1_24) AT=360.05n

.meas tran vdout1_25ck350 FIND v(dout1_25) AT=360.05n

.meas tran vdout1_26ck350 FIND v(dout1_26) AT=360.05n

.meas tran vdout1_27ck350 FIND v(dout1_27) AT=360.05n

.meas tran vdout1_28ck350 FIND v(dout1_28) AT=360.05n

.meas tran vdout1_29ck350 FIND v(dout1_29) AT=360.05n

.meas tran vdout1_30ck350 FIND v(dout1_30) AT=360.05n

.meas tran vdout1_31ck350 FIND v(dout1_31) AT=360.05n

.meas tran vdout1_0ck380 FIND v(dout1_0) AT=390.05n

.meas tran vdout1_1ck380 FIND v(dout1_1) AT=390.05n

.meas tran vdout1_2ck380 FIND v(dout1_2) AT=390.05n

.meas tran vdout1_3ck380 FIND v(dout1_3) AT=390.05n

.meas tran vdout1_4ck380 FIND v(dout1_4) AT=390.05n

.meas tran vdout1_5ck380 FIND v(dout1_5) AT=390.05n

.meas tran vdout1_6ck380 FIND v(dout1_6) AT=390.05n

.meas tran vdout1_7ck380 FIND v(dout1_7) AT=390.05n

.meas tran vdout1_8ck380 FIND v(dout1_8) AT=390.05n

.meas tran vdout1_9ck380 FIND v(dout1_9) AT=390.05n

.meas tran vdout1_10ck380 FIND v(dout1_10) AT=390.05n

.meas tran vdout1_11ck380 FIND v(dout1_11) AT=390.05n

.meas tran vdout1_12ck380 FIND v(dout1_12) AT=390.05n

.meas tran vdout1_13ck380 FIND v(dout1_13) AT=390.05n

.meas tran vdout1_14ck380 FIND v(dout1_14) AT=390.05n

.meas tran vdout1_15ck380 FIND v(dout1_15) AT=390.05n

.meas tran vdout1_16ck380 FIND v(dout1_16) AT=390.05n

.meas tran vdout1_17ck380 FIND v(dout1_17) AT=390.05n

.meas tran vdout1_18ck380 FIND v(dout1_18) AT=390.05n

.meas tran vdout1_19ck380 FIND v(dout1_19) AT=390.05n

.meas tran vdout1_20ck380 FIND v(dout1_20) AT=390.05n

.meas tran vdout1_21ck380 FIND v(dout1_21) AT=390.05n

.meas tran vdout1_22ck380 FIND v(dout1_22) AT=390.05n

.meas tran vdout1_23ck380 FIND v(dout1_23) AT=390.05n

.meas tran vdout1_24ck380 FIND v(dout1_24) AT=390.05n

.meas tran vdout1_25ck380 FIND v(dout1_25) AT=390.05n

.meas tran vdout1_26ck380 FIND v(dout1_26) AT=390.05n

.meas tran vdout1_27ck380 FIND v(dout1_27) AT=390.05n

.meas tran vdout1_28ck380 FIND v(dout1_28) AT=390.05n

.meas tran vdout1_29ck380 FIND v(dout1_29) AT=390.05n

.meas tran vdout1_30ck380 FIND v(dout1_30) AT=390.05n

.meas tran vdout1_31ck380 FIND v(dout1_31) AT=390.05n

.meas tran vdout1_0ck390 FIND v(dout1_0) AT=400.05n

.meas tran vdout1_1ck390 FIND v(dout1_1) AT=400.05n

.meas tran vdout1_2ck390 FIND v(dout1_2) AT=400.05n

.meas tran vdout1_3ck390 FIND v(dout1_3) AT=400.05n

.meas tran vdout1_4ck390 FIND v(dout1_4) AT=400.05n

.meas tran vdout1_5ck390 FIND v(dout1_5) AT=400.05n

.meas tran vdout1_6ck390 FIND v(dout1_6) AT=400.05n

.meas tran vdout1_7ck390 FIND v(dout1_7) AT=400.05n

.meas tran vdout1_8ck390 FIND v(dout1_8) AT=400.05n

.meas tran vdout1_9ck390 FIND v(dout1_9) AT=400.05n

.meas tran vdout1_10ck390 FIND v(dout1_10) AT=400.05n

.meas tran vdout1_11ck390 FIND v(dout1_11) AT=400.05n

.meas tran vdout1_12ck390 FIND v(dout1_12) AT=400.05n

.meas tran vdout1_13ck390 FIND v(dout1_13) AT=400.05n

.meas tran vdout1_14ck390 FIND v(dout1_14) AT=400.05n

.meas tran vdout1_15ck390 FIND v(dout1_15) AT=400.05n

.meas tran vdout1_16ck390 FIND v(dout1_16) AT=400.05n

.meas tran vdout1_17ck390 FIND v(dout1_17) AT=400.05n

.meas tran vdout1_18ck390 FIND v(dout1_18) AT=400.05n

.meas tran vdout1_19ck390 FIND v(dout1_19) AT=400.05n

.meas tran vdout1_20ck390 FIND v(dout1_20) AT=400.05n

.meas tran vdout1_21ck390 FIND v(dout1_21) AT=400.05n

.meas tran vdout1_22ck390 FIND v(dout1_22) AT=400.05n

.meas tran vdout1_23ck390 FIND v(dout1_23) AT=400.05n

.meas tran vdout1_24ck390 FIND v(dout1_24) AT=400.05n

.meas tran vdout1_25ck390 FIND v(dout1_25) AT=400.05n

.meas tran vdout1_26ck390 FIND v(dout1_26) AT=400.05n

.meas tran vdout1_27ck390 FIND v(dout1_27) AT=400.05n

.meas tran vdout1_28ck390 FIND v(dout1_28) AT=400.05n

.meas tran vdout1_29ck390 FIND v(dout1_29) AT=400.05n

.meas tran vdout1_30ck390 FIND v(dout1_30) AT=400.05n

.meas tran vdout1_31ck390 FIND v(dout1_31) AT=400.05n

.meas tran vdout0_0ck400 FIND v(dout0_0) AT=410.05n

.meas tran vdout0_1ck400 FIND v(dout0_1) AT=410.05n

.meas tran vdout0_2ck400 FIND v(dout0_2) AT=410.05n

.meas tran vdout0_3ck400 FIND v(dout0_3) AT=410.05n

.meas tran vdout0_4ck400 FIND v(dout0_4) AT=410.05n

.meas tran vdout0_5ck400 FIND v(dout0_5) AT=410.05n

.meas tran vdout0_6ck400 FIND v(dout0_6) AT=410.05n

.meas tran vdout0_7ck400 FIND v(dout0_7) AT=410.05n

.meas tran vdout0_8ck400 FIND v(dout0_8) AT=410.05n

.meas tran vdout0_9ck400 FIND v(dout0_9) AT=410.05n

.meas tran vdout0_10ck400 FIND v(dout0_10) AT=410.05n

.meas tran vdout0_11ck400 FIND v(dout0_11) AT=410.05n

.meas tran vdout0_12ck400 FIND v(dout0_12) AT=410.05n

.meas tran vdout0_13ck400 FIND v(dout0_13) AT=410.05n

.meas tran vdout0_14ck400 FIND v(dout0_14) AT=410.05n

.meas tran vdout0_15ck400 FIND v(dout0_15) AT=410.05n

.meas tran vdout0_16ck400 FIND v(dout0_16) AT=410.05n

.meas tran vdout0_17ck400 FIND v(dout0_17) AT=410.05n

.meas tran vdout0_18ck400 FIND v(dout0_18) AT=410.05n

.meas tran vdout0_19ck400 FIND v(dout0_19) AT=410.05n

.meas tran vdout0_20ck400 FIND v(dout0_20) AT=410.05n

.meas tran vdout0_21ck400 FIND v(dout0_21) AT=410.05n

.meas tran vdout0_22ck400 FIND v(dout0_22) AT=410.05n

.meas tran vdout0_23ck400 FIND v(dout0_23) AT=410.05n

.meas tran vdout0_24ck400 FIND v(dout0_24) AT=410.05n

.meas tran vdout0_25ck400 FIND v(dout0_25) AT=410.05n

.meas tran vdout0_26ck400 FIND v(dout0_26) AT=410.05n

.meas tran vdout0_27ck400 FIND v(dout0_27) AT=410.05n

.meas tran vdout0_28ck400 FIND v(dout0_28) AT=410.05n

.meas tran vdout0_29ck400 FIND v(dout0_29) AT=410.05n

.meas tran vdout0_30ck400 FIND v(dout0_30) AT=410.05n

.meas tran vdout0_31ck400 FIND v(dout0_31) AT=410.05n

.meas tran vdout0_0ck420 FIND v(dout0_0) AT=430.05n

.meas tran vdout0_1ck420 FIND v(dout0_1) AT=430.05n

.meas tran vdout0_2ck420 FIND v(dout0_2) AT=430.05n

.meas tran vdout0_3ck420 FIND v(dout0_3) AT=430.05n

.meas tran vdout0_4ck420 FIND v(dout0_4) AT=430.05n

.meas tran vdout0_5ck420 FIND v(dout0_5) AT=430.05n

.meas tran vdout0_6ck420 FIND v(dout0_6) AT=430.05n

.meas tran vdout0_7ck420 FIND v(dout0_7) AT=430.05n

.meas tran vdout0_8ck420 FIND v(dout0_8) AT=430.05n

.meas tran vdout0_9ck420 FIND v(dout0_9) AT=430.05n

.meas tran vdout0_10ck420 FIND v(dout0_10) AT=430.05n

.meas tran vdout0_11ck420 FIND v(dout0_11) AT=430.05n

.meas tran vdout0_12ck420 FIND v(dout0_12) AT=430.05n

.meas tran vdout0_13ck420 FIND v(dout0_13) AT=430.05n

.meas tran vdout0_14ck420 FIND v(dout0_14) AT=430.05n

.meas tran vdout0_15ck420 FIND v(dout0_15) AT=430.05n

.meas tran vdout0_16ck420 FIND v(dout0_16) AT=430.05n

.meas tran vdout0_17ck420 FIND v(dout0_17) AT=430.05n

.meas tran vdout0_18ck420 FIND v(dout0_18) AT=430.05n

.meas tran vdout0_19ck420 FIND v(dout0_19) AT=430.05n

.meas tran vdout0_20ck420 FIND v(dout0_20) AT=430.05n

.meas tran vdout0_21ck420 FIND v(dout0_21) AT=430.05n

.meas tran vdout0_22ck420 FIND v(dout0_22) AT=430.05n

.meas tran vdout0_23ck420 FIND v(dout0_23) AT=430.05n

.meas tran vdout0_24ck420 FIND v(dout0_24) AT=430.05n

.meas tran vdout0_25ck420 FIND v(dout0_25) AT=430.05n

.meas tran vdout0_26ck420 FIND v(dout0_26) AT=430.05n

.meas tran vdout0_27ck420 FIND v(dout0_27) AT=430.05n

.meas tran vdout0_28ck420 FIND v(dout0_28) AT=430.05n

.meas tran vdout0_29ck420 FIND v(dout0_29) AT=430.05n

.meas tran vdout0_30ck420 FIND v(dout0_30) AT=430.05n

.meas tran vdout0_31ck420 FIND v(dout0_31) AT=430.05n

.meas tran vdout1_0ck420 FIND v(dout1_0) AT=430.05n

.meas tran vdout1_1ck420 FIND v(dout1_1) AT=430.05n

.meas tran vdout1_2ck420 FIND v(dout1_2) AT=430.05n

.meas tran vdout1_3ck420 FIND v(dout1_3) AT=430.05n

.meas tran vdout1_4ck420 FIND v(dout1_4) AT=430.05n

.meas tran vdout1_5ck420 FIND v(dout1_5) AT=430.05n

.meas tran vdout1_6ck420 FIND v(dout1_6) AT=430.05n

.meas tran vdout1_7ck420 FIND v(dout1_7) AT=430.05n

.meas tran vdout1_8ck420 FIND v(dout1_8) AT=430.05n

.meas tran vdout1_9ck420 FIND v(dout1_9) AT=430.05n

.meas tran vdout1_10ck420 FIND v(dout1_10) AT=430.05n

.meas tran vdout1_11ck420 FIND v(dout1_11) AT=430.05n

.meas tran vdout1_12ck420 FIND v(dout1_12) AT=430.05n

.meas tran vdout1_13ck420 FIND v(dout1_13) AT=430.05n

.meas tran vdout1_14ck420 FIND v(dout1_14) AT=430.05n

.meas tran vdout1_15ck420 FIND v(dout1_15) AT=430.05n

.meas tran vdout1_16ck420 FIND v(dout1_16) AT=430.05n

.meas tran vdout1_17ck420 FIND v(dout1_17) AT=430.05n

.meas tran vdout1_18ck420 FIND v(dout1_18) AT=430.05n

.meas tran vdout1_19ck420 FIND v(dout1_19) AT=430.05n

.meas tran vdout1_20ck420 FIND v(dout1_20) AT=430.05n

.meas tran vdout1_21ck420 FIND v(dout1_21) AT=430.05n

.meas tran vdout1_22ck420 FIND v(dout1_22) AT=430.05n

.meas tran vdout1_23ck420 FIND v(dout1_23) AT=430.05n

.meas tran vdout1_24ck420 FIND v(dout1_24) AT=430.05n

.meas tran vdout1_25ck420 FIND v(dout1_25) AT=430.05n

.meas tran vdout1_26ck420 FIND v(dout1_26) AT=430.05n

.meas tran vdout1_27ck420 FIND v(dout1_27) AT=430.05n

.meas tran vdout1_28ck420 FIND v(dout1_28) AT=430.05n

.meas tran vdout1_29ck420 FIND v(dout1_29) AT=430.05n

.meas tran vdout1_30ck420 FIND v(dout1_30) AT=430.05n

.meas tran vdout1_31ck420 FIND v(dout1_31) AT=430.05n

.meas tran vdout0_0ck430 FIND v(dout0_0) AT=440.05n

.meas tran vdout0_1ck430 FIND v(dout0_1) AT=440.05n

.meas tran vdout0_2ck430 FIND v(dout0_2) AT=440.05n

.meas tran vdout0_3ck430 FIND v(dout0_3) AT=440.05n

.meas tran vdout0_4ck430 FIND v(dout0_4) AT=440.05n

.meas tran vdout0_5ck430 FIND v(dout0_5) AT=440.05n

.meas tran vdout0_6ck430 FIND v(dout0_6) AT=440.05n

.meas tran vdout0_7ck430 FIND v(dout0_7) AT=440.05n

.meas tran vdout0_8ck430 FIND v(dout0_8) AT=440.05n

.meas tran vdout0_9ck430 FIND v(dout0_9) AT=440.05n

.meas tran vdout0_10ck430 FIND v(dout0_10) AT=440.05n

.meas tran vdout0_11ck430 FIND v(dout0_11) AT=440.05n

.meas tran vdout0_12ck430 FIND v(dout0_12) AT=440.05n

.meas tran vdout0_13ck430 FIND v(dout0_13) AT=440.05n

.meas tran vdout0_14ck430 FIND v(dout0_14) AT=440.05n

.meas tran vdout0_15ck430 FIND v(dout0_15) AT=440.05n

.meas tran vdout0_16ck430 FIND v(dout0_16) AT=440.05n

.meas tran vdout0_17ck430 FIND v(dout0_17) AT=440.05n

.meas tran vdout0_18ck430 FIND v(dout0_18) AT=440.05n

.meas tran vdout0_19ck430 FIND v(dout0_19) AT=440.05n

.meas tran vdout0_20ck430 FIND v(dout0_20) AT=440.05n

.meas tran vdout0_21ck430 FIND v(dout0_21) AT=440.05n

.meas tran vdout0_22ck430 FIND v(dout0_22) AT=440.05n

.meas tran vdout0_23ck430 FIND v(dout0_23) AT=440.05n

.meas tran vdout0_24ck430 FIND v(dout0_24) AT=440.05n

.meas tran vdout0_25ck430 FIND v(dout0_25) AT=440.05n

.meas tran vdout0_26ck430 FIND v(dout0_26) AT=440.05n

.meas tran vdout0_27ck430 FIND v(dout0_27) AT=440.05n

.meas tran vdout0_28ck430 FIND v(dout0_28) AT=440.05n

.meas tran vdout0_29ck430 FIND v(dout0_29) AT=440.05n

.meas tran vdout0_30ck430 FIND v(dout0_30) AT=440.05n

.meas tran vdout0_31ck430 FIND v(dout0_31) AT=440.05n

.meas tran vdout0_0ck440 FIND v(dout0_0) AT=450.05n

.meas tran vdout0_1ck440 FIND v(dout0_1) AT=450.05n

.meas tran vdout0_2ck440 FIND v(dout0_2) AT=450.05n

.meas tran vdout0_3ck440 FIND v(dout0_3) AT=450.05n

.meas tran vdout0_4ck440 FIND v(dout0_4) AT=450.05n

.meas tran vdout0_5ck440 FIND v(dout0_5) AT=450.05n

.meas tran vdout0_6ck440 FIND v(dout0_6) AT=450.05n

.meas tran vdout0_7ck440 FIND v(dout0_7) AT=450.05n

.meas tran vdout0_8ck440 FIND v(dout0_8) AT=450.05n

.meas tran vdout0_9ck440 FIND v(dout0_9) AT=450.05n

.meas tran vdout0_10ck440 FIND v(dout0_10) AT=450.05n

.meas tran vdout0_11ck440 FIND v(dout0_11) AT=450.05n

.meas tran vdout0_12ck440 FIND v(dout0_12) AT=450.05n

.meas tran vdout0_13ck440 FIND v(dout0_13) AT=450.05n

.meas tran vdout0_14ck440 FIND v(dout0_14) AT=450.05n

.meas tran vdout0_15ck440 FIND v(dout0_15) AT=450.05n

.meas tran vdout0_16ck440 FIND v(dout0_16) AT=450.05n

.meas tran vdout0_17ck440 FIND v(dout0_17) AT=450.05n

.meas tran vdout0_18ck440 FIND v(dout0_18) AT=450.05n

.meas tran vdout0_19ck440 FIND v(dout0_19) AT=450.05n

.meas tran vdout0_20ck440 FIND v(dout0_20) AT=450.05n

.meas tran vdout0_21ck440 FIND v(dout0_21) AT=450.05n

.meas tran vdout0_22ck440 FIND v(dout0_22) AT=450.05n

.meas tran vdout0_23ck440 FIND v(dout0_23) AT=450.05n

.meas tran vdout0_24ck440 FIND v(dout0_24) AT=450.05n

.meas tran vdout0_25ck440 FIND v(dout0_25) AT=450.05n

.meas tran vdout0_26ck440 FIND v(dout0_26) AT=450.05n

.meas tran vdout0_27ck440 FIND v(dout0_27) AT=450.05n

.meas tran vdout0_28ck440 FIND v(dout0_28) AT=450.05n

.meas tran vdout0_29ck440 FIND v(dout0_29) AT=450.05n

.meas tran vdout0_30ck440 FIND v(dout0_30) AT=450.05n

.meas tran vdout0_31ck440 FIND v(dout0_31) AT=450.05n

.meas tran vdout1_0ck440 FIND v(dout1_0) AT=450.05n

.meas tran vdout1_1ck440 FIND v(dout1_1) AT=450.05n

.meas tran vdout1_2ck440 FIND v(dout1_2) AT=450.05n

.meas tran vdout1_3ck440 FIND v(dout1_3) AT=450.05n

.meas tran vdout1_4ck440 FIND v(dout1_4) AT=450.05n

.meas tran vdout1_5ck440 FIND v(dout1_5) AT=450.05n

.meas tran vdout1_6ck440 FIND v(dout1_6) AT=450.05n

.meas tran vdout1_7ck440 FIND v(dout1_7) AT=450.05n

.meas tran vdout1_8ck440 FIND v(dout1_8) AT=450.05n

.meas tran vdout1_9ck440 FIND v(dout1_9) AT=450.05n

.meas tran vdout1_10ck440 FIND v(dout1_10) AT=450.05n

.meas tran vdout1_11ck440 FIND v(dout1_11) AT=450.05n

.meas tran vdout1_12ck440 FIND v(dout1_12) AT=450.05n

.meas tran vdout1_13ck440 FIND v(dout1_13) AT=450.05n

.meas tran vdout1_14ck440 FIND v(dout1_14) AT=450.05n

.meas tran vdout1_15ck440 FIND v(dout1_15) AT=450.05n

.meas tran vdout1_16ck440 FIND v(dout1_16) AT=450.05n

.meas tran vdout1_17ck440 FIND v(dout1_17) AT=450.05n

.meas tran vdout1_18ck440 FIND v(dout1_18) AT=450.05n

.meas tran vdout1_19ck440 FIND v(dout1_19) AT=450.05n

.meas tran vdout1_20ck440 FIND v(dout1_20) AT=450.05n

.meas tran vdout1_21ck440 FIND v(dout1_21) AT=450.05n

.meas tran vdout1_22ck440 FIND v(dout1_22) AT=450.05n

.meas tran vdout1_23ck440 FIND v(dout1_23) AT=450.05n

.meas tran vdout1_24ck440 FIND v(dout1_24) AT=450.05n

.meas tran vdout1_25ck440 FIND v(dout1_25) AT=450.05n

.meas tran vdout1_26ck440 FIND v(dout1_26) AT=450.05n

.meas tran vdout1_27ck440 FIND v(dout1_27) AT=450.05n

.meas tran vdout1_28ck440 FIND v(dout1_28) AT=450.05n

.meas tran vdout1_29ck440 FIND v(dout1_29) AT=450.05n

.meas tran vdout1_30ck440 FIND v(dout1_30) AT=450.05n

.meas tran vdout1_31ck440 FIND v(dout1_31) AT=450.05n

.meas tran vdout1_0ck460 FIND v(dout1_0) AT=470.05n

.meas tran vdout1_1ck460 FIND v(dout1_1) AT=470.05n

.meas tran vdout1_2ck460 FIND v(dout1_2) AT=470.05n

.meas tran vdout1_3ck460 FIND v(dout1_3) AT=470.05n

.meas tran vdout1_4ck460 FIND v(dout1_4) AT=470.05n

.meas tran vdout1_5ck460 FIND v(dout1_5) AT=470.05n

.meas tran vdout1_6ck460 FIND v(dout1_6) AT=470.05n

.meas tran vdout1_7ck460 FIND v(dout1_7) AT=470.05n

.meas tran vdout1_8ck460 FIND v(dout1_8) AT=470.05n

.meas tran vdout1_9ck460 FIND v(dout1_9) AT=470.05n

.meas tran vdout1_10ck460 FIND v(dout1_10) AT=470.05n

.meas tran vdout1_11ck460 FIND v(dout1_11) AT=470.05n

.meas tran vdout1_12ck460 FIND v(dout1_12) AT=470.05n

.meas tran vdout1_13ck460 FIND v(dout1_13) AT=470.05n

.meas tran vdout1_14ck460 FIND v(dout1_14) AT=470.05n

.meas tran vdout1_15ck460 FIND v(dout1_15) AT=470.05n

.meas tran vdout1_16ck460 FIND v(dout1_16) AT=470.05n

.meas tran vdout1_17ck460 FIND v(dout1_17) AT=470.05n

.meas tran vdout1_18ck460 FIND v(dout1_18) AT=470.05n

.meas tran vdout1_19ck460 FIND v(dout1_19) AT=470.05n

.meas tran vdout1_20ck460 FIND v(dout1_20) AT=470.05n

.meas tran vdout1_21ck460 FIND v(dout1_21) AT=470.05n

.meas tran vdout1_22ck460 FIND v(dout1_22) AT=470.05n

.meas tran vdout1_23ck460 FIND v(dout1_23) AT=470.05n

.meas tran vdout1_24ck460 FIND v(dout1_24) AT=470.05n

.meas tran vdout1_25ck460 FIND v(dout1_25) AT=470.05n

.meas tran vdout1_26ck460 FIND v(dout1_26) AT=470.05n

.meas tran vdout1_27ck460 FIND v(dout1_27) AT=470.05n

.meas tran vdout1_28ck460 FIND v(dout1_28) AT=470.05n

.meas tran vdout1_29ck460 FIND v(dout1_29) AT=470.05n

.meas tran vdout1_30ck460 FIND v(dout1_30) AT=470.05n

.meas tran vdout1_31ck460 FIND v(dout1_31) AT=470.05n

.meas tran vdout1_0ck470 FIND v(dout1_0) AT=480.05n

.meas tran vdout1_1ck470 FIND v(dout1_1) AT=480.05n

.meas tran vdout1_2ck470 FIND v(dout1_2) AT=480.05n

.meas tran vdout1_3ck470 FIND v(dout1_3) AT=480.05n

.meas tran vdout1_4ck470 FIND v(dout1_4) AT=480.05n

.meas tran vdout1_5ck470 FIND v(dout1_5) AT=480.05n

.meas tran vdout1_6ck470 FIND v(dout1_6) AT=480.05n

.meas tran vdout1_7ck470 FIND v(dout1_7) AT=480.05n

.meas tran vdout1_8ck470 FIND v(dout1_8) AT=480.05n

.meas tran vdout1_9ck470 FIND v(dout1_9) AT=480.05n

.meas tran vdout1_10ck470 FIND v(dout1_10) AT=480.05n

.meas tran vdout1_11ck470 FIND v(dout1_11) AT=480.05n

.meas tran vdout1_12ck470 FIND v(dout1_12) AT=480.05n

.meas tran vdout1_13ck470 FIND v(dout1_13) AT=480.05n

.meas tran vdout1_14ck470 FIND v(dout1_14) AT=480.05n

.meas tran vdout1_15ck470 FIND v(dout1_15) AT=480.05n

.meas tran vdout1_16ck470 FIND v(dout1_16) AT=480.05n

.meas tran vdout1_17ck470 FIND v(dout1_17) AT=480.05n

.meas tran vdout1_18ck470 FIND v(dout1_18) AT=480.05n

.meas tran vdout1_19ck470 FIND v(dout1_19) AT=480.05n

.meas tran vdout1_20ck470 FIND v(dout1_20) AT=480.05n

.meas tran vdout1_21ck470 FIND v(dout1_21) AT=480.05n

.meas tran vdout1_22ck470 FIND v(dout1_22) AT=480.05n

.meas tran vdout1_23ck470 FIND v(dout1_23) AT=480.05n

.meas tran vdout1_24ck470 FIND v(dout1_24) AT=480.05n

.meas tran vdout1_25ck470 FIND v(dout1_25) AT=480.05n

.meas tran vdout1_26ck470 FIND v(dout1_26) AT=480.05n

.meas tran vdout1_27ck470 FIND v(dout1_27) AT=480.05n

.meas tran vdout1_28ck470 FIND v(dout1_28) AT=480.05n

.meas tran vdout1_29ck470 FIND v(dout1_29) AT=480.05n

.meas tran vdout1_30ck470 FIND v(dout1_30) AT=480.05n

.meas tran vdout1_31ck470 FIND v(dout1_31) AT=480.05n

.meas tran vdout1_0ck480 FIND v(dout1_0) AT=490.05n

.meas tran vdout1_1ck480 FIND v(dout1_1) AT=490.05n

.meas tran vdout1_2ck480 FIND v(dout1_2) AT=490.05n

.meas tran vdout1_3ck480 FIND v(dout1_3) AT=490.05n

.meas tran vdout1_4ck480 FIND v(dout1_4) AT=490.05n

.meas tran vdout1_5ck480 FIND v(dout1_5) AT=490.05n

.meas tran vdout1_6ck480 FIND v(dout1_6) AT=490.05n

.meas tran vdout1_7ck480 FIND v(dout1_7) AT=490.05n

.meas tran vdout1_8ck480 FIND v(dout1_8) AT=490.05n

.meas tran vdout1_9ck480 FIND v(dout1_9) AT=490.05n

.meas tran vdout1_10ck480 FIND v(dout1_10) AT=490.05n

.meas tran vdout1_11ck480 FIND v(dout1_11) AT=490.05n

.meas tran vdout1_12ck480 FIND v(dout1_12) AT=490.05n

.meas tran vdout1_13ck480 FIND v(dout1_13) AT=490.05n

.meas tran vdout1_14ck480 FIND v(dout1_14) AT=490.05n

.meas tran vdout1_15ck480 FIND v(dout1_15) AT=490.05n

.meas tran vdout1_16ck480 FIND v(dout1_16) AT=490.05n

.meas tran vdout1_17ck480 FIND v(dout1_17) AT=490.05n

.meas tran vdout1_18ck480 FIND v(dout1_18) AT=490.05n

.meas tran vdout1_19ck480 FIND v(dout1_19) AT=490.05n

.meas tran vdout1_20ck480 FIND v(dout1_20) AT=490.05n

.meas tran vdout1_21ck480 FIND v(dout1_21) AT=490.05n

.meas tran vdout1_22ck480 FIND v(dout1_22) AT=490.05n

.meas tran vdout1_23ck480 FIND v(dout1_23) AT=490.05n

.meas tran vdout1_24ck480 FIND v(dout1_24) AT=490.05n

.meas tran vdout1_25ck480 FIND v(dout1_25) AT=490.05n

.meas tran vdout1_26ck480 FIND v(dout1_26) AT=490.05n

.meas tran vdout1_27ck480 FIND v(dout1_27) AT=490.05n

.meas tran vdout1_28ck480 FIND v(dout1_28) AT=490.05n

.meas tran vdout1_29ck480 FIND v(dout1_29) AT=490.05n

.meas tran vdout1_30ck480 FIND v(dout1_30) AT=490.05n

.meas tran vdout1_31ck480 FIND v(dout1_31) AT=490.05n

.meas tran vdout0_0ck510 FIND v(dout0_0) AT=520.05n

.meas tran vdout0_1ck510 FIND v(dout0_1) AT=520.05n

.meas tran vdout0_2ck510 FIND v(dout0_2) AT=520.05n

.meas tran vdout0_3ck510 FIND v(dout0_3) AT=520.05n

.meas tran vdout0_4ck510 FIND v(dout0_4) AT=520.05n

.meas tran vdout0_5ck510 FIND v(dout0_5) AT=520.05n

.meas tran vdout0_6ck510 FIND v(dout0_6) AT=520.05n

.meas tran vdout0_7ck510 FIND v(dout0_7) AT=520.05n

.meas tran vdout0_8ck510 FIND v(dout0_8) AT=520.05n

.meas tran vdout0_9ck510 FIND v(dout0_9) AT=520.05n

.meas tran vdout0_10ck510 FIND v(dout0_10) AT=520.05n

.meas tran vdout0_11ck510 FIND v(dout0_11) AT=520.05n

.meas tran vdout0_12ck510 FIND v(dout0_12) AT=520.05n

.meas tran vdout0_13ck510 FIND v(dout0_13) AT=520.05n

.meas tran vdout0_14ck510 FIND v(dout0_14) AT=520.05n

.meas tran vdout0_15ck510 FIND v(dout0_15) AT=520.05n

.meas tran vdout0_16ck510 FIND v(dout0_16) AT=520.05n

.meas tran vdout0_17ck510 FIND v(dout0_17) AT=520.05n

.meas tran vdout0_18ck510 FIND v(dout0_18) AT=520.05n

.meas tran vdout0_19ck510 FIND v(dout0_19) AT=520.05n

.meas tran vdout0_20ck510 FIND v(dout0_20) AT=520.05n

.meas tran vdout0_21ck510 FIND v(dout0_21) AT=520.05n

.meas tran vdout0_22ck510 FIND v(dout0_22) AT=520.05n

.meas tran vdout0_23ck510 FIND v(dout0_23) AT=520.05n

.meas tran vdout0_24ck510 FIND v(dout0_24) AT=520.05n

.meas tran vdout0_25ck510 FIND v(dout0_25) AT=520.05n

.meas tran vdout0_26ck510 FIND v(dout0_26) AT=520.05n

.meas tran vdout0_27ck510 FIND v(dout0_27) AT=520.05n

.meas tran vdout0_28ck510 FIND v(dout0_28) AT=520.05n

.meas tran vdout0_29ck510 FIND v(dout0_29) AT=520.05n

.meas tran vdout0_30ck510 FIND v(dout0_30) AT=520.05n

.meas tran vdout0_31ck510 FIND v(dout0_31) AT=520.05n

.meas tran vdout1_0ck510 FIND v(dout1_0) AT=520.05n

.meas tran vdout1_1ck510 FIND v(dout1_1) AT=520.05n

.meas tran vdout1_2ck510 FIND v(dout1_2) AT=520.05n

.meas tran vdout1_3ck510 FIND v(dout1_3) AT=520.05n

.meas tran vdout1_4ck510 FIND v(dout1_4) AT=520.05n

.meas tran vdout1_5ck510 FIND v(dout1_5) AT=520.05n

.meas tran vdout1_6ck510 FIND v(dout1_6) AT=520.05n

.meas tran vdout1_7ck510 FIND v(dout1_7) AT=520.05n

.meas tran vdout1_8ck510 FIND v(dout1_8) AT=520.05n

.meas tran vdout1_9ck510 FIND v(dout1_9) AT=520.05n

.meas tran vdout1_10ck510 FIND v(dout1_10) AT=520.05n

.meas tran vdout1_11ck510 FIND v(dout1_11) AT=520.05n

.meas tran vdout1_12ck510 FIND v(dout1_12) AT=520.05n

.meas tran vdout1_13ck510 FIND v(dout1_13) AT=520.05n

.meas tran vdout1_14ck510 FIND v(dout1_14) AT=520.05n

.meas tran vdout1_15ck510 FIND v(dout1_15) AT=520.05n

.meas tran vdout1_16ck510 FIND v(dout1_16) AT=520.05n

.meas tran vdout1_17ck510 FIND v(dout1_17) AT=520.05n

.meas tran vdout1_18ck510 FIND v(dout1_18) AT=520.05n

.meas tran vdout1_19ck510 FIND v(dout1_19) AT=520.05n

.meas tran vdout1_20ck510 FIND v(dout1_20) AT=520.05n

.meas tran vdout1_21ck510 FIND v(dout1_21) AT=520.05n

.meas tran vdout1_22ck510 FIND v(dout1_22) AT=520.05n

.meas tran vdout1_23ck510 FIND v(dout1_23) AT=520.05n

.meas tran vdout1_24ck510 FIND v(dout1_24) AT=520.05n

.meas tran vdout1_25ck510 FIND v(dout1_25) AT=520.05n

.meas tran vdout1_26ck510 FIND v(dout1_26) AT=520.05n

.meas tran vdout1_27ck510 FIND v(dout1_27) AT=520.05n

.meas tran vdout1_28ck510 FIND v(dout1_28) AT=520.05n

.meas tran vdout1_29ck510 FIND v(dout1_29) AT=520.05n

.meas tran vdout1_30ck510 FIND v(dout1_30) AT=520.05n

.meas tran vdout1_31ck510 FIND v(dout1_31) AT=520.05n

.meas tran vdout0_0ck520 FIND v(dout0_0) AT=530.05n

.meas tran vdout0_1ck520 FIND v(dout0_1) AT=530.05n

.meas tran vdout0_2ck520 FIND v(dout0_2) AT=530.05n

.meas tran vdout0_3ck520 FIND v(dout0_3) AT=530.05n

.meas tran vdout0_4ck520 FIND v(dout0_4) AT=530.05n

.meas tran vdout0_5ck520 FIND v(dout0_5) AT=530.05n

.meas tran vdout0_6ck520 FIND v(dout0_6) AT=530.05n

.meas tran vdout0_7ck520 FIND v(dout0_7) AT=530.05n

.meas tran vdout0_8ck520 FIND v(dout0_8) AT=530.05n

.meas tran vdout0_9ck520 FIND v(dout0_9) AT=530.05n

.meas tran vdout0_10ck520 FIND v(dout0_10) AT=530.05n

.meas tran vdout0_11ck520 FIND v(dout0_11) AT=530.05n

.meas tran vdout0_12ck520 FIND v(dout0_12) AT=530.05n

.meas tran vdout0_13ck520 FIND v(dout0_13) AT=530.05n

.meas tran vdout0_14ck520 FIND v(dout0_14) AT=530.05n

.meas tran vdout0_15ck520 FIND v(dout0_15) AT=530.05n

.meas tran vdout0_16ck520 FIND v(dout0_16) AT=530.05n

.meas tran vdout0_17ck520 FIND v(dout0_17) AT=530.05n

.meas tran vdout0_18ck520 FIND v(dout0_18) AT=530.05n

.meas tran vdout0_19ck520 FIND v(dout0_19) AT=530.05n

.meas tran vdout0_20ck520 FIND v(dout0_20) AT=530.05n

.meas tran vdout0_21ck520 FIND v(dout0_21) AT=530.05n

.meas tran vdout0_22ck520 FIND v(dout0_22) AT=530.05n

.meas tran vdout0_23ck520 FIND v(dout0_23) AT=530.05n

.meas tran vdout0_24ck520 FIND v(dout0_24) AT=530.05n

.meas tran vdout0_25ck520 FIND v(dout0_25) AT=530.05n

.meas tran vdout0_26ck520 FIND v(dout0_26) AT=530.05n

.meas tran vdout0_27ck520 FIND v(dout0_27) AT=530.05n

.meas tran vdout0_28ck520 FIND v(dout0_28) AT=530.05n

.meas tran vdout0_29ck520 FIND v(dout0_29) AT=530.05n

.meas tran vdout0_30ck520 FIND v(dout0_30) AT=530.05n

.meas tran vdout0_31ck520 FIND v(dout0_31) AT=530.05n

.meas tran vdout1_0ck520 FIND v(dout1_0) AT=530.05n

.meas tran vdout1_1ck520 FIND v(dout1_1) AT=530.05n

.meas tran vdout1_2ck520 FIND v(dout1_2) AT=530.05n

.meas tran vdout1_3ck520 FIND v(dout1_3) AT=530.05n

.meas tran vdout1_4ck520 FIND v(dout1_4) AT=530.05n

.meas tran vdout1_5ck520 FIND v(dout1_5) AT=530.05n

.meas tran vdout1_6ck520 FIND v(dout1_6) AT=530.05n

.meas tran vdout1_7ck520 FIND v(dout1_7) AT=530.05n

.meas tran vdout1_8ck520 FIND v(dout1_8) AT=530.05n

.meas tran vdout1_9ck520 FIND v(dout1_9) AT=530.05n

.meas tran vdout1_10ck520 FIND v(dout1_10) AT=530.05n

.meas tran vdout1_11ck520 FIND v(dout1_11) AT=530.05n

.meas tran vdout1_12ck520 FIND v(dout1_12) AT=530.05n

.meas tran vdout1_13ck520 FIND v(dout1_13) AT=530.05n

.meas tran vdout1_14ck520 FIND v(dout1_14) AT=530.05n

.meas tran vdout1_15ck520 FIND v(dout1_15) AT=530.05n

.meas tran vdout1_16ck520 FIND v(dout1_16) AT=530.05n

.meas tran vdout1_17ck520 FIND v(dout1_17) AT=530.05n

.meas tran vdout1_18ck520 FIND v(dout1_18) AT=530.05n

.meas tran vdout1_19ck520 FIND v(dout1_19) AT=530.05n

.meas tran vdout1_20ck520 FIND v(dout1_20) AT=530.05n

.meas tran vdout1_21ck520 FIND v(dout1_21) AT=530.05n

.meas tran vdout1_22ck520 FIND v(dout1_22) AT=530.05n

.meas tran vdout1_23ck520 FIND v(dout1_23) AT=530.05n

.meas tran vdout1_24ck520 FIND v(dout1_24) AT=530.05n

.meas tran vdout1_25ck520 FIND v(dout1_25) AT=530.05n

.meas tran vdout1_26ck520 FIND v(dout1_26) AT=530.05n

.meas tran vdout1_27ck520 FIND v(dout1_27) AT=530.05n

.meas tran vdout1_28ck520 FIND v(dout1_28) AT=530.05n

.meas tran vdout1_29ck520 FIND v(dout1_29) AT=530.05n

.meas tran vdout1_30ck520 FIND v(dout1_30) AT=530.05n

.meas tran vdout1_31ck520 FIND v(dout1_31) AT=530.05n

.meas tran vdout1_0ck540 FIND v(dout1_0) AT=550.05n

.meas tran vdout1_1ck540 FIND v(dout1_1) AT=550.05n

.meas tran vdout1_2ck540 FIND v(dout1_2) AT=550.05n

.meas tran vdout1_3ck540 FIND v(dout1_3) AT=550.05n

.meas tran vdout1_4ck540 FIND v(dout1_4) AT=550.05n

.meas tran vdout1_5ck540 FIND v(dout1_5) AT=550.05n

.meas tran vdout1_6ck540 FIND v(dout1_6) AT=550.05n

.meas tran vdout1_7ck540 FIND v(dout1_7) AT=550.05n

.meas tran vdout1_8ck540 FIND v(dout1_8) AT=550.05n

.meas tran vdout1_9ck540 FIND v(dout1_9) AT=550.05n

.meas tran vdout1_10ck540 FIND v(dout1_10) AT=550.05n

.meas tran vdout1_11ck540 FIND v(dout1_11) AT=550.05n

.meas tran vdout1_12ck540 FIND v(dout1_12) AT=550.05n

.meas tran vdout1_13ck540 FIND v(dout1_13) AT=550.05n

.meas tran vdout1_14ck540 FIND v(dout1_14) AT=550.05n

.meas tran vdout1_15ck540 FIND v(dout1_15) AT=550.05n

.meas tran vdout1_16ck540 FIND v(dout1_16) AT=550.05n

.meas tran vdout1_17ck540 FIND v(dout1_17) AT=550.05n

.meas tran vdout1_18ck540 FIND v(dout1_18) AT=550.05n

.meas tran vdout1_19ck540 FIND v(dout1_19) AT=550.05n

.meas tran vdout1_20ck540 FIND v(dout1_20) AT=550.05n

.meas tran vdout1_21ck540 FIND v(dout1_21) AT=550.05n

.meas tran vdout1_22ck540 FIND v(dout1_22) AT=550.05n

.meas tran vdout1_23ck540 FIND v(dout1_23) AT=550.05n

.meas tran vdout1_24ck540 FIND v(dout1_24) AT=550.05n

.meas tran vdout1_25ck540 FIND v(dout1_25) AT=550.05n

.meas tran vdout1_26ck540 FIND v(dout1_26) AT=550.05n

.meas tran vdout1_27ck540 FIND v(dout1_27) AT=550.05n

.meas tran vdout1_28ck540 FIND v(dout1_28) AT=550.05n

.meas tran vdout1_29ck540 FIND v(dout1_29) AT=550.05n

.meas tran vdout1_30ck540 FIND v(dout1_30) AT=550.05n

.meas tran vdout1_31ck540 FIND v(dout1_31) AT=550.05n

.meas tran vdout0_0ck550 FIND v(dout0_0) AT=560.05n

.meas tran vdout0_1ck550 FIND v(dout0_1) AT=560.05n

.meas tran vdout0_2ck550 FIND v(dout0_2) AT=560.05n

.meas tran vdout0_3ck550 FIND v(dout0_3) AT=560.05n

.meas tran vdout0_4ck550 FIND v(dout0_4) AT=560.05n

.meas tran vdout0_5ck550 FIND v(dout0_5) AT=560.05n

.meas tran vdout0_6ck550 FIND v(dout0_6) AT=560.05n

.meas tran vdout0_7ck550 FIND v(dout0_7) AT=560.05n

.meas tran vdout0_8ck550 FIND v(dout0_8) AT=560.05n

.meas tran vdout0_9ck550 FIND v(dout0_9) AT=560.05n

.meas tran vdout0_10ck550 FIND v(dout0_10) AT=560.05n

.meas tran vdout0_11ck550 FIND v(dout0_11) AT=560.05n

.meas tran vdout0_12ck550 FIND v(dout0_12) AT=560.05n

.meas tran vdout0_13ck550 FIND v(dout0_13) AT=560.05n

.meas tran vdout0_14ck550 FIND v(dout0_14) AT=560.05n

.meas tran vdout0_15ck550 FIND v(dout0_15) AT=560.05n

.meas tran vdout0_16ck550 FIND v(dout0_16) AT=560.05n

.meas tran vdout0_17ck550 FIND v(dout0_17) AT=560.05n

.meas tran vdout0_18ck550 FIND v(dout0_18) AT=560.05n

.meas tran vdout0_19ck550 FIND v(dout0_19) AT=560.05n

.meas tran vdout0_20ck550 FIND v(dout0_20) AT=560.05n

.meas tran vdout0_21ck550 FIND v(dout0_21) AT=560.05n

.meas tran vdout0_22ck550 FIND v(dout0_22) AT=560.05n

.meas tran vdout0_23ck550 FIND v(dout0_23) AT=560.05n

.meas tran vdout0_24ck550 FIND v(dout0_24) AT=560.05n

.meas tran vdout0_25ck550 FIND v(dout0_25) AT=560.05n

.meas tran vdout0_26ck550 FIND v(dout0_26) AT=560.05n

.meas tran vdout0_27ck550 FIND v(dout0_27) AT=560.05n

.meas tran vdout0_28ck550 FIND v(dout0_28) AT=560.05n

.meas tran vdout0_29ck550 FIND v(dout0_29) AT=560.05n

.meas tran vdout0_30ck550 FIND v(dout0_30) AT=560.05n

.meas tran vdout0_31ck550 FIND v(dout0_31) AT=560.05n

.meas tran vdout0_0ck560 FIND v(dout0_0) AT=570.05n

.meas tran vdout0_1ck560 FIND v(dout0_1) AT=570.05n

.meas tran vdout0_2ck560 FIND v(dout0_2) AT=570.05n

.meas tran vdout0_3ck560 FIND v(dout0_3) AT=570.05n

.meas tran vdout0_4ck560 FIND v(dout0_4) AT=570.05n

.meas tran vdout0_5ck560 FIND v(dout0_5) AT=570.05n

.meas tran vdout0_6ck560 FIND v(dout0_6) AT=570.05n

.meas tran vdout0_7ck560 FIND v(dout0_7) AT=570.05n

.meas tran vdout0_8ck560 FIND v(dout0_8) AT=570.05n

.meas tran vdout0_9ck560 FIND v(dout0_9) AT=570.05n

.meas tran vdout0_10ck560 FIND v(dout0_10) AT=570.05n

.meas tran vdout0_11ck560 FIND v(dout0_11) AT=570.05n

.meas tran vdout0_12ck560 FIND v(dout0_12) AT=570.05n

.meas tran vdout0_13ck560 FIND v(dout0_13) AT=570.05n

.meas tran vdout0_14ck560 FIND v(dout0_14) AT=570.05n

.meas tran vdout0_15ck560 FIND v(dout0_15) AT=570.05n

.meas tran vdout0_16ck560 FIND v(dout0_16) AT=570.05n

.meas tran vdout0_17ck560 FIND v(dout0_17) AT=570.05n

.meas tran vdout0_18ck560 FIND v(dout0_18) AT=570.05n

.meas tran vdout0_19ck560 FIND v(dout0_19) AT=570.05n

.meas tran vdout0_20ck560 FIND v(dout0_20) AT=570.05n

.meas tran vdout0_21ck560 FIND v(dout0_21) AT=570.05n

.meas tran vdout0_22ck560 FIND v(dout0_22) AT=570.05n

.meas tran vdout0_23ck560 FIND v(dout0_23) AT=570.05n

.meas tran vdout0_24ck560 FIND v(dout0_24) AT=570.05n

.meas tran vdout0_25ck560 FIND v(dout0_25) AT=570.05n

.meas tran vdout0_26ck560 FIND v(dout0_26) AT=570.05n

.meas tran vdout0_27ck560 FIND v(dout0_27) AT=570.05n

.meas tran vdout0_28ck560 FIND v(dout0_28) AT=570.05n

.meas tran vdout0_29ck560 FIND v(dout0_29) AT=570.05n

.meas tran vdout0_30ck560 FIND v(dout0_30) AT=570.05n

.meas tran vdout0_31ck560 FIND v(dout0_31) AT=570.05n

.meas tran vdout1_0ck560 FIND v(dout1_0) AT=570.05n

.meas tran vdout1_1ck560 FIND v(dout1_1) AT=570.05n

.meas tran vdout1_2ck560 FIND v(dout1_2) AT=570.05n

.meas tran vdout1_3ck560 FIND v(dout1_3) AT=570.05n

.meas tran vdout1_4ck560 FIND v(dout1_4) AT=570.05n

.meas tran vdout1_5ck560 FIND v(dout1_5) AT=570.05n

.meas tran vdout1_6ck560 FIND v(dout1_6) AT=570.05n

.meas tran vdout1_7ck560 FIND v(dout1_7) AT=570.05n

.meas tran vdout1_8ck560 FIND v(dout1_8) AT=570.05n

.meas tran vdout1_9ck560 FIND v(dout1_9) AT=570.05n

.meas tran vdout1_10ck560 FIND v(dout1_10) AT=570.05n

.meas tran vdout1_11ck560 FIND v(dout1_11) AT=570.05n

.meas tran vdout1_12ck560 FIND v(dout1_12) AT=570.05n

.meas tran vdout1_13ck560 FIND v(dout1_13) AT=570.05n

.meas tran vdout1_14ck560 FIND v(dout1_14) AT=570.05n

.meas tran vdout1_15ck560 FIND v(dout1_15) AT=570.05n

.meas tran vdout1_16ck560 FIND v(dout1_16) AT=570.05n

.meas tran vdout1_17ck560 FIND v(dout1_17) AT=570.05n

.meas tran vdout1_18ck560 FIND v(dout1_18) AT=570.05n

.meas tran vdout1_19ck560 FIND v(dout1_19) AT=570.05n

.meas tran vdout1_20ck560 FIND v(dout1_20) AT=570.05n

.meas tran vdout1_21ck560 FIND v(dout1_21) AT=570.05n

.meas tran vdout1_22ck560 FIND v(dout1_22) AT=570.05n

.meas tran vdout1_23ck560 FIND v(dout1_23) AT=570.05n

.meas tran vdout1_24ck560 FIND v(dout1_24) AT=570.05n

.meas tran vdout1_25ck560 FIND v(dout1_25) AT=570.05n

.meas tran vdout1_26ck560 FIND v(dout1_26) AT=570.05n

.meas tran vdout1_27ck560 FIND v(dout1_27) AT=570.05n

.meas tran vdout1_28ck560 FIND v(dout1_28) AT=570.05n

.meas tran vdout1_29ck560 FIND v(dout1_29) AT=570.05n

.meas tran vdout1_30ck560 FIND v(dout1_30) AT=570.05n

.meas tran vdout1_31ck560 FIND v(dout1_31) AT=570.05n

.meas tran vdout0_0ck570 FIND v(dout0_0) AT=580.05n

.meas tran vdout0_1ck570 FIND v(dout0_1) AT=580.05n

.meas tran vdout0_2ck570 FIND v(dout0_2) AT=580.05n

.meas tran vdout0_3ck570 FIND v(dout0_3) AT=580.05n

.meas tran vdout0_4ck570 FIND v(dout0_4) AT=580.05n

.meas tran vdout0_5ck570 FIND v(dout0_5) AT=580.05n

.meas tran vdout0_6ck570 FIND v(dout0_6) AT=580.05n

.meas tran vdout0_7ck570 FIND v(dout0_7) AT=580.05n

.meas tran vdout0_8ck570 FIND v(dout0_8) AT=580.05n

.meas tran vdout0_9ck570 FIND v(dout0_9) AT=580.05n

.meas tran vdout0_10ck570 FIND v(dout0_10) AT=580.05n

.meas tran vdout0_11ck570 FIND v(dout0_11) AT=580.05n

.meas tran vdout0_12ck570 FIND v(dout0_12) AT=580.05n

.meas tran vdout0_13ck570 FIND v(dout0_13) AT=580.05n

.meas tran vdout0_14ck570 FIND v(dout0_14) AT=580.05n

.meas tran vdout0_15ck570 FIND v(dout0_15) AT=580.05n

.meas tran vdout0_16ck570 FIND v(dout0_16) AT=580.05n

.meas tran vdout0_17ck570 FIND v(dout0_17) AT=580.05n

.meas tran vdout0_18ck570 FIND v(dout0_18) AT=580.05n

.meas tran vdout0_19ck570 FIND v(dout0_19) AT=580.05n

.meas tran vdout0_20ck570 FIND v(dout0_20) AT=580.05n

.meas tran vdout0_21ck570 FIND v(dout0_21) AT=580.05n

.meas tran vdout0_22ck570 FIND v(dout0_22) AT=580.05n

.meas tran vdout0_23ck570 FIND v(dout0_23) AT=580.05n

.meas tran vdout0_24ck570 FIND v(dout0_24) AT=580.05n

.meas tran vdout0_25ck570 FIND v(dout0_25) AT=580.05n

.meas tran vdout0_26ck570 FIND v(dout0_26) AT=580.05n

.meas tran vdout0_27ck570 FIND v(dout0_27) AT=580.05n

.meas tran vdout0_28ck570 FIND v(dout0_28) AT=580.05n

.meas tran vdout0_29ck570 FIND v(dout0_29) AT=580.05n

.meas tran vdout0_30ck570 FIND v(dout0_30) AT=580.05n

.meas tran vdout0_31ck570 FIND v(dout0_31) AT=580.05n

.meas tran vdout1_0ck570 FIND v(dout1_0) AT=580.05n

.meas tran vdout1_1ck570 FIND v(dout1_1) AT=580.05n

.meas tran vdout1_2ck570 FIND v(dout1_2) AT=580.05n

.meas tran vdout1_3ck570 FIND v(dout1_3) AT=580.05n

.meas tran vdout1_4ck570 FIND v(dout1_4) AT=580.05n

.meas tran vdout1_5ck570 FIND v(dout1_5) AT=580.05n

.meas tran vdout1_6ck570 FIND v(dout1_6) AT=580.05n

.meas tran vdout1_7ck570 FIND v(dout1_7) AT=580.05n

.meas tran vdout1_8ck570 FIND v(dout1_8) AT=580.05n

.meas tran vdout1_9ck570 FIND v(dout1_9) AT=580.05n

.meas tran vdout1_10ck570 FIND v(dout1_10) AT=580.05n

.meas tran vdout1_11ck570 FIND v(dout1_11) AT=580.05n

.meas tran vdout1_12ck570 FIND v(dout1_12) AT=580.05n

.meas tran vdout1_13ck570 FIND v(dout1_13) AT=580.05n

.meas tran vdout1_14ck570 FIND v(dout1_14) AT=580.05n

.meas tran vdout1_15ck570 FIND v(dout1_15) AT=580.05n

.meas tran vdout1_16ck570 FIND v(dout1_16) AT=580.05n

.meas tran vdout1_17ck570 FIND v(dout1_17) AT=580.05n

.meas tran vdout1_18ck570 FIND v(dout1_18) AT=580.05n

.meas tran vdout1_19ck570 FIND v(dout1_19) AT=580.05n

.meas tran vdout1_20ck570 FIND v(dout1_20) AT=580.05n

.meas tran vdout1_21ck570 FIND v(dout1_21) AT=580.05n

.meas tran vdout1_22ck570 FIND v(dout1_22) AT=580.05n

.meas tran vdout1_23ck570 FIND v(dout1_23) AT=580.05n

.meas tran vdout1_24ck570 FIND v(dout1_24) AT=580.05n

.meas tran vdout1_25ck570 FIND v(dout1_25) AT=580.05n

.meas tran vdout1_26ck570 FIND v(dout1_26) AT=580.05n

.meas tran vdout1_27ck570 FIND v(dout1_27) AT=580.05n

.meas tran vdout1_28ck570 FIND v(dout1_28) AT=580.05n

.meas tran vdout1_29ck570 FIND v(dout1_29) AT=580.05n

.meas tran vdout1_30ck570 FIND v(dout1_30) AT=580.05n

.meas tran vdout1_31ck570 FIND v(dout1_31) AT=580.05n

.meas tran vdout0_0ck580 FIND v(dout0_0) AT=590.05n

.meas tran vdout0_1ck580 FIND v(dout0_1) AT=590.05n

.meas tran vdout0_2ck580 FIND v(dout0_2) AT=590.05n

.meas tran vdout0_3ck580 FIND v(dout0_3) AT=590.05n

.meas tran vdout0_4ck580 FIND v(dout0_4) AT=590.05n

.meas tran vdout0_5ck580 FIND v(dout0_5) AT=590.05n

.meas tran vdout0_6ck580 FIND v(dout0_6) AT=590.05n

.meas tran vdout0_7ck580 FIND v(dout0_7) AT=590.05n

.meas tran vdout0_8ck580 FIND v(dout0_8) AT=590.05n

.meas tran vdout0_9ck580 FIND v(dout0_9) AT=590.05n

.meas tran vdout0_10ck580 FIND v(dout0_10) AT=590.05n

.meas tran vdout0_11ck580 FIND v(dout0_11) AT=590.05n

.meas tran vdout0_12ck580 FIND v(dout0_12) AT=590.05n

.meas tran vdout0_13ck580 FIND v(dout0_13) AT=590.05n

.meas tran vdout0_14ck580 FIND v(dout0_14) AT=590.05n

.meas tran vdout0_15ck580 FIND v(dout0_15) AT=590.05n

.meas tran vdout0_16ck580 FIND v(dout0_16) AT=590.05n

.meas tran vdout0_17ck580 FIND v(dout0_17) AT=590.05n

.meas tran vdout0_18ck580 FIND v(dout0_18) AT=590.05n

.meas tran vdout0_19ck580 FIND v(dout0_19) AT=590.05n

.meas tran vdout0_20ck580 FIND v(dout0_20) AT=590.05n

.meas tran vdout0_21ck580 FIND v(dout0_21) AT=590.05n

.meas tran vdout0_22ck580 FIND v(dout0_22) AT=590.05n

.meas tran vdout0_23ck580 FIND v(dout0_23) AT=590.05n

.meas tran vdout0_24ck580 FIND v(dout0_24) AT=590.05n

.meas tran vdout0_25ck580 FIND v(dout0_25) AT=590.05n

.meas tran vdout0_26ck580 FIND v(dout0_26) AT=590.05n

.meas tran vdout0_27ck580 FIND v(dout0_27) AT=590.05n

.meas tran vdout0_28ck580 FIND v(dout0_28) AT=590.05n

.meas tran vdout0_29ck580 FIND v(dout0_29) AT=590.05n

.meas tran vdout0_30ck580 FIND v(dout0_30) AT=590.05n

.meas tran vdout0_31ck580 FIND v(dout0_31) AT=590.05n

.meas tran vdout1_0ck580 FIND v(dout1_0) AT=590.05n

.meas tran vdout1_1ck580 FIND v(dout1_1) AT=590.05n

.meas tran vdout1_2ck580 FIND v(dout1_2) AT=590.05n

.meas tran vdout1_3ck580 FIND v(dout1_3) AT=590.05n

.meas tran vdout1_4ck580 FIND v(dout1_4) AT=590.05n

.meas tran vdout1_5ck580 FIND v(dout1_5) AT=590.05n

.meas tran vdout1_6ck580 FIND v(dout1_6) AT=590.05n

.meas tran vdout1_7ck580 FIND v(dout1_7) AT=590.05n

.meas tran vdout1_8ck580 FIND v(dout1_8) AT=590.05n

.meas tran vdout1_9ck580 FIND v(dout1_9) AT=590.05n

.meas tran vdout1_10ck580 FIND v(dout1_10) AT=590.05n

.meas tran vdout1_11ck580 FIND v(dout1_11) AT=590.05n

.meas tran vdout1_12ck580 FIND v(dout1_12) AT=590.05n

.meas tran vdout1_13ck580 FIND v(dout1_13) AT=590.05n

.meas tran vdout1_14ck580 FIND v(dout1_14) AT=590.05n

.meas tran vdout1_15ck580 FIND v(dout1_15) AT=590.05n

.meas tran vdout1_16ck580 FIND v(dout1_16) AT=590.05n

.meas tran vdout1_17ck580 FIND v(dout1_17) AT=590.05n

.meas tran vdout1_18ck580 FIND v(dout1_18) AT=590.05n

.meas tran vdout1_19ck580 FIND v(dout1_19) AT=590.05n

.meas tran vdout1_20ck580 FIND v(dout1_20) AT=590.05n

.meas tran vdout1_21ck580 FIND v(dout1_21) AT=590.05n

.meas tran vdout1_22ck580 FIND v(dout1_22) AT=590.05n

.meas tran vdout1_23ck580 FIND v(dout1_23) AT=590.05n

.meas tran vdout1_24ck580 FIND v(dout1_24) AT=590.05n

.meas tran vdout1_25ck580 FIND v(dout1_25) AT=590.05n

.meas tran vdout1_26ck580 FIND v(dout1_26) AT=590.05n

.meas tran vdout1_27ck580 FIND v(dout1_27) AT=590.05n

.meas tran vdout1_28ck580 FIND v(dout1_28) AT=590.05n

.meas tran vdout1_29ck580 FIND v(dout1_29) AT=590.05n

.meas tran vdout1_30ck580 FIND v(dout1_30) AT=590.05n

.meas tran vdout1_31ck580 FIND v(dout1_31) AT=590.05n

.meas tran vdout0_0ck590 FIND v(dout0_0) AT=600.05n

.meas tran vdout0_1ck590 FIND v(dout0_1) AT=600.05n

.meas tran vdout0_2ck590 FIND v(dout0_2) AT=600.05n

.meas tran vdout0_3ck590 FIND v(dout0_3) AT=600.05n

.meas tran vdout0_4ck590 FIND v(dout0_4) AT=600.05n

.meas tran vdout0_5ck590 FIND v(dout0_5) AT=600.05n

.meas tran vdout0_6ck590 FIND v(dout0_6) AT=600.05n

.meas tran vdout0_7ck590 FIND v(dout0_7) AT=600.05n

.meas tran vdout0_8ck590 FIND v(dout0_8) AT=600.05n

.meas tran vdout0_9ck590 FIND v(dout0_9) AT=600.05n

.meas tran vdout0_10ck590 FIND v(dout0_10) AT=600.05n

.meas tran vdout0_11ck590 FIND v(dout0_11) AT=600.05n

.meas tran vdout0_12ck590 FIND v(dout0_12) AT=600.05n

.meas tran vdout0_13ck590 FIND v(dout0_13) AT=600.05n

.meas tran vdout0_14ck590 FIND v(dout0_14) AT=600.05n

.meas tran vdout0_15ck590 FIND v(dout0_15) AT=600.05n

.meas tran vdout0_16ck590 FIND v(dout0_16) AT=600.05n

.meas tran vdout0_17ck590 FIND v(dout0_17) AT=600.05n

.meas tran vdout0_18ck590 FIND v(dout0_18) AT=600.05n

.meas tran vdout0_19ck590 FIND v(dout0_19) AT=600.05n

.meas tran vdout0_20ck590 FIND v(dout0_20) AT=600.05n

.meas tran vdout0_21ck590 FIND v(dout0_21) AT=600.05n

.meas tran vdout0_22ck590 FIND v(dout0_22) AT=600.05n

.meas tran vdout0_23ck590 FIND v(dout0_23) AT=600.05n

.meas tran vdout0_24ck590 FIND v(dout0_24) AT=600.05n

.meas tran vdout0_25ck590 FIND v(dout0_25) AT=600.05n

.meas tran vdout0_26ck590 FIND v(dout0_26) AT=600.05n

.meas tran vdout0_27ck590 FIND v(dout0_27) AT=600.05n

.meas tran vdout0_28ck590 FIND v(dout0_28) AT=600.05n

.meas tran vdout0_29ck590 FIND v(dout0_29) AT=600.05n

.meas tran vdout0_30ck590 FIND v(dout0_30) AT=600.05n

.meas tran vdout0_31ck590 FIND v(dout0_31) AT=600.05n

.meas tran vdout1_0ck590 FIND v(dout1_0) AT=600.05n

.meas tran vdout1_1ck590 FIND v(dout1_1) AT=600.05n

.meas tran vdout1_2ck590 FIND v(dout1_2) AT=600.05n

.meas tran vdout1_3ck590 FIND v(dout1_3) AT=600.05n

.meas tran vdout1_4ck590 FIND v(dout1_4) AT=600.05n

.meas tran vdout1_5ck590 FIND v(dout1_5) AT=600.05n

.meas tran vdout1_6ck590 FIND v(dout1_6) AT=600.05n

.meas tran vdout1_7ck590 FIND v(dout1_7) AT=600.05n

.meas tran vdout1_8ck590 FIND v(dout1_8) AT=600.05n

.meas tran vdout1_9ck590 FIND v(dout1_9) AT=600.05n

.meas tran vdout1_10ck590 FIND v(dout1_10) AT=600.05n

.meas tran vdout1_11ck590 FIND v(dout1_11) AT=600.05n

.meas tran vdout1_12ck590 FIND v(dout1_12) AT=600.05n

.meas tran vdout1_13ck590 FIND v(dout1_13) AT=600.05n

.meas tran vdout1_14ck590 FIND v(dout1_14) AT=600.05n

.meas tran vdout1_15ck590 FIND v(dout1_15) AT=600.05n

.meas tran vdout1_16ck590 FIND v(dout1_16) AT=600.05n

.meas tran vdout1_17ck590 FIND v(dout1_17) AT=600.05n

.meas tran vdout1_18ck590 FIND v(dout1_18) AT=600.05n

.meas tran vdout1_19ck590 FIND v(dout1_19) AT=600.05n

.meas tran vdout1_20ck590 FIND v(dout1_20) AT=600.05n

.meas tran vdout1_21ck590 FIND v(dout1_21) AT=600.05n

.meas tran vdout1_22ck590 FIND v(dout1_22) AT=600.05n

.meas tran vdout1_23ck590 FIND v(dout1_23) AT=600.05n

.meas tran vdout1_24ck590 FIND v(dout1_24) AT=600.05n

.meas tran vdout1_25ck590 FIND v(dout1_25) AT=600.05n

.meas tran vdout1_26ck590 FIND v(dout1_26) AT=600.05n

.meas tran vdout1_27ck590 FIND v(dout1_27) AT=600.05n

.meas tran vdout1_28ck590 FIND v(dout1_28) AT=600.05n

.meas tran vdout1_29ck590 FIND v(dout1_29) AT=600.05n

.meas tran vdout1_30ck590 FIND v(dout1_30) AT=600.05n

.meas tran vdout1_31ck590 FIND v(dout1_31) AT=600.05n

.meas tran vdout0_0ck600 FIND v(dout0_0) AT=610.05n

.meas tran vdout0_1ck600 FIND v(dout0_1) AT=610.05n

.meas tran vdout0_2ck600 FIND v(dout0_2) AT=610.05n

.meas tran vdout0_3ck600 FIND v(dout0_3) AT=610.05n

.meas tran vdout0_4ck600 FIND v(dout0_4) AT=610.05n

.meas tran vdout0_5ck600 FIND v(dout0_5) AT=610.05n

.meas tran vdout0_6ck600 FIND v(dout0_6) AT=610.05n

.meas tran vdout0_7ck600 FIND v(dout0_7) AT=610.05n

.meas tran vdout0_8ck600 FIND v(dout0_8) AT=610.05n

.meas tran vdout0_9ck600 FIND v(dout0_9) AT=610.05n

.meas tran vdout0_10ck600 FIND v(dout0_10) AT=610.05n

.meas tran vdout0_11ck600 FIND v(dout0_11) AT=610.05n

.meas tran vdout0_12ck600 FIND v(dout0_12) AT=610.05n

.meas tran vdout0_13ck600 FIND v(dout0_13) AT=610.05n

.meas tran vdout0_14ck600 FIND v(dout0_14) AT=610.05n

.meas tran vdout0_15ck600 FIND v(dout0_15) AT=610.05n

.meas tran vdout0_16ck600 FIND v(dout0_16) AT=610.05n

.meas tran vdout0_17ck600 FIND v(dout0_17) AT=610.05n

.meas tran vdout0_18ck600 FIND v(dout0_18) AT=610.05n

.meas tran vdout0_19ck600 FIND v(dout0_19) AT=610.05n

.meas tran vdout0_20ck600 FIND v(dout0_20) AT=610.05n

.meas tran vdout0_21ck600 FIND v(dout0_21) AT=610.05n

.meas tran vdout0_22ck600 FIND v(dout0_22) AT=610.05n

.meas tran vdout0_23ck600 FIND v(dout0_23) AT=610.05n

.meas tran vdout0_24ck600 FIND v(dout0_24) AT=610.05n

.meas tran vdout0_25ck600 FIND v(dout0_25) AT=610.05n

.meas tran vdout0_26ck600 FIND v(dout0_26) AT=610.05n

.meas tran vdout0_27ck600 FIND v(dout0_27) AT=610.05n

.meas tran vdout0_28ck600 FIND v(dout0_28) AT=610.05n

.meas tran vdout0_29ck600 FIND v(dout0_29) AT=610.05n

.meas tran vdout0_30ck600 FIND v(dout0_30) AT=610.05n

.meas tran vdout0_31ck600 FIND v(dout0_31) AT=610.05n

.meas tran vdout1_0ck610 FIND v(dout1_0) AT=620.05n

.meas tran vdout1_1ck610 FIND v(dout1_1) AT=620.05n

.meas tran vdout1_2ck610 FIND v(dout1_2) AT=620.05n

.meas tran vdout1_3ck610 FIND v(dout1_3) AT=620.05n

.meas tran vdout1_4ck610 FIND v(dout1_4) AT=620.05n

.meas tran vdout1_5ck610 FIND v(dout1_5) AT=620.05n

.meas tran vdout1_6ck610 FIND v(dout1_6) AT=620.05n

.meas tran vdout1_7ck610 FIND v(dout1_7) AT=620.05n

.meas tran vdout1_8ck610 FIND v(dout1_8) AT=620.05n

.meas tran vdout1_9ck610 FIND v(dout1_9) AT=620.05n

.meas tran vdout1_10ck610 FIND v(dout1_10) AT=620.05n

.meas tran vdout1_11ck610 FIND v(dout1_11) AT=620.05n

.meas tran vdout1_12ck610 FIND v(dout1_12) AT=620.05n

.meas tran vdout1_13ck610 FIND v(dout1_13) AT=620.05n

.meas tran vdout1_14ck610 FIND v(dout1_14) AT=620.05n

.meas tran vdout1_15ck610 FIND v(dout1_15) AT=620.05n

.meas tran vdout1_16ck610 FIND v(dout1_16) AT=620.05n

.meas tran vdout1_17ck610 FIND v(dout1_17) AT=620.05n

.meas tran vdout1_18ck610 FIND v(dout1_18) AT=620.05n

.meas tran vdout1_19ck610 FIND v(dout1_19) AT=620.05n

.meas tran vdout1_20ck610 FIND v(dout1_20) AT=620.05n

.meas tran vdout1_21ck610 FIND v(dout1_21) AT=620.05n

.meas tran vdout1_22ck610 FIND v(dout1_22) AT=620.05n

.meas tran vdout1_23ck610 FIND v(dout1_23) AT=620.05n

.meas tran vdout1_24ck610 FIND v(dout1_24) AT=620.05n

.meas tran vdout1_25ck610 FIND v(dout1_25) AT=620.05n

.meas tran vdout1_26ck610 FIND v(dout1_26) AT=620.05n

.meas tran vdout1_27ck610 FIND v(dout1_27) AT=620.05n

.meas tran vdout1_28ck610 FIND v(dout1_28) AT=620.05n

.meas tran vdout1_29ck610 FIND v(dout1_29) AT=620.05n

.meas tran vdout1_30ck610 FIND v(dout1_30) AT=620.05n

.meas tran vdout1_31ck610 FIND v(dout1_31) AT=620.05n

.meas tran vdout0_0ck620 FIND v(dout0_0) AT=630.05n

.meas tran vdout0_1ck620 FIND v(dout0_1) AT=630.05n

.meas tran vdout0_2ck620 FIND v(dout0_2) AT=630.05n

.meas tran vdout0_3ck620 FIND v(dout0_3) AT=630.05n

.meas tran vdout0_4ck620 FIND v(dout0_4) AT=630.05n

.meas tran vdout0_5ck620 FIND v(dout0_5) AT=630.05n

.meas tran vdout0_6ck620 FIND v(dout0_6) AT=630.05n

.meas tran vdout0_7ck620 FIND v(dout0_7) AT=630.05n

.meas tran vdout0_8ck620 FIND v(dout0_8) AT=630.05n

.meas tran vdout0_9ck620 FIND v(dout0_9) AT=630.05n

.meas tran vdout0_10ck620 FIND v(dout0_10) AT=630.05n

.meas tran vdout0_11ck620 FIND v(dout0_11) AT=630.05n

.meas tran vdout0_12ck620 FIND v(dout0_12) AT=630.05n

.meas tran vdout0_13ck620 FIND v(dout0_13) AT=630.05n

.meas tran vdout0_14ck620 FIND v(dout0_14) AT=630.05n

.meas tran vdout0_15ck620 FIND v(dout0_15) AT=630.05n

.meas tran vdout0_16ck620 FIND v(dout0_16) AT=630.05n

.meas tran vdout0_17ck620 FIND v(dout0_17) AT=630.05n

.meas tran vdout0_18ck620 FIND v(dout0_18) AT=630.05n

.meas tran vdout0_19ck620 FIND v(dout0_19) AT=630.05n

.meas tran vdout0_20ck620 FIND v(dout0_20) AT=630.05n

.meas tran vdout0_21ck620 FIND v(dout0_21) AT=630.05n

.meas tran vdout0_22ck620 FIND v(dout0_22) AT=630.05n

.meas tran vdout0_23ck620 FIND v(dout0_23) AT=630.05n

.meas tran vdout0_24ck620 FIND v(dout0_24) AT=630.05n

.meas tran vdout0_25ck620 FIND v(dout0_25) AT=630.05n

.meas tran vdout0_26ck620 FIND v(dout0_26) AT=630.05n

.meas tran vdout0_27ck620 FIND v(dout0_27) AT=630.05n

.meas tran vdout0_28ck620 FIND v(dout0_28) AT=630.05n

.meas tran vdout0_29ck620 FIND v(dout0_29) AT=630.05n

.meas tran vdout0_30ck620 FIND v(dout0_30) AT=630.05n

.meas tran vdout0_31ck620 FIND v(dout0_31) AT=630.05n

.meas tran vdout1_0ck620 FIND v(dout1_0) AT=630.05n

.meas tran vdout1_1ck620 FIND v(dout1_1) AT=630.05n

.meas tran vdout1_2ck620 FIND v(dout1_2) AT=630.05n

.meas tran vdout1_3ck620 FIND v(dout1_3) AT=630.05n

.meas tran vdout1_4ck620 FIND v(dout1_4) AT=630.05n

.meas tran vdout1_5ck620 FIND v(dout1_5) AT=630.05n

.meas tran vdout1_6ck620 FIND v(dout1_6) AT=630.05n

.meas tran vdout1_7ck620 FIND v(dout1_7) AT=630.05n

.meas tran vdout1_8ck620 FIND v(dout1_8) AT=630.05n

.meas tran vdout1_9ck620 FIND v(dout1_9) AT=630.05n

.meas tran vdout1_10ck620 FIND v(dout1_10) AT=630.05n

.meas tran vdout1_11ck620 FIND v(dout1_11) AT=630.05n

.meas tran vdout1_12ck620 FIND v(dout1_12) AT=630.05n

.meas tran vdout1_13ck620 FIND v(dout1_13) AT=630.05n

.meas tran vdout1_14ck620 FIND v(dout1_14) AT=630.05n

.meas tran vdout1_15ck620 FIND v(dout1_15) AT=630.05n

.meas tran vdout1_16ck620 FIND v(dout1_16) AT=630.05n

.meas tran vdout1_17ck620 FIND v(dout1_17) AT=630.05n

.meas tran vdout1_18ck620 FIND v(dout1_18) AT=630.05n

.meas tran vdout1_19ck620 FIND v(dout1_19) AT=630.05n

.meas tran vdout1_20ck620 FIND v(dout1_20) AT=630.05n

.meas tran vdout1_21ck620 FIND v(dout1_21) AT=630.05n

.meas tran vdout1_22ck620 FIND v(dout1_22) AT=630.05n

.meas tran vdout1_23ck620 FIND v(dout1_23) AT=630.05n

.meas tran vdout1_24ck620 FIND v(dout1_24) AT=630.05n

.meas tran vdout1_25ck620 FIND v(dout1_25) AT=630.05n

.meas tran vdout1_26ck620 FIND v(dout1_26) AT=630.05n

.meas tran vdout1_27ck620 FIND v(dout1_27) AT=630.05n

.meas tran vdout1_28ck620 FIND v(dout1_28) AT=630.05n

.meas tran vdout1_29ck620 FIND v(dout1_29) AT=630.05n

.meas tran vdout1_30ck620 FIND v(dout1_30) AT=630.05n

.meas tran vdout1_31ck620 FIND v(dout1_31) AT=630.05n

.meas tran vdout0_0ck640 FIND v(dout0_0) AT=650.05n

.meas tran vdout0_1ck640 FIND v(dout0_1) AT=650.05n

.meas tran vdout0_2ck640 FIND v(dout0_2) AT=650.05n

.meas tran vdout0_3ck640 FIND v(dout0_3) AT=650.05n

.meas tran vdout0_4ck640 FIND v(dout0_4) AT=650.05n

.meas tran vdout0_5ck640 FIND v(dout0_5) AT=650.05n

.meas tran vdout0_6ck640 FIND v(dout0_6) AT=650.05n

.meas tran vdout0_7ck640 FIND v(dout0_7) AT=650.05n

.meas tran vdout0_8ck640 FIND v(dout0_8) AT=650.05n

.meas tran vdout0_9ck640 FIND v(dout0_9) AT=650.05n

.meas tran vdout0_10ck640 FIND v(dout0_10) AT=650.05n

.meas tran vdout0_11ck640 FIND v(dout0_11) AT=650.05n

.meas tran vdout0_12ck640 FIND v(dout0_12) AT=650.05n

.meas tran vdout0_13ck640 FIND v(dout0_13) AT=650.05n

.meas tran vdout0_14ck640 FIND v(dout0_14) AT=650.05n

.meas tran vdout0_15ck640 FIND v(dout0_15) AT=650.05n

.meas tran vdout0_16ck640 FIND v(dout0_16) AT=650.05n

.meas tran vdout0_17ck640 FIND v(dout0_17) AT=650.05n

.meas tran vdout0_18ck640 FIND v(dout0_18) AT=650.05n

.meas tran vdout0_19ck640 FIND v(dout0_19) AT=650.05n

.meas tran vdout0_20ck640 FIND v(dout0_20) AT=650.05n

.meas tran vdout0_21ck640 FIND v(dout0_21) AT=650.05n

.meas tran vdout0_22ck640 FIND v(dout0_22) AT=650.05n

.meas tran vdout0_23ck640 FIND v(dout0_23) AT=650.05n

.meas tran vdout0_24ck640 FIND v(dout0_24) AT=650.05n

.meas tran vdout0_25ck640 FIND v(dout0_25) AT=650.05n

.meas tran vdout0_26ck640 FIND v(dout0_26) AT=650.05n

.meas tran vdout0_27ck640 FIND v(dout0_27) AT=650.05n

.meas tran vdout0_28ck640 FIND v(dout0_28) AT=650.05n

.meas tran vdout0_29ck640 FIND v(dout0_29) AT=650.05n

.meas tran vdout0_30ck640 FIND v(dout0_30) AT=650.05n

.meas tran vdout0_31ck640 FIND v(dout0_31) AT=650.05n

.meas tran vdout1_0ck640 FIND v(dout1_0) AT=650.05n

.meas tran vdout1_1ck640 FIND v(dout1_1) AT=650.05n

.meas tran vdout1_2ck640 FIND v(dout1_2) AT=650.05n

.meas tran vdout1_3ck640 FIND v(dout1_3) AT=650.05n

.meas tran vdout1_4ck640 FIND v(dout1_4) AT=650.05n

.meas tran vdout1_5ck640 FIND v(dout1_5) AT=650.05n

.meas tran vdout1_6ck640 FIND v(dout1_6) AT=650.05n

.meas tran vdout1_7ck640 FIND v(dout1_7) AT=650.05n

.meas tran vdout1_8ck640 FIND v(dout1_8) AT=650.05n

.meas tran vdout1_9ck640 FIND v(dout1_9) AT=650.05n

.meas tran vdout1_10ck640 FIND v(dout1_10) AT=650.05n

.meas tran vdout1_11ck640 FIND v(dout1_11) AT=650.05n

.meas tran vdout1_12ck640 FIND v(dout1_12) AT=650.05n

.meas tran vdout1_13ck640 FIND v(dout1_13) AT=650.05n

.meas tran vdout1_14ck640 FIND v(dout1_14) AT=650.05n

.meas tran vdout1_15ck640 FIND v(dout1_15) AT=650.05n

.meas tran vdout1_16ck640 FIND v(dout1_16) AT=650.05n

.meas tran vdout1_17ck640 FIND v(dout1_17) AT=650.05n

.meas tran vdout1_18ck640 FIND v(dout1_18) AT=650.05n

.meas tran vdout1_19ck640 FIND v(dout1_19) AT=650.05n

.meas tran vdout1_20ck640 FIND v(dout1_20) AT=650.05n

.meas tran vdout1_21ck640 FIND v(dout1_21) AT=650.05n

.meas tran vdout1_22ck640 FIND v(dout1_22) AT=650.05n

.meas tran vdout1_23ck640 FIND v(dout1_23) AT=650.05n

.meas tran vdout1_24ck640 FIND v(dout1_24) AT=650.05n

.meas tran vdout1_25ck640 FIND v(dout1_25) AT=650.05n

.meas tran vdout1_26ck640 FIND v(dout1_26) AT=650.05n

.meas tran vdout1_27ck640 FIND v(dout1_27) AT=650.05n

.meas tran vdout1_28ck640 FIND v(dout1_28) AT=650.05n

.meas tran vdout1_29ck640 FIND v(dout1_29) AT=650.05n

.meas tran vdout1_30ck640 FIND v(dout1_30) AT=650.05n

.meas tran vdout1_31ck640 FIND v(dout1_31) AT=650.05n

.meas tran vdout1_0ck650 FIND v(dout1_0) AT=660.05n

.meas tran vdout1_1ck650 FIND v(dout1_1) AT=660.05n

.meas tran vdout1_2ck650 FIND v(dout1_2) AT=660.05n

.meas tran vdout1_3ck650 FIND v(dout1_3) AT=660.05n

.meas tran vdout1_4ck650 FIND v(dout1_4) AT=660.05n

.meas tran vdout1_5ck650 FIND v(dout1_5) AT=660.05n

.meas tran vdout1_6ck650 FIND v(dout1_6) AT=660.05n

.meas tran vdout1_7ck650 FIND v(dout1_7) AT=660.05n

.meas tran vdout1_8ck650 FIND v(dout1_8) AT=660.05n

.meas tran vdout1_9ck650 FIND v(dout1_9) AT=660.05n

.meas tran vdout1_10ck650 FIND v(dout1_10) AT=660.05n

.meas tran vdout1_11ck650 FIND v(dout1_11) AT=660.05n

.meas tran vdout1_12ck650 FIND v(dout1_12) AT=660.05n

.meas tran vdout1_13ck650 FIND v(dout1_13) AT=660.05n

.meas tran vdout1_14ck650 FIND v(dout1_14) AT=660.05n

.meas tran vdout1_15ck650 FIND v(dout1_15) AT=660.05n

.meas tran vdout1_16ck650 FIND v(dout1_16) AT=660.05n

.meas tran vdout1_17ck650 FIND v(dout1_17) AT=660.05n

.meas tran vdout1_18ck650 FIND v(dout1_18) AT=660.05n

.meas tran vdout1_19ck650 FIND v(dout1_19) AT=660.05n

.meas tran vdout1_20ck650 FIND v(dout1_20) AT=660.05n

.meas tran vdout1_21ck650 FIND v(dout1_21) AT=660.05n

.meas tran vdout1_22ck650 FIND v(dout1_22) AT=660.05n

.meas tran vdout1_23ck650 FIND v(dout1_23) AT=660.05n

.meas tran vdout1_24ck650 FIND v(dout1_24) AT=660.05n

.meas tran vdout1_25ck650 FIND v(dout1_25) AT=660.05n

.meas tran vdout1_26ck650 FIND v(dout1_26) AT=660.05n

.meas tran vdout1_27ck650 FIND v(dout1_27) AT=660.05n

.meas tran vdout1_28ck650 FIND v(dout1_28) AT=660.05n

.meas tran vdout1_29ck650 FIND v(dout1_29) AT=660.05n

.meas tran vdout1_30ck650 FIND v(dout1_30) AT=660.05n

.meas tran vdout1_31ck650 FIND v(dout1_31) AT=660.05n

.meas tran vdout1_0ck660 FIND v(dout1_0) AT=670.05n

.meas tran vdout1_1ck660 FIND v(dout1_1) AT=670.05n

.meas tran vdout1_2ck660 FIND v(dout1_2) AT=670.05n

.meas tran vdout1_3ck660 FIND v(dout1_3) AT=670.05n

.meas tran vdout1_4ck660 FIND v(dout1_4) AT=670.05n

.meas tran vdout1_5ck660 FIND v(dout1_5) AT=670.05n

.meas tran vdout1_6ck660 FIND v(dout1_6) AT=670.05n

.meas tran vdout1_7ck660 FIND v(dout1_7) AT=670.05n

.meas tran vdout1_8ck660 FIND v(dout1_8) AT=670.05n

.meas tran vdout1_9ck660 FIND v(dout1_9) AT=670.05n

.meas tran vdout1_10ck660 FIND v(dout1_10) AT=670.05n

.meas tran vdout1_11ck660 FIND v(dout1_11) AT=670.05n

.meas tran vdout1_12ck660 FIND v(dout1_12) AT=670.05n

.meas tran vdout1_13ck660 FIND v(dout1_13) AT=670.05n

.meas tran vdout1_14ck660 FIND v(dout1_14) AT=670.05n

.meas tran vdout1_15ck660 FIND v(dout1_15) AT=670.05n

.meas tran vdout1_16ck660 FIND v(dout1_16) AT=670.05n

.meas tran vdout1_17ck660 FIND v(dout1_17) AT=670.05n

.meas tran vdout1_18ck660 FIND v(dout1_18) AT=670.05n

.meas tran vdout1_19ck660 FIND v(dout1_19) AT=670.05n

.meas tran vdout1_20ck660 FIND v(dout1_20) AT=670.05n

.meas tran vdout1_21ck660 FIND v(dout1_21) AT=670.05n

.meas tran vdout1_22ck660 FIND v(dout1_22) AT=670.05n

.meas tran vdout1_23ck660 FIND v(dout1_23) AT=670.05n

.meas tran vdout1_24ck660 FIND v(dout1_24) AT=670.05n

.meas tran vdout1_25ck660 FIND v(dout1_25) AT=670.05n

.meas tran vdout1_26ck660 FIND v(dout1_26) AT=670.05n

.meas tran vdout1_27ck660 FIND v(dout1_27) AT=670.05n

.meas tran vdout1_28ck660 FIND v(dout1_28) AT=670.05n

.meas tran vdout1_29ck660 FIND v(dout1_29) AT=670.05n

.meas tran vdout1_30ck660 FIND v(dout1_30) AT=670.05n

.meas tran vdout1_31ck660 FIND v(dout1_31) AT=670.05n

.meas tran vdout1_0ck680 FIND v(dout1_0) AT=690.05n

.meas tran vdout1_1ck680 FIND v(dout1_1) AT=690.05n

.meas tran vdout1_2ck680 FIND v(dout1_2) AT=690.05n

.meas tran vdout1_3ck680 FIND v(dout1_3) AT=690.05n

.meas tran vdout1_4ck680 FIND v(dout1_4) AT=690.05n

.meas tran vdout1_5ck680 FIND v(dout1_5) AT=690.05n

.meas tran vdout1_6ck680 FIND v(dout1_6) AT=690.05n

.meas tran vdout1_7ck680 FIND v(dout1_7) AT=690.05n

.meas tran vdout1_8ck680 FIND v(dout1_8) AT=690.05n

.meas tran vdout1_9ck680 FIND v(dout1_9) AT=690.05n

.meas tran vdout1_10ck680 FIND v(dout1_10) AT=690.05n

.meas tran vdout1_11ck680 FIND v(dout1_11) AT=690.05n

.meas tran vdout1_12ck680 FIND v(dout1_12) AT=690.05n

.meas tran vdout1_13ck680 FIND v(dout1_13) AT=690.05n

.meas tran vdout1_14ck680 FIND v(dout1_14) AT=690.05n

.meas tran vdout1_15ck680 FIND v(dout1_15) AT=690.05n

.meas tran vdout1_16ck680 FIND v(dout1_16) AT=690.05n

.meas tran vdout1_17ck680 FIND v(dout1_17) AT=690.05n

.meas tran vdout1_18ck680 FIND v(dout1_18) AT=690.05n

.meas tran vdout1_19ck680 FIND v(dout1_19) AT=690.05n

.meas tran vdout1_20ck680 FIND v(dout1_20) AT=690.05n

.meas tran vdout1_21ck680 FIND v(dout1_21) AT=690.05n

.meas tran vdout1_22ck680 FIND v(dout1_22) AT=690.05n

.meas tran vdout1_23ck680 FIND v(dout1_23) AT=690.05n

.meas tran vdout1_24ck680 FIND v(dout1_24) AT=690.05n

.meas tran vdout1_25ck680 FIND v(dout1_25) AT=690.05n

.meas tran vdout1_26ck680 FIND v(dout1_26) AT=690.05n

.meas tran vdout1_27ck680 FIND v(dout1_27) AT=690.05n

.meas tran vdout1_28ck680 FIND v(dout1_28) AT=690.05n

.meas tran vdout1_29ck680 FIND v(dout1_29) AT=690.05n

.meas tran vdout1_30ck680 FIND v(dout1_30) AT=690.05n

.meas tran vdout1_31ck680 FIND v(dout1_31) AT=690.05n

.meas tran vdout1_0ck700 FIND v(dout1_0) AT=710.05n

.meas tran vdout1_1ck700 FIND v(dout1_1) AT=710.05n

.meas tran vdout1_2ck700 FIND v(dout1_2) AT=710.05n

.meas tran vdout1_3ck700 FIND v(dout1_3) AT=710.05n

.meas tran vdout1_4ck700 FIND v(dout1_4) AT=710.05n

.meas tran vdout1_5ck700 FIND v(dout1_5) AT=710.05n

.meas tran vdout1_6ck700 FIND v(dout1_6) AT=710.05n

.meas tran vdout1_7ck700 FIND v(dout1_7) AT=710.05n

.meas tran vdout1_8ck700 FIND v(dout1_8) AT=710.05n

.meas tran vdout1_9ck700 FIND v(dout1_9) AT=710.05n

.meas tran vdout1_10ck700 FIND v(dout1_10) AT=710.05n

.meas tran vdout1_11ck700 FIND v(dout1_11) AT=710.05n

.meas tran vdout1_12ck700 FIND v(dout1_12) AT=710.05n

.meas tran vdout1_13ck700 FIND v(dout1_13) AT=710.05n

.meas tran vdout1_14ck700 FIND v(dout1_14) AT=710.05n

.meas tran vdout1_15ck700 FIND v(dout1_15) AT=710.05n

.meas tran vdout1_16ck700 FIND v(dout1_16) AT=710.05n

.meas tran vdout1_17ck700 FIND v(dout1_17) AT=710.05n

.meas tran vdout1_18ck700 FIND v(dout1_18) AT=710.05n

.meas tran vdout1_19ck700 FIND v(dout1_19) AT=710.05n

.meas tran vdout1_20ck700 FIND v(dout1_20) AT=710.05n

.meas tran vdout1_21ck700 FIND v(dout1_21) AT=710.05n

.meas tran vdout1_22ck700 FIND v(dout1_22) AT=710.05n

.meas tran vdout1_23ck700 FIND v(dout1_23) AT=710.05n

.meas tran vdout1_24ck700 FIND v(dout1_24) AT=710.05n

.meas tran vdout1_25ck700 FIND v(dout1_25) AT=710.05n

.meas tran vdout1_26ck700 FIND v(dout1_26) AT=710.05n

.meas tran vdout1_27ck700 FIND v(dout1_27) AT=710.05n

.meas tran vdout1_28ck700 FIND v(dout1_28) AT=710.05n

.meas tran vdout1_29ck700 FIND v(dout1_29) AT=710.05n

.meas tran vdout1_30ck700 FIND v(dout1_30) AT=710.05n

.meas tran vdout1_31ck700 FIND v(dout1_31) AT=710.05n

.meas tran vdout0_0ck730 FIND v(dout0_0) AT=740.05n

.meas tran vdout0_1ck730 FIND v(dout0_1) AT=740.05n

.meas tran vdout0_2ck730 FIND v(dout0_2) AT=740.05n

.meas tran vdout0_3ck730 FIND v(dout0_3) AT=740.05n

.meas tran vdout0_4ck730 FIND v(dout0_4) AT=740.05n

.meas tran vdout0_5ck730 FIND v(dout0_5) AT=740.05n

.meas tran vdout0_6ck730 FIND v(dout0_6) AT=740.05n

.meas tran vdout0_7ck730 FIND v(dout0_7) AT=740.05n

.meas tran vdout0_8ck730 FIND v(dout0_8) AT=740.05n

.meas tran vdout0_9ck730 FIND v(dout0_9) AT=740.05n

.meas tran vdout0_10ck730 FIND v(dout0_10) AT=740.05n

.meas tran vdout0_11ck730 FIND v(dout0_11) AT=740.05n

.meas tran vdout0_12ck730 FIND v(dout0_12) AT=740.05n

.meas tran vdout0_13ck730 FIND v(dout0_13) AT=740.05n

.meas tran vdout0_14ck730 FIND v(dout0_14) AT=740.05n

.meas tran vdout0_15ck730 FIND v(dout0_15) AT=740.05n

.meas tran vdout0_16ck730 FIND v(dout0_16) AT=740.05n

.meas tran vdout0_17ck730 FIND v(dout0_17) AT=740.05n

.meas tran vdout0_18ck730 FIND v(dout0_18) AT=740.05n

.meas tran vdout0_19ck730 FIND v(dout0_19) AT=740.05n

.meas tran vdout0_20ck730 FIND v(dout0_20) AT=740.05n

.meas tran vdout0_21ck730 FIND v(dout0_21) AT=740.05n

.meas tran vdout0_22ck730 FIND v(dout0_22) AT=740.05n

.meas tran vdout0_23ck730 FIND v(dout0_23) AT=740.05n

.meas tran vdout0_24ck730 FIND v(dout0_24) AT=740.05n

.meas tran vdout0_25ck730 FIND v(dout0_25) AT=740.05n

.meas tran vdout0_26ck730 FIND v(dout0_26) AT=740.05n

.meas tran vdout0_27ck730 FIND v(dout0_27) AT=740.05n

.meas tran vdout0_28ck730 FIND v(dout0_28) AT=740.05n

.meas tran vdout0_29ck730 FIND v(dout0_29) AT=740.05n

.meas tran vdout0_30ck730 FIND v(dout0_30) AT=740.05n

.meas tran vdout0_31ck730 FIND v(dout0_31) AT=740.05n

.meas tran vdout0_0ck740 FIND v(dout0_0) AT=750.05n

.meas tran vdout0_1ck740 FIND v(dout0_1) AT=750.05n

.meas tran vdout0_2ck740 FIND v(dout0_2) AT=750.05n

.meas tran vdout0_3ck740 FIND v(dout0_3) AT=750.05n

.meas tran vdout0_4ck740 FIND v(dout0_4) AT=750.05n

.meas tran vdout0_5ck740 FIND v(dout0_5) AT=750.05n

.meas tran vdout0_6ck740 FIND v(dout0_6) AT=750.05n

.meas tran vdout0_7ck740 FIND v(dout0_7) AT=750.05n

.meas tran vdout0_8ck740 FIND v(dout0_8) AT=750.05n

.meas tran vdout0_9ck740 FIND v(dout0_9) AT=750.05n

.meas tran vdout0_10ck740 FIND v(dout0_10) AT=750.05n

.meas tran vdout0_11ck740 FIND v(dout0_11) AT=750.05n

.meas tran vdout0_12ck740 FIND v(dout0_12) AT=750.05n

.meas tran vdout0_13ck740 FIND v(dout0_13) AT=750.05n

.meas tran vdout0_14ck740 FIND v(dout0_14) AT=750.05n

.meas tran vdout0_15ck740 FIND v(dout0_15) AT=750.05n

.meas tran vdout0_16ck740 FIND v(dout0_16) AT=750.05n

.meas tran vdout0_17ck740 FIND v(dout0_17) AT=750.05n

.meas tran vdout0_18ck740 FIND v(dout0_18) AT=750.05n

.meas tran vdout0_19ck740 FIND v(dout0_19) AT=750.05n

.meas tran vdout0_20ck740 FIND v(dout0_20) AT=750.05n

.meas tran vdout0_21ck740 FIND v(dout0_21) AT=750.05n

.meas tran vdout0_22ck740 FIND v(dout0_22) AT=750.05n

.meas tran vdout0_23ck740 FIND v(dout0_23) AT=750.05n

.meas tran vdout0_24ck740 FIND v(dout0_24) AT=750.05n

.meas tran vdout0_25ck740 FIND v(dout0_25) AT=750.05n

.meas tran vdout0_26ck740 FIND v(dout0_26) AT=750.05n

.meas tran vdout0_27ck740 FIND v(dout0_27) AT=750.05n

.meas tran vdout0_28ck740 FIND v(dout0_28) AT=750.05n

.meas tran vdout0_29ck740 FIND v(dout0_29) AT=750.05n

.meas tran vdout0_30ck740 FIND v(dout0_30) AT=750.05n

.meas tran vdout0_31ck740 FIND v(dout0_31) AT=750.05n

.meas tran vdout0_0ck750 FIND v(dout0_0) AT=760.05n

.meas tran vdout0_1ck750 FIND v(dout0_1) AT=760.05n

.meas tran vdout0_2ck750 FIND v(dout0_2) AT=760.05n

.meas tran vdout0_3ck750 FIND v(dout0_3) AT=760.05n

.meas tran vdout0_4ck750 FIND v(dout0_4) AT=760.05n

.meas tran vdout0_5ck750 FIND v(dout0_5) AT=760.05n

.meas tran vdout0_6ck750 FIND v(dout0_6) AT=760.05n

.meas tran vdout0_7ck750 FIND v(dout0_7) AT=760.05n

.meas tran vdout0_8ck750 FIND v(dout0_8) AT=760.05n

.meas tran vdout0_9ck750 FIND v(dout0_9) AT=760.05n

.meas tran vdout0_10ck750 FIND v(dout0_10) AT=760.05n

.meas tran vdout0_11ck750 FIND v(dout0_11) AT=760.05n

.meas tran vdout0_12ck750 FIND v(dout0_12) AT=760.05n

.meas tran vdout0_13ck750 FIND v(dout0_13) AT=760.05n

.meas tran vdout0_14ck750 FIND v(dout0_14) AT=760.05n

.meas tran vdout0_15ck750 FIND v(dout0_15) AT=760.05n

.meas tran vdout0_16ck750 FIND v(dout0_16) AT=760.05n

.meas tran vdout0_17ck750 FIND v(dout0_17) AT=760.05n

.meas tran vdout0_18ck750 FIND v(dout0_18) AT=760.05n

.meas tran vdout0_19ck750 FIND v(dout0_19) AT=760.05n

.meas tran vdout0_20ck750 FIND v(dout0_20) AT=760.05n

.meas tran vdout0_21ck750 FIND v(dout0_21) AT=760.05n

.meas tran vdout0_22ck750 FIND v(dout0_22) AT=760.05n

.meas tran vdout0_23ck750 FIND v(dout0_23) AT=760.05n

.meas tran vdout0_24ck750 FIND v(dout0_24) AT=760.05n

.meas tran vdout0_25ck750 FIND v(dout0_25) AT=760.05n

.meas tran vdout0_26ck750 FIND v(dout0_26) AT=760.05n

.meas tran vdout0_27ck750 FIND v(dout0_27) AT=760.05n

.meas tran vdout0_28ck750 FIND v(dout0_28) AT=760.05n

.meas tran vdout0_29ck750 FIND v(dout0_29) AT=760.05n

.meas tran vdout0_30ck750 FIND v(dout0_30) AT=760.05n

.meas tran vdout0_31ck750 FIND v(dout0_31) AT=760.05n

.meas tran vdout1_0ck750 FIND v(dout1_0) AT=760.05n

.meas tran vdout1_1ck750 FIND v(dout1_1) AT=760.05n

.meas tran vdout1_2ck750 FIND v(dout1_2) AT=760.05n

.meas tran vdout1_3ck750 FIND v(dout1_3) AT=760.05n

.meas tran vdout1_4ck750 FIND v(dout1_4) AT=760.05n

.meas tran vdout1_5ck750 FIND v(dout1_5) AT=760.05n

.meas tran vdout1_6ck750 FIND v(dout1_6) AT=760.05n

.meas tran vdout1_7ck750 FIND v(dout1_7) AT=760.05n

.meas tran vdout1_8ck750 FIND v(dout1_8) AT=760.05n

.meas tran vdout1_9ck750 FIND v(dout1_9) AT=760.05n

.meas tran vdout1_10ck750 FIND v(dout1_10) AT=760.05n

.meas tran vdout1_11ck750 FIND v(dout1_11) AT=760.05n

.meas tran vdout1_12ck750 FIND v(dout1_12) AT=760.05n

.meas tran vdout1_13ck750 FIND v(dout1_13) AT=760.05n

.meas tran vdout1_14ck750 FIND v(dout1_14) AT=760.05n

.meas tran vdout1_15ck750 FIND v(dout1_15) AT=760.05n

.meas tran vdout1_16ck750 FIND v(dout1_16) AT=760.05n

.meas tran vdout1_17ck750 FIND v(dout1_17) AT=760.05n

.meas tran vdout1_18ck750 FIND v(dout1_18) AT=760.05n

.meas tran vdout1_19ck750 FIND v(dout1_19) AT=760.05n

.meas tran vdout1_20ck750 FIND v(dout1_20) AT=760.05n

.meas tran vdout1_21ck750 FIND v(dout1_21) AT=760.05n

.meas tran vdout1_22ck750 FIND v(dout1_22) AT=760.05n

.meas tran vdout1_23ck750 FIND v(dout1_23) AT=760.05n

.meas tran vdout1_24ck750 FIND v(dout1_24) AT=760.05n

.meas tran vdout1_25ck750 FIND v(dout1_25) AT=760.05n

.meas tran vdout1_26ck750 FIND v(dout1_26) AT=760.05n

.meas tran vdout1_27ck750 FIND v(dout1_27) AT=760.05n

.meas tran vdout1_28ck750 FIND v(dout1_28) AT=760.05n

.meas tran vdout1_29ck750 FIND v(dout1_29) AT=760.05n

.meas tran vdout1_30ck750 FIND v(dout1_30) AT=760.05n

.meas tran vdout1_31ck750 FIND v(dout1_31) AT=760.05n

.meas tran vdout0_0ck760 FIND v(dout0_0) AT=770.05n

.meas tran vdout0_1ck760 FIND v(dout0_1) AT=770.05n

.meas tran vdout0_2ck760 FIND v(dout0_2) AT=770.05n

.meas tran vdout0_3ck760 FIND v(dout0_3) AT=770.05n

.meas tran vdout0_4ck760 FIND v(dout0_4) AT=770.05n

.meas tran vdout0_5ck760 FIND v(dout0_5) AT=770.05n

.meas tran vdout0_6ck760 FIND v(dout0_6) AT=770.05n

.meas tran vdout0_7ck760 FIND v(dout0_7) AT=770.05n

.meas tran vdout0_8ck760 FIND v(dout0_8) AT=770.05n

.meas tran vdout0_9ck760 FIND v(dout0_9) AT=770.05n

.meas tran vdout0_10ck760 FIND v(dout0_10) AT=770.05n

.meas tran vdout0_11ck760 FIND v(dout0_11) AT=770.05n

.meas tran vdout0_12ck760 FIND v(dout0_12) AT=770.05n

.meas tran vdout0_13ck760 FIND v(dout0_13) AT=770.05n

.meas tran vdout0_14ck760 FIND v(dout0_14) AT=770.05n

.meas tran vdout0_15ck760 FIND v(dout0_15) AT=770.05n

.meas tran vdout0_16ck760 FIND v(dout0_16) AT=770.05n

.meas tran vdout0_17ck760 FIND v(dout0_17) AT=770.05n

.meas tran vdout0_18ck760 FIND v(dout0_18) AT=770.05n

.meas tran vdout0_19ck760 FIND v(dout0_19) AT=770.05n

.meas tran vdout0_20ck760 FIND v(dout0_20) AT=770.05n

.meas tran vdout0_21ck760 FIND v(dout0_21) AT=770.05n

.meas tran vdout0_22ck760 FIND v(dout0_22) AT=770.05n

.meas tran vdout0_23ck760 FIND v(dout0_23) AT=770.05n

.meas tran vdout0_24ck760 FIND v(dout0_24) AT=770.05n

.meas tran vdout0_25ck760 FIND v(dout0_25) AT=770.05n

.meas tran vdout0_26ck760 FIND v(dout0_26) AT=770.05n

.meas tran vdout0_27ck760 FIND v(dout0_27) AT=770.05n

.meas tran vdout0_28ck760 FIND v(dout0_28) AT=770.05n

.meas tran vdout0_29ck760 FIND v(dout0_29) AT=770.05n

.meas tran vdout0_30ck760 FIND v(dout0_30) AT=770.05n

.meas tran vdout0_31ck760 FIND v(dout0_31) AT=770.05n

.meas tran vdout1_0ck760 FIND v(dout1_0) AT=770.05n

.meas tran vdout1_1ck760 FIND v(dout1_1) AT=770.05n

.meas tran vdout1_2ck760 FIND v(dout1_2) AT=770.05n

.meas tran vdout1_3ck760 FIND v(dout1_3) AT=770.05n

.meas tran vdout1_4ck760 FIND v(dout1_4) AT=770.05n

.meas tran vdout1_5ck760 FIND v(dout1_5) AT=770.05n

.meas tran vdout1_6ck760 FIND v(dout1_6) AT=770.05n

.meas tran vdout1_7ck760 FIND v(dout1_7) AT=770.05n

.meas tran vdout1_8ck760 FIND v(dout1_8) AT=770.05n

.meas tran vdout1_9ck760 FIND v(dout1_9) AT=770.05n

.meas tran vdout1_10ck760 FIND v(dout1_10) AT=770.05n

.meas tran vdout1_11ck760 FIND v(dout1_11) AT=770.05n

.meas tran vdout1_12ck760 FIND v(dout1_12) AT=770.05n

.meas tran vdout1_13ck760 FIND v(dout1_13) AT=770.05n

.meas tran vdout1_14ck760 FIND v(dout1_14) AT=770.05n

.meas tran vdout1_15ck760 FIND v(dout1_15) AT=770.05n

.meas tran vdout1_16ck760 FIND v(dout1_16) AT=770.05n

.meas tran vdout1_17ck760 FIND v(dout1_17) AT=770.05n

.meas tran vdout1_18ck760 FIND v(dout1_18) AT=770.05n

.meas tran vdout1_19ck760 FIND v(dout1_19) AT=770.05n

.meas tran vdout1_20ck760 FIND v(dout1_20) AT=770.05n

.meas tran vdout1_21ck760 FIND v(dout1_21) AT=770.05n

.meas tran vdout1_22ck760 FIND v(dout1_22) AT=770.05n

.meas tran vdout1_23ck760 FIND v(dout1_23) AT=770.05n

.meas tran vdout1_24ck760 FIND v(dout1_24) AT=770.05n

.meas tran vdout1_25ck760 FIND v(dout1_25) AT=770.05n

.meas tran vdout1_26ck760 FIND v(dout1_26) AT=770.05n

.meas tran vdout1_27ck760 FIND v(dout1_27) AT=770.05n

.meas tran vdout1_28ck760 FIND v(dout1_28) AT=770.05n

.meas tran vdout1_29ck760 FIND v(dout1_29) AT=770.05n

.meas tran vdout1_30ck760 FIND v(dout1_30) AT=770.05n

.meas tran vdout1_31ck760 FIND v(dout1_31) AT=770.05n

.meas tran vdout1_0ck780 FIND v(dout1_0) AT=790.05n

.meas tran vdout1_1ck780 FIND v(dout1_1) AT=790.05n

.meas tran vdout1_2ck780 FIND v(dout1_2) AT=790.05n

.meas tran vdout1_3ck780 FIND v(dout1_3) AT=790.05n

.meas tran vdout1_4ck780 FIND v(dout1_4) AT=790.05n

.meas tran vdout1_5ck780 FIND v(dout1_5) AT=790.05n

.meas tran vdout1_6ck780 FIND v(dout1_6) AT=790.05n

.meas tran vdout1_7ck780 FIND v(dout1_7) AT=790.05n

.meas tran vdout1_8ck780 FIND v(dout1_8) AT=790.05n

.meas tran vdout1_9ck780 FIND v(dout1_9) AT=790.05n

.meas tran vdout1_10ck780 FIND v(dout1_10) AT=790.05n

.meas tran vdout1_11ck780 FIND v(dout1_11) AT=790.05n

.meas tran vdout1_12ck780 FIND v(dout1_12) AT=790.05n

.meas tran vdout1_13ck780 FIND v(dout1_13) AT=790.05n

.meas tran vdout1_14ck780 FIND v(dout1_14) AT=790.05n

.meas tran vdout1_15ck780 FIND v(dout1_15) AT=790.05n

.meas tran vdout1_16ck780 FIND v(dout1_16) AT=790.05n

.meas tran vdout1_17ck780 FIND v(dout1_17) AT=790.05n

.meas tran vdout1_18ck780 FIND v(dout1_18) AT=790.05n

.meas tran vdout1_19ck780 FIND v(dout1_19) AT=790.05n

.meas tran vdout1_20ck780 FIND v(dout1_20) AT=790.05n

.meas tran vdout1_21ck780 FIND v(dout1_21) AT=790.05n

.meas tran vdout1_22ck780 FIND v(dout1_22) AT=790.05n

.meas tran vdout1_23ck780 FIND v(dout1_23) AT=790.05n

.meas tran vdout1_24ck780 FIND v(dout1_24) AT=790.05n

.meas tran vdout1_25ck780 FIND v(dout1_25) AT=790.05n

.meas tran vdout1_26ck780 FIND v(dout1_26) AT=790.05n

.meas tran vdout1_27ck780 FIND v(dout1_27) AT=790.05n

.meas tran vdout1_28ck780 FIND v(dout1_28) AT=790.05n

.meas tran vdout1_29ck780 FIND v(dout1_29) AT=790.05n

.meas tran vdout1_30ck780 FIND v(dout1_30) AT=790.05n

.meas tran vdout1_31ck780 FIND v(dout1_31) AT=790.05n

.meas tran vdout1_0ck800 FIND v(dout1_0) AT=810.05n

.meas tran vdout1_1ck800 FIND v(dout1_1) AT=810.05n

.meas tran vdout1_2ck800 FIND v(dout1_2) AT=810.05n

.meas tran vdout1_3ck800 FIND v(dout1_3) AT=810.05n

.meas tran vdout1_4ck800 FIND v(dout1_4) AT=810.05n

.meas tran vdout1_5ck800 FIND v(dout1_5) AT=810.05n

.meas tran vdout1_6ck800 FIND v(dout1_6) AT=810.05n

.meas tran vdout1_7ck800 FIND v(dout1_7) AT=810.05n

.meas tran vdout1_8ck800 FIND v(dout1_8) AT=810.05n

.meas tran vdout1_9ck800 FIND v(dout1_9) AT=810.05n

.meas tran vdout1_10ck800 FIND v(dout1_10) AT=810.05n

.meas tran vdout1_11ck800 FIND v(dout1_11) AT=810.05n

.meas tran vdout1_12ck800 FIND v(dout1_12) AT=810.05n

.meas tran vdout1_13ck800 FIND v(dout1_13) AT=810.05n

.meas tran vdout1_14ck800 FIND v(dout1_14) AT=810.05n

.meas tran vdout1_15ck800 FIND v(dout1_15) AT=810.05n

.meas tran vdout1_16ck800 FIND v(dout1_16) AT=810.05n

.meas tran vdout1_17ck800 FIND v(dout1_17) AT=810.05n

.meas tran vdout1_18ck800 FIND v(dout1_18) AT=810.05n

.meas tran vdout1_19ck800 FIND v(dout1_19) AT=810.05n

.meas tran vdout1_20ck800 FIND v(dout1_20) AT=810.05n

.meas tran vdout1_21ck800 FIND v(dout1_21) AT=810.05n

.meas tran vdout1_22ck800 FIND v(dout1_22) AT=810.05n

.meas tran vdout1_23ck800 FIND v(dout1_23) AT=810.05n

.meas tran vdout1_24ck800 FIND v(dout1_24) AT=810.05n

.meas tran vdout1_25ck800 FIND v(dout1_25) AT=810.05n

.meas tran vdout1_26ck800 FIND v(dout1_26) AT=810.05n

.meas tran vdout1_27ck800 FIND v(dout1_27) AT=810.05n

.meas tran vdout1_28ck800 FIND v(dout1_28) AT=810.05n

.meas tran vdout1_29ck800 FIND v(dout1_29) AT=810.05n

.meas tran vdout1_30ck800 FIND v(dout1_30) AT=810.05n

.meas tran vdout1_31ck800 FIND v(dout1_31) AT=810.05n

.meas tran vdout0_0ck810 FIND v(dout0_0) AT=820.05n

.meas tran vdout0_1ck810 FIND v(dout0_1) AT=820.05n

.meas tran vdout0_2ck810 FIND v(dout0_2) AT=820.05n

.meas tran vdout0_3ck810 FIND v(dout0_3) AT=820.05n

.meas tran vdout0_4ck810 FIND v(dout0_4) AT=820.05n

.meas tran vdout0_5ck810 FIND v(dout0_5) AT=820.05n

.meas tran vdout0_6ck810 FIND v(dout0_6) AT=820.05n

.meas tran vdout0_7ck810 FIND v(dout0_7) AT=820.05n

.meas tran vdout0_8ck810 FIND v(dout0_8) AT=820.05n

.meas tran vdout0_9ck810 FIND v(dout0_9) AT=820.05n

.meas tran vdout0_10ck810 FIND v(dout0_10) AT=820.05n

.meas tran vdout0_11ck810 FIND v(dout0_11) AT=820.05n

.meas tran vdout0_12ck810 FIND v(dout0_12) AT=820.05n

.meas tran vdout0_13ck810 FIND v(dout0_13) AT=820.05n

.meas tran vdout0_14ck810 FIND v(dout0_14) AT=820.05n

.meas tran vdout0_15ck810 FIND v(dout0_15) AT=820.05n

.meas tran vdout0_16ck810 FIND v(dout0_16) AT=820.05n

.meas tran vdout0_17ck810 FIND v(dout0_17) AT=820.05n

.meas tran vdout0_18ck810 FIND v(dout0_18) AT=820.05n

.meas tran vdout0_19ck810 FIND v(dout0_19) AT=820.05n

.meas tran vdout0_20ck810 FIND v(dout0_20) AT=820.05n

.meas tran vdout0_21ck810 FIND v(dout0_21) AT=820.05n

.meas tran vdout0_22ck810 FIND v(dout0_22) AT=820.05n

.meas tran vdout0_23ck810 FIND v(dout0_23) AT=820.05n

.meas tran vdout0_24ck810 FIND v(dout0_24) AT=820.05n

.meas tran vdout0_25ck810 FIND v(dout0_25) AT=820.05n

.meas tran vdout0_26ck810 FIND v(dout0_26) AT=820.05n

.meas tran vdout0_27ck810 FIND v(dout0_27) AT=820.05n

.meas tran vdout0_28ck810 FIND v(dout0_28) AT=820.05n

.meas tran vdout0_29ck810 FIND v(dout0_29) AT=820.05n

.meas tran vdout0_30ck810 FIND v(dout0_30) AT=820.05n

.meas tran vdout0_31ck810 FIND v(dout0_31) AT=820.05n

.meas tran vdout1_0ck810 FIND v(dout1_0) AT=820.05n

.meas tran vdout1_1ck810 FIND v(dout1_1) AT=820.05n

.meas tran vdout1_2ck810 FIND v(dout1_2) AT=820.05n

.meas tran vdout1_3ck810 FIND v(dout1_3) AT=820.05n

.meas tran vdout1_4ck810 FIND v(dout1_4) AT=820.05n

.meas tran vdout1_5ck810 FIND v(dout1_5) AT=820.05n

.meas tran vdout1_6ck810 FIND v(dout1_6) AT=820.05n

.meas tran vdout1_7ck810 FIND v(dout1_7) AT=820.05n

.meas tran vdout1_8ck810 FIND v(dout1_8) AT=820.05n

.meas tran vdout1_9ck810 FIND v(dout1_9) AT=820.05n

.meas tran vdout1_10ck810 FIND v(dout1_10) AT=820.05n

.meas tran vdout1_11ck810 FIND v(dout1_11) AT=820.05n

.meas tran vdout1_12ck810 FIND v(dout1_12) AT=820.05n

.meas tran vdout1_13ck810 FIND v(dout1_13) AT=820.05n

.meas tran vdout1_14ck810 FIND v(dout1_14) AT=820.05n

.meas tran vdout1_15ck810 FIND v(dout1_15) AT=820.05n

.meas tran vdout1_16ck810 FIND v(dout1_16) AT=820.05n

.meas tran vdout1_17ck810 FIND v(dout1_17) AT=820.05n

.meas tran vdout1_18ck810 FIND v(dout1_18) AT=820.05n

.meas tran vdout1_19ck810 FIND v(dout1_19) AT=820.05n

.meas tran vdout1_20ck810 FIND v(dout1_20) AT=820.05n

.meas tran vdout1_21ck810 FIND v(dout1_21) AT=820.05n

.meas tran vdout1_22ck810 FIND v(dout1_22) AT=820.05n

.meas tran vdout1_23ck810 FIND v(dout1_23) AT=820.05n

.meas tran vdout1_24ck810 FIND v(dout1_24) AT=820.05n

.meas tran vdout1_25ck810 FIND v(dout1_25) AT=820.05n

.meas tran vdout1_26ck810 FIND v(dout1_26) AT=820.05n

.meas tran vdout1_27ck810 FIND v(dout1_27) AT=820.05n

.meas tran vdout1_28ck810 FIND v(dout1_28) AT=820.05n

.meas tran vdout1_29ck810 FIND v(dout1_29) AT=820.05n

.meas tran vdout1_30ck810 FIND v(dout1_30) AT=820.05n

.meas tran vdout1_31ck810 FIND v(dout1_31) AT=820.05n

.meas tran vdout1_0ck820 FIND v(dout1_0) AT=830.05n

.meas tran vdout1_1ck820 FIND v(dout1_1) AT=830.05n

.meas tran vdout1_2ck820 FIND v(dout1_2) AT=830.05n

.meas tran vdout1_3ck820 FIND v(dout1_3) AT=830.05n

.meas tran vdout1_4ck820 FIND v(dout1_4) AT=830.05n

.meas tran vdout1_5ck820 FIND v(dout1_5) AT=830.05n

.meas tran vdout1_6ck820 FIND v(dout1_6) AT=830.05n

.meas tran vdout1_7ck820 FIND v(dout1_7) AT=830.05n

.meas tran vdout1_8ck820 FIND v(dout1_8) AT=830.05n

.meas tran vdout1_9ck820 FIND v(dout1_9) AT=830.05n

.meas tran vdout1_10ck820 FIND v(dout1_10) AT=830.05n

.meas tran vdout1_11ck820 FIND v(dout1_11) AT=830.05n

.meas tran vdout1_12ck820 FIND v(dout1_12) AT=830.05n

.meas tran vdout1_13ck820 FIND v(dout1_13) AT=830.05n

.meas tran vdout1_14ck820 FIND v(dout1_14) AT=830.05n

.meas tran vdout1_15ck820 FIND v(dout1_15) AT=830.05n

.meas tran vdout1_16ck820 FIND v(dout1_16) AT=830.05n

.meas tran vdout1_17ck820 FIND v(dout1_17) AT=830.05n

.meas tran vdout1_18ck820 FIND v(dout1_18) AT=830.05n

.meas tran vdout1_19ck820 FIND v(dout1_19) AT=830.05n

.meas tran vdout1_20ck820 FIND v(dout1_20) AT=830.05n

.meas tran vdout1_21ck820 FIND v(dout1_21) AT=830.05n

.meas tran vdout1_22ck820 FIND v(dout1_22) AT=830.05n

.meas tran vdout1_23ck820 FIND v(dout1_23) AT=830.05n

.meas tran vdout1_24ck820 FIND v(dout1_24) AT=830.05n

.meas tran vdout1_25ck820 FIND v(dout1_25) AT=830.05n

.meas tran vdout1_26ck820 FIND v(dout1_26) AT=830.05n

.meas tran vdout1_27ck820 FIND v(dout1_27) AT=830.05n

.meas tran vdout1_28ck820 FIND v(dout1_28) AT=830.05n

.meas tran vdout1_29ck820 FIND v(dout1_29) AT=830.05n

.meas tran vdout1_30ck820 FIND v(dout1_30) AT=830.05n

.meas tran vdout1_31ck820 FIND v(dout1_31) AT=830.05n

.meas tran vdout0_0ck830 FIND v(dout0_0) AT=840.05n

.meas tran vdout0_1ck830 FIND v(dout0_1) AT=840.05n

.meas tran vdout0_2ck830 FIND v(dout0_2) AT=840.05n

.meas tran vdout0_3ck830 FIND v(dout0_3) AT=840.05n

.meas tran vdout0_4ck830 FIND v(dout0_4) AT=840.05n

.meas tran vdout0_5ck830 FIND v(dout0_5) AT=840.05n

.meas tran vdout0_6ck830 FIND v(dout0_6) AT=840.05n

.meas tran vdout0_7ck830 FIND v(dout0_7) AT=840.05n

.meas tran vdout0_8ck830 FIND v(dout0_8) AT=840.05n

.meas tran vdout0_9ck830 FIND v(dout0_9) AT=840.05n

.meas tran vdout0_10ck830 FIND v(dout0_10) AT=840.05n

.meas tran vdout0_11ck830 FIND v(dout0_11) AT=840.05n

.meas tran vdout0_12ck830 FIND v(dout0_12) AT=840.05n

.meas tran vdout0_13ck830 FIND v(dout0_13) AT=840.05n

.meas tran vdout0_14ck830 FIND v(dout0_14) AT=840.05n

.meas tran vdout0_15ck830 FIND v(dout0_15) AT=840.05n

.meas tran vdout0_16ck830 FIND v(dout0_16) AT=840.05n

.meas tran vdout0_17ck830 FIND v(dout0_17) AT=840.05n

.meas tran vdout0_18ck830 FIND v(dout0_18) AT=840.05n

.meas tran vdout0_19ck830 FIND v(dout0_19) AT=840.05n

.meas tran vdout0_20ck830 FIND v(dout0_20) AT=840.05n

.meas tran vdout0_21ck830 FIND v(dout0_21) AT=840.05n

.meas tran vdout0_22ck830 FIND v(dout0_22) AT=840.05n

.meas tran vdout0_23ck830 FIND v(dout0_23) AT=840.05n

.meas tran vdout0_24ck830 FIND v(dout0_24) AT=840.05n

.meas tran vdout0_25ck830 FIND v(dout0_25) AT=840.05n

.meas tran vdout0_26ck830 FIND v(dout0_26) AT=840.05n

.meas tran vdout0_27ck830 FIND v(dout0_27) AT=840.05n

.meas tran vdout0_28ck830 FIND v(dout0_28) AT=840.05n

.meas tran vdout0_29ck830 FIND v(dout0_29) AT=840.05n

.meas tran vdout0_30ck830 FIND v(dout0_30) AT=840.05n

.meas tran vdout0_31ck830 FIND v(dout0_31) AT=840.05n

.meas tran vdout1_0ck830 FIND v(dout1_0) AT=840.05n

.meas tran vdout1_1ck830 FIND v(dout1_1) AT=840.05n

.meas tran vdout1_2ck830 FIND v(dout1_2) AT=840.05n

.meas tran vdout1_3ck830 FIND v(dout1_3) AT=840.05n

.meas tran vdout1_4ck830 FIND v(dout1_4) AT=840.05n

.meas tran vdout1_5ck830 FIND v(dout1_5) AT=840.05n

.meas tran vdout1_6ck830 FIND v(dout1_6) AT=840.05n

.meas tran vdout1_7ck830 FIND v(dout1_7) AT=840.05n

.meas tran vdout1_8ck830 FIND v(dout1_8) AT=840.05n

.meas tran vdout1_9ck830 FIND v(dout1_9) AT=840.05n

.meas tran vdout1_10ck830 FIND v(dout1_10) AT=840.05n

.meas tran vdout1_11ck830 FIND v(dout1_11) AT=840.05n

.meas tran vdout1_12ck830 FIND v(dout1_12) AT=840.05n

.meas tran vdout1_13ck830 FIND v(dout1_13) AT=840.05n

.meas tran vdout1_14ck830 FIND v(dout1_14) AT=840.05n

.meas tran vdout1_15ck830 FIND v(dout1_15) AT=840.05n

.meas tran vdout1_16ck830 FIND v(dout1_16) AT=840.05n

.meas tran vdout1_17ck830 FIND v(dout1_17) AT=840.05n

.meas tran vdout1_18ck830 FIND v(dout1_18) AT=840.05n

.meas tran vdout1_19ck830 FIND v(dout1_19) AT=840.05n

.meas tran vdout1_20ck830 FIND v(dout1_20) AT=840.05n

.meas tran vdout1_21ck830 FIND v(dout1_21) AT=840.05n

.meas tran vdout1_22ck830 FIND v(dout1_22) AT=840.05n

.meas tran vdout1_23ck830 FIND v(dout1_23) AT=840.05n

.meas tran vdout1_24ck830 FIND v(dout1_24) AT=840.05n

.meas tran vdout1_25ck830 FIND v(dout1_25) AT=840.05n

.meas tran vdout1_26ck830 FIND v(dout1_26) AT=840.05n

.meas tran vdout1_27ck830 FIND v(dout1_27) AT=840.05n

.meas tran vdout1_28ck830 FIND v(dout1_28) AT=840.05n

.meas tran vdout1_29ck830 FIND v(dout1_29) AT=840.05n

.meas tran vdout1_30ck830 FIND v(dout1_30) AT=840.05n

.meas tran vdout1_31ck830 FIND v(dout1_31) AT=840.05n

.meas tran vdout0_0ck840 FIND v(dout0_0) AT=850.05n

.meas tran vdout0_1ck840 FIND v(dout0_1) AT=850.05n

.meas tran vdout0_2ck840 FIND v(dout0_2) AT=850.05n

.meas tran vdout0_3ck840 FIND v(dout0_3) AT=850.05n

.meas tran vdout0_4ck840 FIND v(dout0_4) AT=850.05n

.meas tran vdout0_5ck840 FIND v(dout0_5) AT=850.05n

.meas tran vdout0_6ck840 FIND v(dout0_6) AT=850.05n

.meas tran vdout0_7ck840 FIND v(dout0_7) AT=850.05n

.meas tran vdout0_8ck840 FIND v(dout0_8) AT=850.05n

.meas tran vdout0_9ck840 FIND v(dout0_9) AT=850.05n

.meas tran vdout0_10ck840 FIND v(dout0_10) AT=850.05n

.meas tran vdout0_11ck840 FIND v(dout0_11) AT=850.05n

.meas tran vdout0_12ck840 FIND v(dout0_12) AT=850.05n

.meas tran vdout0_13ck840 FIND v(dout0_13) AT=850.05n

.meas tran vdout0_14ck840 FIND v(dout0_14) AT=850.05n

.meas tran vdout0_15ck840 FIND v(dout0_15) AT=850.05n

.meas tran vdout0_16ck840 FIND v(dout0_16) AT=850.05n

.meas tran vdout0_17ck840 FIND v(dout0_17) AT=850.05n

.meas tran vdout0_18ck840 FIND v(dout0_18) AT=850.05n

.meas tran vdout0_19ck840 FIND v(dout0_19) AT=850.05n

.meas tran vdout0_20ck840 FIND v(dout0_20) AT=850.05n

.meas tran vdout0_21ck840 FIND v(dout0_21) AT=850.05n

.meas tran vdout0_22ck840 FIND v(dout0_22) AT=850.05n

.meas tran vdout0_23ck840 FIND v(dout0_23) AT=850.05n

.meas tran vdout0_24ck840 FIND v(dout0_24) AT=850.05n

.meas tran vdout0_25ck840 FIND v(dout0_25) AT=850.05n

.meas tran vdout0_26ck840 FIND v(dout0_26) AT=850.05n

.meas tran vdout0_27ck840 FIND v(dout0_27) AT=850.05n

.meas tran vdout0_28ck840 FIND v(dout0_28) AT=850.05n

.meas tran vdout0_29ck840 FIND v(dout0_29) AT=850.05n

.meas tran vdout0_30ck840 FIND v(dout0_30) AT=850.05n

.meas tran vdout0_31ck840 FIND v(dout0_31) AT=850.05n

.meas tran vdout0_0ck850 FIND v(dout0_0) AT=860.05n

.meas tran vdout0_1ck850 FIND v(dout0_1) AT=860.05n

.meas tran vdout0_2ck850 FIND v(dout0_2) AT=860.05n

.meas tran vdout0_3ck850 FIND v(dout0_3) AT=860.05n

.meas tran vdout0_4ck850 FIND v(dout0_4) AT=860.05n

.meas tran vdout0_5ck850 FIND v(dout0_5) AT=860.05n

.meas tran vdout0_6ck850 FIND v(dout0_6) AT=860.05n

.meas tran vdout0_7ck850 FIND v(dout0_7) AT=860.05n

.meas tran vdout0_8ck850 FIND v(dout0_8) AT=860.05n

.meas tran vdout0_9ck850 FIND v(dout0_9) AT=860.05n

.meas tran vdout0_10ck850 FIND v(dout0_10) AT=860.05n

.meas tran vdout0_11ck850 FIND v(dout0_11) AT=860.05n

.meas tran vdout0_12ck850 FIND v(dout0_12) AT=860.05n

.meas tran vdout0_13ck850 FIND v(dout0_13) AT=860.05n

.meas tran vdout0_14ck850 FIND v(dout0_14) AT=860.05n

.meas tran vdout0_15ck850 FIND v(dout0_15) AT=860.05n

.meas tran vdout0_16ck850 FIND v(dout0_16) AT=860.05n

.meas tran vdout0_17ck850 FIND v(dout0_17) AT=860.05n

.meas tran vdout0_18ck850 FIND v(dout0_18) AT=860.05n

.meas tran vdout0_19ck850 FIND v(dout0_19) AT=860.05n

.meas tran vdout0_20ck850 FIND v(dout0_20) AT=860.05n

.meas tran vdout0_21ck850 FIND v(dout0_21) AT=860.05n

.meas tran vdout0_22ck850 FIND v(dout0_22) AT=860.05n

.meas tran vdout0_23ck850 FIND v(dout0_23) AT=860.05n

.meas tran vdout0_24ck850 FIND v(dout0_24) AT=860.05n

.meas tran vdout0_25ck850 FIND v(dout0_25) AT=860.05n

.meas tran vdout0_26ck850 FIND v(dout0_26) AT=860.05n

.meas tran vdout0_27ck850 FIND v(dout0_27) AT=860.05n

.meas tran vdout0_28ck850 FIND v(dout0_28) AT=860.05n

.meas tran vdout0_29ck850 FIND v(dout0_29) AT=860.05n

.meas tran vdout0_30ck850 FIND v(dout0_30) AT=860.05n

.meas tran vdout0_31ck850 FIND v(dout0_31) AT=860.05n

.meas tran vdout0_0ck870 FIND v(dout0_0) AT=880.05n

.meas tran vdout0_1ck870 FIND v(dout0_1) AT=880.05n

.meas tran vdout0_2ck870 FIND v(dout0_2) AT=880.05n

.meas tran vdout0_3ck870 FIND v(dout0_3) AT=880.05n

.meas tran vdout0_4ck870 FIND v(dout0_4) AT=880.05n

.meas tran vdout0_5ck870 FIND v(dout0_5) AT=880.05n

.meas tran vdout0_6ck870 FIND v(dout0_6) AT=880.05n

.meas tran vdout0_7ck870 FIND v(dout0_7) AT=880.05n

.meas tran vdout0_8ck870 FIND v(dout0_8) AT=880.05n

.meas tran vdout0_9ck870 FIND v(dout0_9) AT=880.05n

.meas tran vdout0_10ck870 FIND v(dout0_10) AT=880.05n

.meas tran vdout0_11ck870 FIND v(dout0_11) AT=880.05n

.meas tran vdout0_12ck870 FIND v(dout0_12) AT=880.05n

.meas tran vdout0_13ck870 FIND v(dout0_13) AT=880.05n

.meas tran vdout0_14ck870 FIND v(dout0_14) AT=880.05n

.meas tran vdout0_15ck870 FIND v(dout0_15) AT=880.05n

.meas tran vdout0_16ck870 FIND v(dout0_16) AT=880.05n

.meas tran vdout0_17ck870 FIND v(dout0_17) AT=880.05n

.meas tran vdout0_18ck870 FIND v(dout0_18) AT=880.05n

.meas tran vdout0_19ck870 FIND v(dout0_19) AT=880.05n

.meas tran vdout0_20ck870 FIND v(dout0_20) AT=880.05n

.meas tran vdout0_21ck870 FIND v(dout0_21) AT=880.05n

.meas tran vdout0_22ck870 FIND v(dout0_22) AT=880.05n

.meas tran vdout0_23ck870 FIND v(dout0_23) AT=880.05n

.meas tran vdout0_24ck870 FIND v(dout0_24) AT=880.05n

.meas tran vdout0_25ck870 FIND v(dout0_25) AT=880.05n

.meas tran vdout0_26ck870 FIND v(dout0_26) AT=880.05n

.meas tran vdout0_27ck870 FIND v(dout0_27) AT=880.05n

.meas tran vdout0_28ck870 FIND v(dout0_28) AT=880.05n

.meas tran vdout0_29ck870 FIND v(dout0_29) AT=880.05n

.meas tran vdout0_30ck870 FIND v(dout0_30) AT=880.05n

.meas tran vdout0_31ck870 FIND v(dout0_31) AT=880.05n

.meas tran vdout1_0ck870 FIND v(dout1_0) AT=880.05n

.meas tran vdout1_1ck870 FIND v(dout1_1) AT=880.05n

.meas tran vdout1_2ck870 FIND v(dout1_2) AT=880.05n

.meas tran vdout1_3ck870 FIND v(dout1_3) AT=880.05n

.meas tran vdout1_4ck870 FIND v(dout1_4) AT=880.05n

.meas tran vdout1_5ck870 FIND v(dout1_5) AT=880.05n

.meas tran vdout1_6ck870 FIND v(dout1_6) AT=880.05n

.meas tran vdout1_7ck870 FIND v(dout1_7) AT=880.05n

.meas tran vdout1_8ck870 FIND v(dout1_8) AT=880.05n

.meas tran vdout1_9ck870 FIND v(dout1_9) AT=880.05n

.meas tran vdout1_10ck870 FIND v(dout1_10) AT=880.05n

.meas tran vdout1_11ck870 FIND v(dout1_11) AT=880.05n

.meas tran vdout1_12ck870 FIND v(dout1_12) AT=880.05n

.meas tran vdout1_13ck870 FIND v(dout1_13) AT=880.05n

.meas tran vdout1_14ck870 FIND v(dout1_14) AT=880.05n

.meas tran vdout1_15ck870 FIND v(dout1_15) AT=880.05n

.meas tran vdout1_16ck870 FIND v(dout1_16) AT=880.05n

.meas tran vdout1_17ck870 FIND v(dout1_17) AT=880.05n

.meas tran vdout1_18ck870 FIND v(dout1_18) AT=880.05n

.meas tran vdout1_19ck870 FIND v(dout1_19) AT=880.05n

.meas tran vdout1_20ck870 FIND v(dout1_20) AT=880.05n

.meas tran vdout1_21ck870 FIND v(dout1_21) AT=880.05n

.meas tran vdout1_22ck870 FIND v(dout1_22) AT=880.05n

.meas tran vdout1_23ck870 FIND v(dout1_23) AT=880.05n

.meas tran vdout1_24ck870 FIND v(dout1_24) AT=880.05n

.meas tran vdout1_25ck870 FIND v(dout1_25) AT=880.05n

.meas tran vdout1_26ck870 FIND v(dout1_26) AT=880.05n

.meas tran vdout1_27ck870 FIND v(dout1_27) AT=880.05n

.meas tran vdout1_28ck870 FIND v(dout1_28) AT=880.05n

.meas tran vdout1_29ck870 FIND v(dout1_29) AT=880.05n

.meas tran vdout1_30ck870 FIND v(dout1_30) AT=880.05n

.meas tran vdout1_31ck870 FIND v(dout1_31) AT=880.05n

.meas tran vdout1_0ck890 FIND v(dout1_0) AT=900.05n

.meas tran vdout1_1ck890 FIND v(dout1_1) AT=900.05n

.meas tran vdout1_2ck890 FIND v(dout1_2) AT=900.05n

.meas tran vdout1_3ck890 FIND v(dout1_3) AT=900.05n

.meas tran vdout1_4ck890 FIND v(dout1_4) AT=900.05n

.meas tran vdout1_5ck890 FIND v(dout1_5) AT=900.05n

.meas tran vdout1_6ck890 FIND v(dout1_6) AT=900.05n

.meas tran vdout1_7ck890 FIND v(dout1_7) AT=900.05n

.meas tran vdout1_8ck890 FIND v(dout1_8) AT=900.05n

.meas tran vdout1_9ck890 FIND v(dout1_9) AT=900.05n

.meas tran vdout1_10ck890 FIND v(dout1_10) AT=900.05n

.meas tran vdout1_11ck890 FIND v(dout1_11) AT=900.05n

.meas tran vdout1_12ck890 FIND v(dout1_12) AT=900.05n

.meas tran vdout1_13ck890 FIND v(dout1_13) AT=900.05n

.meas tran vdout1_14ck890 FIND v(dout1_14) AT=900.05n

.meas tran vdout1_15ck890 FIND v(dout1_15) AT=900.05n

.meas tran vdout1_16ck890 FIND v(dout1_16) AT=900.05n

.meas tran vdout1_17ck890 FIND v(dout1_17) AT=900.05n

.meas tran vdout1_18ck890 FIND v(dout1_18) AT=900.05n

.meas tran vdout1_19ck890 FIND v(dout1_19) AT=900.05n

.meas tran vdout1_20ck890 FIND v(dout1_20) AT=900.05n

.meas tran vdout1_21ck890 FIND v(dout1_21) AT=900.05n

.meas tran vdout1_22ck890 FIND v(dout1_22) AT=900.05n

.meas tran vdout1_23ck890 FIND v(dout1_23) AT=900.05n

.meas tran vdout1_24ck890 FIND v(dout1_24) AT=900.05n

.meas tran vdout1_25ck890 FIND v(dout1_25) AT=900.05n

.meas tran vdout1_26ck890 FIND v(dout1_26) AT=900.05n

.meas tran vdout1_27ck890 FIND v(dout1_27) AT=900.05n

.meas tran vdout1_28ck890 FIND v(dout1_28) AT=900.05n

.meas tran vdout1_29ck890 FIND v(dout1_29) AT=900.05n

.meas tran vdout1_30ck890 FIND v(dout1_30) AT=900.05n

.meas tran vdout1_31ck890 FIND v(dout1_31) AT=900.05n

.meas tran vdout0_0ck920 FIND v(dout0_0) AT=930.05n

.meas tran vdout0_1ck920 FIND v(dout0_1) AT=930.05n

.meas tran vdout0_2ck920 FIND v(dout0_2) AT=930.05n

.meas tran vdout0_3ck920 FIND v(dout0_3) AT=930.05n

.meas tran vdout0_4ck920 FIND v(dout0_4) AT=930.05n

.meas tran vdout0_5ck920 FIND v(dout0_5) AT=930.05n

.meas tran vdout0_6ck920 FIND v(dout0_6) AT=930.05n

.meas tran vdout0_7ck920 FIND v(dout0_7) AT=930.05n

.meas tran vdout0_8ck920 FIND v(dout0_8) AT=930.05n

.meas tran vdout0_9ck920 FIND v(dout0_9) AT=930.05n

.meas tran vdout0_10ck920 FIND v(dout0_10) AT=930.05n

.meas tran vdout0_11ck920 FIND v(dout0_11) AT=930.05n

.meas tran vdout0_12ck920 FIND v(dout0_12) AT=930.05n

.meas tran vdout0_13ck920 FIND v(dout0_13) AT=930.05n

.meas tran vdout0_14ck920 FIND v(dout0_14) AT=930.05n

.meas tran vdout0_15ck920 FIND v(dout0_15) AT=930.05n

.meas tran vdout0_16ck920 FIND v(dout0_16) AT=930.05n

.meas tran vdout0_17ck920 FIND v(dout0_17) AT=930.05n

.meas tran vdout0_18ck920 FIND v(dout0_18) AT=930.05n

.meas tran vdout0_19ck920 FIND v(dout0_19) AT=930.05n

.meas tran vdout0_20ck920 FIND v(dout0_20) AT=930.05n

.meas tran vdout0_21ck920 FIND v(dout0_21) AT=930.05n

.meas tran vdout0_22ck920 FIND v(dout0_22) AT=930.05n

.meas tran vdout0_23ck920 FIND v(dout0_23) AT=930.05n

.meas tran vdout0_24ck920 FIND v(dout0_24) AT=930.05n

.meas tran vdout0_25ck920 FIND v(dout0_25) AT=930.05n

.meas tran vdout0_26ck920 FIND v(dout0_26) AT=930.05n

.meas tran vdout0_27ck920 FIND v(dout0_27) AT=930.05n

.meas tran vdout0_28ck920 FIND v(dout0_28) AT=930.05n

.meas tran vdout0_29ck920 FIND v(dout0_29) AT=930.05n

.meas tran vdout0_30ck920 FIND v(dout0_30) AT=930.05n

.meas tran vdout0_31ck920 FIND v(dout0_31) AT=930.05n

.meas tran vdout1_0ck930 FIND v(dout1_0) AT=940.05n

.meas tran vdout1_1ck930 FIND v(dout1_1) AT=940.05n

.meas tran vdout1_2ck930 FIND v(dout1_2) AT=940.05n

.meas tran vdout1_3ck930 FIND v(dout1_3) AT=940.05n

.meas tran vdout1_4ck930 FIND v(dout1_4) AT=940.05n

.meas tran vdout1_5ck930 FIND v(dout1_5) AT=940.05n

.meas tran vdout1_6ck930 FIND v(dout1_6) AT=940.05n

.meas tran vdout1_7ck930 FIND v(dout1_7) AT=940.05n

.meas tran vdout1_8ck930 FIND v(dout1_8) AT=940.05n

.meas tran vdout1_9ck930 FIND v(dout1_9) AT=940.05n

.meas tran vdout1_10ck930 FIND v(dout1_10) AT=940.05n

.meas tran vdout1_11ck930 FIND v(dout1_11) AT=940.05n

.meas tran vdout1_12ck930 FIND v(dout1_12) AT=940.05n

.meas tran vdout1_13ck930 FIND v(dout1_13) AT=940.05n

.meas tran vdout1_14ck930 FIND v(dout1_14) AT=940.05n

.meas tran vdout1_15ck930 FIND v(dout1_15) AT=940.05n

.meas tran vdout1_16ck930 FIND v(dout1_16) AT=940.05n

.meas tran vdout1_17ck930 FIND v(dout1_17) AT=940.05n

.meas tran vdout1_18ck930 FIND v(dout1_18) AT=940.05n

.meas tran vdout1_19ck930 FIND v(dout1_19) AT=940.05n

.meas tran vdout1_20ck930 FIND v(dout1_20) AT=940.05n

.meas tran vdout1_21ck930 FIND v(dout1_21) AT=940.05n

.meas tran vdout1_22ck930 FIND v(dout1_22) AT=940.05n

.meas tran vdout1_23ck930 FIND v(dout1_23) AT=940.05n

.meas tran vdout1_24ck930 FIND v(dout1_24) AT=940.05n

.meas tran vdout1_25ck930 FIND v(dout1_25) AT=940.05n

.meas tran vdout1_26ck930 FIND v(dout1_26) AT=940.05n

.meas tran vdout1_27ck930 FIND v(dout1_27) AT=940.05n

.meas tran vdout1_28ck930 FIND v(dout1_28) AT=940.05n

.meas tran vdout1_29ck930 FIND v(dout1_29) AT=940.05n

.meas tran vdout1_30ck930 FIND v(dout1_30) AT=940.05n

.meas tran vdout1_31ck930 FIND v(dout1_31) AT=940.05n

.meas tran vdout1_0ck940 FIND v(dout1_0) AT=950.05n

.meas tran vdout1_1ck940 FIND v(dout1_1) AT=950.05n

.meas tran vdout1_2ck940 FIND v(dout1_2) AT=950.05n

.meas tran vdout1_3ck940 FIND v(dout1_3) AT=950.05n

.meas tran vdout1_4ck940 FIND v(dout1_4) AT=950.05n

.meas tran vdout1_5ck940 FIND v(dout1_5) AT=950.05n

.meas tran vdout1_6ck940 FIND v(dout1_6) AT=950.05n

.meas tran vdout1_7ck940 FIND v(dout1_7) AT=950.05n

.meas tran vdout1_8ck940 FIND v(dout1_8) AT=950.05n

.meas tran vdout1_9ck940 FIND v(dout1_9) AT=950.05n

.meas tran vdout1_10ck940 FIND v(dout1_10) AT=950.05n

.meas tran vdout1_11ck940 FIND v(dout1_11) AT=950.05n

.meas tran vdout1_12ck940 FIND v(dout1_12) AT=950.05n

.meas tran vdout1_13ck940 FIND v(dout1_13) AT=950.05n

.meas tran vdout1_14ck940 FIND v(dout1_14) AT=950.05n

.meas tran vdout1_15ck940 FIND v(dout1_15) AT=950.05n

.meas tran vdout1_16ck940 FIND v(dout1_16) AT=950.05n

.meas tran vdout1_17ck940 FIND v(dout1_17) AT=950.05n

.meas tran vdout1_18ck940 FIND v(dout1_18) AT=950.05n

.meas tran vdout1_19ck940 FIND v(dout1_19) AT=950.05n

.meas tran vdout1_20ck940 FIND v(dout1_20) AT=950.05n

.meas tran vdout1_21ck940 FIND v(dout1_21) AT=950.05n

.meas tran vdout1_22ck940 FIND v(dout1_22) AT=950.05n

.meas tran vdout1_23ck940 FIND v(dout1_23) AT=950.05n

.meas tran vdout1_24ck940 FIND v(dout1_24) AT=950.05n

.meas tran vdout1_25ck940 FIND v(dout1_25) AT=950.05n

.meas tran vdout1_26ck940 FIND v(dout1_26) AT=950.05n

.meas tran vdout1_27ck940 FIND v(dout1_27) AT=950.05n

.meas tran vdout1_28ck940 FIND v(dout1_28) AT=950.05n

.meas tran vdout1_29ck940 FIND v(dout1_29) AT=950.05n

.meas tran vdout1_30ck940 FIND v(dout1_30) AT=950.05n

.meas tran vdout1_31ck940 FIND v(dout1_31) AT=950.05n

.meas tran vdout1_0ck950 FIND v(dout1_0) AT=960.05n

.meas tran vdout1_1ck950 FIND v(dout1_1) AT=960.05n

.meas tran vdout1_2ck950 FIND v(dout1_2) AT=960.05n

.meas tran vdout1_3ck950 FIND v(dout1_3) AT=960.05n

.meas tran vdout1_4ck950 FIND v(dout1_4) AT=960.05n

.meas tran vdout1_5ck950 FIND v(dout1_5) AT=960.05n

.meas tran vdout1_6ck950 FIND v(dout1_6) AT=960.05n

.meas tran vdout1_7ck950 FIND v(dout1_7) AT=960.05n

.meas tran vdout1_8ck950 FIND v(dout1_8) AT=960.05n

.meas tran vdout1_9ck950 FIND v(dout1_9) AT=960.05n

.meas tran vdout1_10ck950 FIND v(dout1_10) AT=960.05n

.meas tran vdout1_11ck950 FIND v(dout1_11) AT=960.05n

.meas tran vdout1_12ck950 FIND v(dout1_12) AT=960.05n

.meas tran vdout1_13ck950 FIND v(dout1_13) AT=960.05n

.meas tran vdout1_14ck950 FIND v(dout1_14) AT=960.05n

.meas tran vdout1_15ck950 FIND v(dout1_15) AT=960.05n

.meas tran vdout1_16ck950 FIND v(dout1_16) AT=960.05n

.meas tran vdout1_17ck950 FIND v(dout1_17) AT=960.05n

.meas tran vdout1_18ck950 FIND v(dout1_18) AT=960.05n

.meas tran vdout1_19ck950 FIND v(dout1_19) AT=960.05n

.meas tran vdout1_20ck950 FIND v(dout1_20) AT=960.05n

.meas tran vdout1_21ck950 FIND v(dout1_21) AT=960.05n

.meas tran vdout1_22ck950 FIND v(dout1_22) AT=960.05n

.meas tran vdout1_23ck950 FIND v(dout1_23) AT=960.05n

.meas tran vdout1_24ck950 FIND v(dout1_24) AT=960.05n

.meas tran vdout1_25ck950 FIND v(dout1_25) AT=960.05n

.meas tran vdout1_26ck950 FIND v(dout1_26) AT=960.05n

.meas tran vdout1_27ck950 FIND v(dout1_27) AT=960.05n

.meas tran vdout1_28ck950 FIND v(dout1_28) AT=960.05n

.meas tran vdout1_29ck950 FIND v(dout1_29) AT=960.05n

.meas tran vdout1_30ck950 FIND v(dout1_30) AT=960.05n

.meas tran vdout1_31ck950 FIND v(dout1_31) AT=960.05n

.meas tran vdout1_0ck960 FIND v(dout1_0) AT=970.05n

.meas tran vdout1_1ck960 FIND v(dout1_1) AT=970.05n

.meas tran vdout1_2ck960 FIND v(dout1_2) AT=970.05n

.meas tran vdout1_3ck960 FIND v(dout1_3) AT=970.05n

.meas tran vdout1_4ck960 FIND v(dout1_4) AT=970.05n

.meas tran vdout1_5ck960 FIND v(dout1_5) AT=970.05n

.meas tran vdout1_6ck960 FIND v(dout1_6) AT=970.05n

.meas tran vdout1_7ck960 FIND v(dout1_7) AT=970.05n

.meas tran vdout1_8ck960 FIND v(dout1_8) AT=970.05n

.meas tran vdout1_9ck960 FIND v(dout1_9) AT=970.05n

.meas tran vdout1_10ck960 FIND v(dout1_10) AT=970.05n

.meas tran vdout1_11ck960 FIND v(dout1_11) AT=970.05n

.meas tran vdout1_12ck960 FIND v(dout1_12) AT=970.05n

.meas tran vdout1_13ck960 FIND v(dout1_13) AT=970.05n

.meas tran vdout1_14ck960 FIND v(dout1_14) AT=970.05n

.meas tran vdout1_15ck960 FIND v(dout1_15) AT=970.05n

.meas tran vdout1_16ck960 FIND v(dout1_16) AT=970.05n

.meas tran vdout1_17ck960 FIND v(dout1_17) AT=970.05n

.meas tran vdout1_18ck960 FIND v(dout1_18) AT=970.05n

.meas tran vdout1_19ck960 FIND v(dout1_19) AT=970.05n

.meas tran vdout1_20ck960 FIND v(dout1_20) AT=970.05n

.meas tran vdout1_21ck960 FIND v(dout1_21) AT=970.05n

.meas tran vdout1_22ck960 FIND v(dout1_22) AT=970.05n

.meas tran vdout1_23ck960 FIND v(dout1_23) AT=970.05n

.meas tran vdout1_24ck960 FIND v(dout1_24) AT=970.05n

.meas tran vdout1_25ck960 FIND v(dout1_25) AT=970.05n

.meas tran vdout1_26ck960 FIND v(dout1_26) AT=970.05n

.meas tran vdout1_27ck960 FIND v(dout1_27) AT=970.05n

.meas tran vdout1_28ck960 FIND v(dout1_28) AT=970.05n

.meas tran vdout1_29ck960 FIND v(dout1_29) AT=970.05n

.meas tran vdout1_30ck960 FIND v(dout1_30) AT=970.05n

.meas tran vdout1_31ck960 FIND v(dout1_31) AT=970.05n

.meas tran vdout0_0ck970 FIND v(dout0_0) AT=980.05n

.meas tran vdout0_1ck970 FIND v(dout0_1) AT=980.05n

.meas tran vdout0_2ck970 FIND v(dout0_2) AT=980.05n

.meas tran vdout0_3ck970 FIND v(dout0_3) AT=980.05n

.meas tran vdout0_4ck970 FIND v(dout0_4) AT=980.05n

.meas tran vdout0_5ck970 FIND v(dout0_5) AT=980.05n

.meas tran vdout0_6ck970 FIND v(dout0_6) AT=980.05n

.meas tran vdout0_7ck970 FIND v(dout0_7) AT=980.05n

.meas tran vdout0_8ck970 FIND v(dout0_8) AT=980.05n

.meas tran vdout0_9ck970 FIND v(dout0_9) AT=980.05n

.meas tran vdout0_10ck970 FIND v(dout0_10) AT=980.05n

.meas tran vdout0_11ck970 FIND v(dout0_11) AT=980.05n

.meas tran vdout0_12ck970 FIND v(dout0_12) AT=980.05n

.meas tran vdout0_13ck970 FIND v(dout0_13) AT=980.05n

.meas tran vdout0_14ck970 FIND v(dout0_14) AT=980.05n

.meas tran vdout0_15ck970 FIND v(dout0_15) AT=980.05n

.meas tran vdout0_16ck970 FIND v(dout0_16) AT=980.05n

.meas tran vdout0_17ck970 FIND v(dout0_17) AT=980.05n

.meas tran vdout0_18ck970 FIND v(dout0_18) AT=980.05n

.meas tran vdout0_19ck970 FIND v(dout0_19) AT=980.05n

.meas tran vdout0_20ck970 FIND v(dout0_20) AT=980.05n

.meas tran vdout0_21ck970 FIND v(dout0_21) AT=980.05n

.meas tran vdout0_22ck970 FIND v(dout0_22) AT=980.05n

.meas tran vdout0_23ck970 FIND v(dout0_23) AT=980.05n

.meas tran vdout0_24ck970 FIND v(dout0_24) AT=980.05n

.meas tran vdout0_25ck970 FIND v(dout0_25) AT=980.05n

.meas tran vdout0_26ck970 FIND v(dout0_26) AT=980.05n

.meas tran vdout0_27ck970 FIND v(dout0_27) AT=980.05n

.meas tran vdout0_28ck970 FIND v(dout0_28) AT=980.05n

.meas tran vdout0_29ck970 FIND v(dout0_29) AT=980.05n

.meas tran vdout0_30ck970 FIND v(dout0_30) AT=980.05n

.meas tran vdout0_31ck970 FIND v(dout0_31) AT=980.05n

.meas tran vdout0_0ck980 FIND v(dout0_0) AT=990.05n

.meas tran vdout0_1ck980 FIND v(dout0_1) AT=990.05n

.meas tran vdout0_2ck980 FIND v(dout0_2) AT=990.05n

.meas tran vdout0_3ck980 FIND v(dout0_3) AT=990.05n

.meas tran vdout0_4ck980 FIND v(dout0_4) AT=990.05n

.meas tran vdout0_5ck980 FIND v(dout0_5) AT=990.05n

.meas tran vdout0_6ck980 FIND v(dout0_6) AT=990.05n

.meas tran vdout0_7ck980 FIND v(dout0_7) AT=990.05n

.meas tran vdout0_8ck980 FIND v(dout0_8) AT=990.05n

.meas tran vdout0_9ck980 FIND v(dout0_9) AT=990.05n

.meas tran vdout0_10ck980 FIND v(dout0_10) AT=990.05n

.meas tran vdout0_11ck980 FIND v(dout0_11) AT=990.05n

.meas tran vdout0_12ck980 FIND v(dout0_12) AT=990.05n

.meas tran vdout0_13ck980 FIND v(dout0_13) AT=990.05n

.meas tran vdout0_14ck980 FIND v(dout0_14) AT=990.05n

.meas tran vdout0_15ck980 FIND v(dout0_15) AT=990.05n

.meas tran vdout0_16ck980 FIND v(dout0_16) AT=990.05n

.meas tran vdout0_17ck980 FIND v(dout0_17) AT=990.05n

.meas tran vdout0_18ck980 FIND v(dout0_18) AT=990.05n

.meas tran vdout0_19ck980 FIND v(dout0_19) AT=990.05n

.meas tran vdout0_20ck980 FIND v(dout0_20) AT=990.05n

.meas tran vdout0_21ck980 FIND v(dout0_21) AT=990.05n

.meas tran vdout0_22ck980 FIND v(dout0_22) AT=990.05n

.meas tran vdout0_23ck980 FIND v(dout0_23) AT=990.05n

.meas tran vdout0_24ck980 FIND v(dout0_24) AT=990.05n

.meas tran vdout0_25ck980 FIND v(dout0_25) AT=990.05n

.meas tran vdout0_26ck980 FIND v(dout0_26) AT=990.05n

.meas tran vdout0_27ck980 FIND v(dout0_27) AT=990.05n

.meas tran vdout0_28ck980 FIND v(dout0_28) AT=990.05n

.meas tran vdout0_29ck980 FIND v(dout0_29) AT=990.05n

.meas tran vdout0_30ck980 FIND v(dout0_30) AT=990.05n

.meas tran vdout0_31ck980 FIND v(dout0_31) AT=990.05n

.meas tran vdout0_0ck1000 FIND v(dout0_0) AT=1010.05n

.meas tran vdout0_1ck1000 FIND v(dout0_1) AT=1010.05n

.meas tran vdout0_2ck1000 FIND v(dout0_2) AT=1010.05n

.meas tran vdout0_3ck1000 FIND v(dout0_3) AT=1010.05n

.meas tran vdout0_4ck1000 FIND v(dout0_4) AT=1010.05n

.meas tran vdout0_5ck1000 FIND v(dout0_5) AT=1010.05n

.meas tran vdout0_6ck1000 FIND v(dout0_6) AT=1010.05n

.meas tran vdout0_7ck1000 FIND v(dout0_7) AT=1010.05n

.meas tran vdout0_8ck1000 FIND v(dout0_8) AT=1010.05n

.meas tran vdout0_9ck1000 FIND v(dout0_9) AT=1010.05n

.meas tran vdout0_10ck1000 FIND v(dout0_10) AT=1010.05n

.meas tran vdout0_11ck1000 FIND v(dout0_11) AT=1010.05n

.meas tran vdout0_12ck1000 FIND v(dout0_12) AT=1010.05n

.meas tran vdout0_13ck1000 FIND v(dout0_13) AT=1010.05n

.meas tran vdout0_14ck1000 FIND v(dout0_14) AT=1010.05n

.meas tran vdout0_15ck1000 FIND v(dout0_15) AT=1010.05n

.meas tran vdout0_16ck1000 FIND v(dout0_16) AT=1010.05n

.meas tran vdout0_17ck1000 FIND v(dout0_17) AT=1010.05n

.meas tran vdout0_18ck1000 FIND v(dout0_18) AT=1010.05n

.meas tran vdout0_19ck1000 FIND v(dout0_19) AT=1010.05n

.meas tran vdout0_20ck1000 FIND v(dout0_20) AT=1010.05n

.meas tran vdout0_21ck1000 FIND v(dout0_21) AT=1010.05n

.meas tran vdout0_22ck1000 FIND v(dout0_22) AT=1010.05n

.meas tran vdout0_23ck1000 FIND v(dout0_23) AT=1010.05n

.meas tran vdout0_24ck1000 FIND v(dout0_24) AT=1010.05n

.meas tran vdout0_25ck1000 FIND v(dout0_25) AT=1010.05n

.meas tran vdout0_26ck1000 FIND v(dout0_26) AT=1010.05n

.meas tran vdout0_27ck1000 FIND v(dout0_27) AT=1010.05n

.meas tran vdout0_28ck1000 FIND v(dout0_28) AT=1010.05n

.meas tran vdout0_29ck1000 FIND v(dout0_29) AT=1010.05n

.meas tran vdout0_30ck1000 FIND v(dout0_30) AT=1010.05n

.meas tran vdout0_31ck1000 FIND v(dout0_31) AT=1010.05n

.meas tran vdout1_0ck1000 FIND v(dout1_0) AT=1010.05n

.meas tran vdout1_1ck1000 FIND v(dout1_1) AT=1010.05n

.meas tran vdout1_2ck1000 FIND v(dout1_2) AT=1010.05n

.meas tran vdout1_3ck1000 FIND v(dout1_3) AT=1010.05n

.meas tran vdout1_4ck1000 FIND v(dout1_4) AT=1010.05n

.meas tran vdout1_5ck1000 FIND v(dout1_5) AT=1010.05n

.meas tran vdout1_6ck1000 FIND v(dout1_6) AT=1010.05n

.meas tran vdout1_7ck1000 FIND v(dout1_7) AT=1010.05n

.meas tran vdout1_8ck1000 FIND v(dout1_8) AT=1010.05n

.meas tran vdout1_9ck1000 FIND v(dout1_9) AT=1010.05n

.meas tran vdout1_10ck1000 FIND v(dout1_10) AT=1010.05n

.meas tran vdout1_11ck1000 FIND v(dout1_11) AT=1010.05n

.meas tran vdout1_12ck1000 FIND v(dout1_12) AT=1010.05n

.meas tran vdout1_13ck1000 FIND v(dout1_13) AT=1010.05n

.meas tran vdout1_14ck1000 FIND v(dout1_14) AT=1010.05n

.meas tran vdout1_15ck1000 FIND v(dout1_15) AT=1010.05n

.meas tran vdout1_16ck1000 FIND v(dout1_16) AT=1010.05n

.meas tran vdout1_17ck1000 FIND v(dout1_17) AT=1010.05n

.meas tran vdout1_18ck1000 FIND v(dout1_18) AT=1010.05n

.meas tran vdout1_19ck1000 FIND v(dout1_19) AT=1010.05n

.meas tran vdout1_20ck1000 FIND v(dout1_20) AT=1010.05n

.meas tran vdout1_21ck1000 FIND v(dout1_21) AT=1010.05n

.meas tran vdout1_22ck1000 FIND v(dout1_22) AT=1010.05n

.meas tran vdout1_23ck1000 FIND v(dout1_23) AT=1010.05n

.meas tran vdout1_24ck1000 FIND v(dout1_24) AT=1010.05n

.meas tran vdout1_25ck1000 FIND v(dout1_25) AT=1010.05n

.meas tran vdout1_26ck1000 FIND v(dout1_26) AT=1010.05n

.meas tran vdout1_27ck1000 FIND v(dout1_27) AT=1010.05n

.meas tran vdout1_28ck1000 FIND v(dout1_28) AT=1010.05n

.meas tran vdout1_29ck1000 FIND v(dout1_29) AT=1010.05n

.meas tran vdout1_30ck1000 FIND v(dout1_30) AT=1010.05n

.meas tran vdout1_31ck1000 FIND v(dout1_31) AT=1010.05n

.meas tran vdout0_0ck1010 FIND v(dout0_0) AT=1020.05n

.meas tran vdout0_1ck1010 FIND v(dout0_1) AT=1020.05n

.meas tran vdout0_2ck1010 FIND v(dout0_2) AT=1020.05n

.meas tran vdout0_3ck1010 FIND v(dout0_3) AT=1020.05n

.meas tran vdout0_4ck1010 FIND v(dout0_4) AT=1020.05n

.meas tran vdout0_5ck1010 FIND v(dout0_5) AT=1020.05n

.meas tran vdout0_6ck1010 FIND v(dout0_6) AT=1020.05n

.meas tran vdout0_7ck1010 FIND v(dout0_7) AT=1020.05n

.meas tran vdout0_8ck1010 FIND v(dout0_8) AT=1020.05n

.meas tran vdout0_9ck1010 FIND v(dout0_9) AT=1020.05n

.meas tran vdout0_10ck1010 FIND v(dout0_10) AT=1020.05n

.meas tran vdout0_11ck1010 FIND v(dout0_11) AT=1020.05n

.meas tran vdout0_12ck1010 FIND v(dout0_12) AT=1020.05n

.meas tran vdout0_13ck1010 FIND v(dout0_13) AT=1020.05n

.meas tran vdout0_14ck1010 FIND v(dout0_14) AT=1020.05n

.meas tran vdout0_15ck1010 FIND v(dout0_15) AT=1020.05n

.meas tran vdout0_16ck1010 FIND v(dout0_16) AT=1020.05n

.meas tran vdout0_17ck1010 FIND v(dout0_17) AT=1020.05n

.meas tran vdout0_18ck1010 FIND v(dout0_18) AT=1020.05n

.meas tran vdout0_19ck1010 FIND v(dout0_19) AT=1020.05n

.meas tran vdout0_20ck1010 FIND v(dout0_20) AT=1020.05n

.meas tran vdout0_21ck1010 FIND v(dout0_21) AT=1020.05n

.meas tran vdout0_22ck1010 FIND v(dout0_22) AT=1020.05n

.meas tran vdout0_23ck1010 FIND v(dout0_23) AT=1020.05n

.meas tran vdout0_24ck1010 FIND v(dout0_24) AT=1020.05n

.meas tran vdout0_25ck1010 FIND v(dout0_25) AT=1020.05n

.meas tran vdout0_26ck1010 FIND v(dout0_26) AT=1020.05n

.meas tran vdout0_27ck1010 FIND v(dout0_27) AT=1020.05n

.meas tran vdout0_28ck1010 FIND v(dout0_28) AT=1020.05n

.meas tran vdout0_29ck1010 FIND v(dout0_29) AT=1020.05n

.meas tran vdout0_30ck1010 FIND v(dout0_30) AT=1020.05n

.meas tran vdout0_31ck1010 FIND v(dout0_31) AT=1020.05n

.meas tran vdout0_0ck1020 FIND v(dout0_0) AT=1030.05n

.meas tran vdout0_1ck1020 FIND v(dout0_1) AT=1030.05n

.meas tran vdout0_2ck1020 FIND v(dout0_2) AT=1030.05n

.meas tran vdout0_3ck1020 FIND v(dout0_3) AT=1030.05n

.meas tran vdout0_4ck1020 FIND v(dout0_4) AT=1030.05n

.meas tran vdout0_5ck1020 FIND v(dout0_5) AT=1030.05n

.meas tran vdout0_6ck1020 FIND v(dout0_6) AT=1030.05n

.meas tran vdout0_7ck1020 FIND v(dout0_7) AT=1030.05n

.meas tran vdout0_8ck1020 FIND v(dout0_8) AT=1030.05n

.meas tran vdout0_9ck1020 FIND v(dout0_9) AT=1030.05n

.meas tran vdout0_10ck1020 FIND v(dout0_10) AT=1030.05n

.meas tran vdout0_11ck1020 FIND v(dout0_11) AT=1030.05n

.meas tran vdout0_12ck1020 FIND v(dout0_12) AT=1030.05n

.meas tran vdout0_13ck1020 FIND v(dout0_13) AT=1030.05n

.meas tran vdout0_14ck1020 FIND v(dout0_14) AT=1030.05n

.meas tran vdout0_15ck1020 FIND v(dout0_15) AT=1030.05n

.meas tran vdout0_16ck1020 FIND v(dout0_16) AT=1030.05n

.meas tran vdout0_17ck1020 FIND v(dout0_17) AT=1030.05n

.meas tran vdout0_18ck1020 FIND v(dout0_18) AT=1030.05n

.meas tran vdout0_19ck1020 FIND v(dout0_19) AT=1030.05n

.meas tran vdout0_20ck1020 FIND v(dout0_20) AT=1030.05n

.meas tran vdout0_21ck1020 FIND v(dout0_21) AT=1030.05n

.meas tran vdout0_22ck1020 FIND v(dout0_22) AT=1030.05n

.meas tran vdout0_23ck1020 FIND v(dout0_23) AT=1030.05n

.meas tran vdout0_24ck1020 FIND v(dout0_24) AT=1030.05n

.meas tran vdout0_25ck1020 FIND v(dout0_25) AT=1030.05n

.meas tran vdout0_26ck1020 FIND v(dout0_26) AT=1030.05n

.meas tran vdout0_27ck1020 FIND v(dout0_27) AT=1030.05n

.meas tran vdout0_28ck1020 FIND v(dout0_28) AT=1030.05n

.meas tran vdout0_29ck1020 FIND v(dout0_29) AT=1030.05n

.meas tran vdout0_30ck1020 FIND v(dout0_30) AT=1030.05n

.meas tran vdout0_31ck1020 FIND v(dout0_31) AT=1030.05n

.meas tran vdout0_0ck1040 FIND v(dout0_0) AT=1050.05n

.meas tran vdout0_1ck1040 FIND v(dout0_1) AT=1050.05n

.meas tran vdout0_2ck1040 FIND v(dout0_2) AT=1050.05n

.meas tran vdout0_3ck1040 FIND v(dout0_3) AT=1050.05n

.meas tran vdout0_4ck1040 FIND v(dout0_4) AT=1050.05n

.meas tran vdout0_5ck1040 FIND v(dout0_5) AT=1050.05n

.meas tran vdout0_6ck1040 FIND v(dout0_6) AT=1050.05n

.meas tran vdout0_7ck1040 FIND v(dout0_7) AT=1050.05n

.meas tran vdout0_8ck1040 FIND v(dout0_8) AT=1050.05n

.meas tran vdout0_9ck1040 FIND v(dout0_9) AT=1050.05n

.meas tran vdout0_10ck1040 FIND v(dout0_10) AT=1050.05n

.meas tran vdout0_11ck1040 FIND v(dout0_11) AT=1050.05n

.meas tran vdout0_12ck1040 FIND v(dout0_12) AT=1050.05n

.meas tran vdout0_13ck1040 FIND v(dout0_13) AT=1050.05n

.meas tran vdout0_14ck1040 FIND v(dout0_14) AT=1050.05n

.meas tran vdout0_15ck1040 FIND v(dout0_15) AT=1050.05n

.meas tran vdout0_16ck1040 FIND v(dout0_16) AT=1050.05n

.meas tran vdout0_17ck1040 FIND v(dout0_17) AT=1050.05n

.meas tran vdout0_18ck1040 FIND v(dout0_18) AT=1050.05n

.meas tran vdout0_19ck1040 FIND v(dout0_19) AT=1050.05n

.meas tran vdout0_20ck1040 FIND v(dout0_20) AT=1050.05n

.meas tran vdout0_21ck1040 FIND v(dout0_21) AT=1050.05n

.meas tran vdout0_22ck1040 FIND v(dout0_22) AT=1050.05n

.meas tran vdout0_23ck1040 FIND v(dout0_23) AT=1050.05n

.meas tran vdout0_24ck1040 FIND v(dout0_24) AT=1050.05n

.meas tran vdout0_25ck1040 FIND v(dout0_25) AT=1050.05n

.meas tran vdout0_26ck1040 FIND v(dout0_26) AT=1050.05n

.meas tran vdout0_27ck1040 FIND v(dout0_27) AT=1050.05n

.meas tran vdout0_28ck1040 FIND v(dout0_28) AT=1050.05n

.meas tran vdout0_29ck1040 FIND v(dout0_29) AT=1050.05n

.meas tran vdout0_30ck1040 FIND v(dout0_30) AT=1050.05n

.meas tran vdout0_31ck1040 FIND v(dout0_31) AT=1050.05n

.meas tran vdout0_0ck1050 FIND v(dout0_0) AT=1060.05n

.meas tran vdout0_1ck1050 FIND v(dout0_1) AT=1060.05n

.meas tran vdout0_2ck1050 FIND v(dout0_2) AT=1060.05n

.meas tran vdout0_3ck1050 FIND v(dout0_3) AT=1060.05n

.meas tran vdout0_4ck1050 FIND v(dout0_4) AT=1060.05n

.meas tran vdout0_5ck1050 FIND v(dout0_5) AT=1060.05n

.meas tran vdout0_6ck1050 FIND v(dout0_6) AT=1060.05n

.meas tran vdout0_7ck1050 FIND v(dout0_7) AT=1060.05n

.meas tran vdout0_8ck1050 FIND v(dout0_8) AT=1060.05n

.meas tran vdout0_9ck1050 FIND v(dout0_9) AT=1060.05n

.meas tran vdout0_10ck1050 FIND v(dout0_10) AT=1060.05n

.meas tran vdout0_11ck1050 FIND v(dout0_11) AT=1060.05n

.meas tran vdout0_12ck1050 FIND v(dout0_12) AT=1060.05n

.meas tran vdout0_13ck1050 FIND v(dout0_13) AT=1060.05n

.meas tran vdout0_14ck1050 FIND v(dout0_14) AT=1060.05n

.meas tran vdout0_15ck1050 FIND v(dout0_15) AT=1060.05n

.meas tran vdout0_16ck1050 FIND v(dout0_16) AT=1060.05n

.meas tran vdout0_17ck1050 FIND v(dout0_17) AT=1060.05n

.meas tran vdout0_18ck1050 FIND v(dout0_18) AT=1060.05n

.meas tran vdout0_19ck1050 FIND v(dout0_19) AT=1060.05n

.meas tran vdout0_20ck1050 FIND v(dout0_20) AT=1060.05n

.meas tran vdout0_21ck1050 FIND v(dout0_21) AT=1060.05n

.meas tran vdout0_22ck1050 FIND v(dout0_22) AT=1060.05n

.meas tran vdout0_23ck1050 FIND v(dout0_23) AT=1060.05n

.meas tran vdout0_24ck1050 FIND v(dout0_24) AT=1060.05n

.meas tran vdout0_25ck1050 FIND v(dout0_25) AT=1060.05n

.meas tran vdout0_26ck1050 FIND v(dout0_26) AT=1060.05n

.meas tran vdout0_27ck1050 FIND v(dout0_27) AT=1060.05n

.meas tran vdout0_28ck1050 FIND v(dout0_28) AT=1060.05n

.meas tran vdout0_29ck1050 FIND v(dout0_29) AT=1060.05n

.meas tran vdout0_30ck1050 FIND v(dout0_30) AT=1060.05n

.meas tran vdout0_31ck1050 FIND v(dout0_31) AT=1060.05n

.meas tran vdout0_0ck1060 FIND v(dout0_0) AT=1070.05n

.meas tran vdout0_1ck1060 FIND v(dout0_1) AT=1070.05n

.meas tran vdout0_2ck1060 FIND v(dout0_2) AT=1070.05n

.meas tran vdout0_3ck1060 FIND v(dout0_3) AT=1070.05n

.meas tran vdout0_4ck1060 FIND v(dout0_4) AT=1070.05n

.meas tran vdout0_5ck1060 FIND v(dout0_5) AT=1070.05n

.meas tran vdout0_6ck1060 FIND v(dout0_6) AT=1070.05n

.meas tran vdout0_7ck1060 FIND v(dout0_7) AT=1070.05n

.meas tran vdout0_8ck1060 FIND v(dout0_8) AT=1070.05n

.meas tran vdout0_9ck1060 FIND v(dout0_9) AT=1070.05n

.meas tran vdout0_10ck1060 FIND v(dout0_10) AT=1070.05n

.meas tran vdout0_11ck1060 FIND v(dout0_11) AT=1070.05n

.meas tran vdout0_12ck1060 FIND v(dout0_12) AT=1070.05n

.meas tran vdout0_13ck1060 FIND v(dout0_13) AT=1070.05n

.meas tran vdout0_14ck1060 FIND v(dout0_14) AT=1070.05n

.meas tran vdout0_15ck1060 FIND v(dout0_15) AT=1070.05n

.meas tran vdout0_16ck1060 FIND v(dout0_16) AT=1070.05n

.meas tran vdout0_17ck1060 FIND v(dout0_17) AT=1070.05n

.meas tran vdout0_18ck1060 FIND v(dout0_18) AT=1070.05n

.meas tran vdout0_19ck1060 FIND v(dout0_19) AT=1070.05n

.meas tran vdout0_20ck1060 FIND v(dout0_20) AT=1070.05n

.meas tran vdout0_21ck1060 FIND v(dout0_21) AT=1070.05n

.meas tran vdout0_22ck1060 FIND v(dout0_22) AT=1070.05n

.meas tran vdout0_23ck1060 FIND v(dout0_23) AT=1070.05n

.meas tran vdout0_24ck1060 FIND v(dout0_24) AT=1070.05n

.meas tran vdout0_25ck1060 FIND v(dout0_25) AT=1070.05n

.meas tran vdout0_26ck1060 FIND v(dout0_26) AT=1070.05n

.meas tran vdout0_27ck1060 FIND v(dout0_27) AT=1070.05n

.meas tran vdout0_28ck1060 FIND v(dout0_28) AT=1070.05n

.meas tran vdout0_29ck1060 FIND v(dout0_29) AT=1070.05n

.meas tran vdout0_30ck1060 FIND v(dout0_30) AT=1070.05n

.meas tran vdout0_31ck1060 FIND v(dout0_31) AT=1070.05n

.meas tran vdout1_0ck1070 FIND v(dout1_0) AT=1080.05n

.meas tran vdout1_1ck1070 FIND v(dout1_1) AT=1080.05n

.meas tran vdout1_2ck1070 FIND v(dout1_2) AT=1080.05n

.meas tran vdout1_3ck1070 FIND v(dout1_3) AT=1080.05n

.meas tran vdout1_4ck1070 FIND v(dout1_4) AT=1080.05n

.meas tran vdout1_5ck1070 FIND v(dout1_5) AT=1080.05n

.meas tran vdout1_6ck1070 FIND v(dout1_6) AT=1080.05n

.meas tran vdout1_7ck1070 FIND v(dout1_7) AT=1080.05n

.meas tran vdout1_8ck1070 FIND v(dout1_8) AT=1080.05n

.meas tran vdout1_9ck1070 FIND v(dout1_9) AT=1080.05n

.meas tran vdout1_10ck1070 FIND v(dout1_10) AT=1080.05n

.meas tran vdout1_11ck1070 FIND v(dout1_11) AT=1080.05n

.meas tran vdout1_12ck1070 FIND v(dout1_12) AT=1080.05n

.meas tran vdout1_13ck1070 FIND v(dout1_13) AT=1080.05n

.meas tran vdout1_14ck1070 FIND v(dout1_14) AT=1080.05n

.meas tran vdout1_15ck1070 FIND v(dout1_15) AT=1080.05n

.meas tran vdout1_16ck1070 FIND v(dout1_16) AT=1080.05n

.meas tran vdout1_17ck1070 FIND v(dout1_17) AT=1080.05n

.meas tran vdout1_18ck1070 FIND v(dout1_18) AT=1080.05n

.meas tran vdout1_19ck1070 FIND v(dout1_19) AT=1080.05n

.meas tran vdout1_20ck1070 FIND v(dout1_20) AT=1080.05n

.meas tran vdout1_21ck1070 FIND v(dout1_21) AT=1080.05n

.meas tran vdout1_22ck1070 FIND v(dout1_22) AT=1080.05n

.meas tran vdout1_23ck1070 FIND v(dout1_23) AT=1080.05n

.meas tran vdout1_24ck1070 FIND v(dout1_24) AT=1080.05n

.meas tran vdout1_25ck1070 FIND v(dout1_25) AT=1080.05n

.meas tran vdout1_26ck1070 FIND v(dout1_26) AT=1080.05n

.meas tran vdout1_27ck1070 FIND v(dout1_27) AT=1080.05n

.meas tran vdout1_28ck1070 FIND v(dout1_28) AT=1080.05n

.meas tran vdout1_29ck1070 FIND v(dout1_29) AT=1080.05n

.meas tran vdout1_30ck1070 FIND v(dout1_30) AT=1080.05n

.meas tran vdout1_31ck1070 FIND v(dout1_31) AT=1080.05n

.meas tran vdout1_0ck1080 FIND v(dout1_0) AT=1090.05n

.meas tran vdout1_1ck1080 FIND v(dout1_1) AT=1090.05n

.meas tran vdout1_2ck1080 FIND v(dout1_2) AT=1090.05n

.meas tran vdout1_3ck1080 FIND v(dout1_3) AT=1090.05n

.meas tran vdout1_4ck1080 FIND v(dout1_4) AT=1090.05n

.meas tran vdout1_5ck1080 FIND v(dout1_5) AT=1090.05n

.meas tran vdout1_6ck1080 FIND v(dout1_6) AT=1090.05n

.meas tran vdout1_7ck1080 FIND v(dout1_7) AT=1090.05n

.meas tran vdout1_8ck1080 FIND v(dout1_8) AT=1090.05n

.meas tran vdout1_9ck1080 FIND v(dout1_9) AT=1090.05n

.meas tran vdout1_10ck1080 FIND v(dout1_10) AT=1090.05n

.meas tran vdout1_11ck1080 FIND v(dout1_11) AT=1090.05n

.meas tran vdout1_12ck1080 FIND v(dout1_12) AT=1090.05n

.meas tran vdout1_13ck1080 FIND v(dout1_13) AT=1090.05n

.meas tran vdout1_14ck1080 FIND v(dout1_14) AT=1090.05n

.meas tran vdout1_15ck1080 FIND v(dout1_15) AT=1090.05n

.meas tran vdout1_16ck1080 FIND v(dout1_16) AT=1090.05n

.meas tran vdout1_17ck1080 FIND v(dout1_17) AT=1090.05n

.meas tran vdout1_18ck1080 FIND v(dout1_18) AT=1090.05n

.meas tran vdout1_19ck1080 FIND v(dout1_19) AT=1090.05n

.meas tran vdout1_20ck1080 FIND v(dout1_20) AT=1090.05n

.meas tran vdout1_21ck1080 FIND v(dout1_21) AT=1090.05n

.meas tran vdout1_22ck1080 FIND v(dout1_22) AT=1090.05n

.meas tran vdout1_23ck1080 FIND v(dout1_23) AT=1090.05n

.meas tran vdout1_24ck1080 FIND v(dout1_24) AT=1090.05n

.meas tran vdout1_25ck1080 FIND v(dout1_25) AT=1090.05n

.meas tran vdout1_26ck1080 FIND v(dout1_26) AT=1090.05n

.meas tran vdout1_27ck1080 FIND v(dout1_27) AT=1090.05n

.meas tran vdout1_28ck1080 FIND v(dout1_28) AT=1090.05n

.meas tran vdout1_29ck1080 FIND v(dout1_29) AT=1090.05n

.meas tran vdout1_30ck1080 FIND v(dout1_30) AT=1090.05n

.meas tran vdout1_31ck1080 FIND v(dout1_31) AT=1090.05n

.meas tran vdout1_0ck1100 FIND v(dout1_0) AT=1110.05n

.meas tran vdout1_1ck1100 FIND v(dout1_1) AT=1110.05n

.meas tran vdout1_2ck1100 FIND v(dout1_2) AT=1110.05n

.meas tran vdout1_3ck1100 FIND v(dout1_3) AT=1110.05n

.meas tran vdout1_4ck1100 FIND v(dout1_4) AT=1110.05n

.meas tran vdout1_5ck1100 FIND v(dout1_5) AT=1110.05n

.meas tran vdout1_6ck1100 FIND v(dout1_6) AT=1110.05n

.meas tran vdout1_7ck1100 FIND v(dout1_7) AT=1110.05n

.meas tran vdout1_8ck1100 FIND v(dout1_8) AT=1110.05n

.meas tran vdout1_9ck1100 FIND v(dout1_9) AT=1110.05n

.meas tran vdout1_10ck1100 FIND v(dout1_10) AT=1110.05n

.meas tran vdout1_11ck1100 FIND v(dout1_11) AT=1110.05n

.meas tran vdout1_12ck1100 FIND v(dout1_12) AT=1110.05n

.meas tran vdout1_13ck1100 FIND v(dout1_13) AT=1110.05n

.meas tran vdout1_14ck1100 FIND v(dout1_14) AT=1110.05n

.meas tran vdout1_15ck1100 FIND v(dout1_15) AT=1110.05n

.meas tran vdout1_16ck1100 FIND v(dout1_16) AT=1110.05n

.meas tran vdout1_17ck1100 FIND v(dout1_17) AT=1110.05n

.meas tran vdout1_18ck1100 FIND v(dout1_18) AT=1110.05n

.meas tran vdout1_19ck1100 FIND v(dout1_19) AT=1110.05n

.meas tran vdout1_20ck1100 FIND v(dout1_20) AT=1110.05n

.meas tran vdout1_21ck1100 FIND v(dout1_21) AT=1110.05n

.meas tran vdout1_22ck1100 FIND v(dout1_22) AT=1110.05n

.meas tran vdout1_23ck1100 FIND v(dout1_23) AT=1110.05n

.meas tran vdout1_24ck1100 FIND v(dout1_24) AT=1110.05n

.meas tran vdout1_25ck1100 FIND v(dout1_25) AT=1110.05n

.meas tran vdout1_26ck1100 FIND v(dout1_26) AT=1110.05n

.meas tran vdout1_27ck1100 FIND v(dout1_27) AT=1110.05n

.meas tran vdout1_28ck1100 FIND v(dout1_28) AT=1110.05n

.meas tran vdout1_29ck1100 FIND v(dout1_29) AT=1110.05n

.meas tran vdout1_30ck1100 FIND v(dout1_30) AT=1110.05n

.meas tran vdout1_31ck1100 FIND v(dout1_31) AT=1110.05n

.meas tran vdout0_0ck1120 FIND v(dout0_0) AT=1130.05n

.meas tran vdout0_1ck1120 FIND v(dout0_1) AT=1130.05n

.meas tran vdout0_2ck1120 FIND v(dout0_2) AT=1130.05n

.meas tran vdout0_3ck1120 FIND v(dout0_3) AT=1130.05n

.meas tran vdout0_4ck1120 FIND v(dout0_4) AT=1130.05n

.meas tran vdout0_5ck1120 FIND v(dout0_5) AT=1130.05n

.meas tran vdout0_6ck1120 FIND v(dout0_6) AT=1130.05n

.meas tran vdout0_7ck1120 FIND v(dout0_7) AT=1130.05n

.meas tran vdout0_8ck1120 FIND v(dout0_8) AT=1130.05n

.meas tran vdout0_9ck1120 FIND v(dout0_9) AT=1130.05n

.meas tran vdout0_10ck1120 FIND v(dout0_10) AT=1130.05n

.meas tran vdout0_11ck1120 FIND v(dout0_11) AT=1130.05n

.meas tran vdout0_12ck1120 FIND v(dout0_12) AT=1130.05n

.meas tran vdout0_13ck1120 FIND v(dout0_13) AT=1130.05n

.meas tran vdout0_14ck1120 FIND v(dout0_14) AT=1130.05n

.meas tran vdout0_15ck1120 FIND v(dout0_15) AT=1130.05n

.meas tran vdout0_16ck1120 FIND v(dout0_16) AT=1130.05n

.meas tran vdout0_17ck1120 FIND v(dout0_17) AT=1130.05n

.meas tran vdout0_18ck1120 FIND v(dout0_18) AT=1130.05n

.meas tran vdout0_19ck1120 FIND v(dout0_19) AT=1130.05n

.meas tran vdout0_20ck1120 FIND v(dout0_20) AT=1130.05n

.meas tran vdout0_21ck1120 FIND v(dout0_21) AT=1130.05n

.meas tran vdout0_22ck1120 FIND v(dout0_22) AT=1130.05n

.meas tran vdout0_23ck1120 FIND v(dout0_23) AT=1130.05n

.meas tran vdout0_24ck1120 FIND v(dout0_24) AT=1130.05n

.meas tran vdout0_25ck1120 FIND v(dout0_25) AT=1130.05n

.meas tran vdout0_26ck1120 FIND v(dout0_26) AT=1130.05n

.meas tran vdout0_27ck1120 FIND v(dout0_27) AT=1130.05n

.meas tran vdout0_28ck1120 FIND v(dout0_28) AT=1130.05n

.meas tran vdout0_29ck1120 FIND v(dout0_29) AT=1130.05n

.meas tran vdout0_30ck1120 FIND v(dout0_30) AT=1130.05n

.meas tran vdout0_31ck1120 FIND v(dout0_31) AT=1130.05n

.meas tran vdout1_0ck1120 FIND v(dout1_0) AT=1130.05n

.meas tran vdout1_1ck1120 FIND v(dout1_1) AT=1130.05n

.meas tran vdout1_2ck1120 FIND v(dout1_2) AT=1130.05n

.meas tran vdout1_3ck1120 FIND v(dout1_3) AT=1130.05n

.meas tran vdout1_4ck1120 FIND v(dout1_4) AT=1130.05n

.meas tran vdout1_5ck1120 FIND v(dout1_5) AT=1130.05n

.meas tran vdout1_6ck1120 FIND v(dout1_6) AT=1130.05n

.meas tran vdout1_7ck1120 FIND v(dout1_7) AT=1130.05n

.meas tran vdout1_8ck1120 FIND v(dout1_8) AT=1130.05n

.meas tran vdout1_9ck1120 FIND v(dout1_9) AT=1130.05n

.meas tran vdout1_10ck1120 FIND v(dout1_10) AT=1130.05n

.meas tran vdout1_11ck1120 FIND v(dout1_11) AT=1130.05n

.meas tran vdout1_12ck1120 FIND v(dout1_12) AT=1130.05n

.meas tran vdout1_13ck1120 FIND v(dout1_13) AT=1130.05n

.meas tran vdout1_14ck1120 FIND v(dout1_14) AT=1130.05n

.meas tran vdout1_15ck1120 FIND v(dout1_15) AT=1130.05n

.meas tran vdout1_16ck1120 FIND v(dout1_16) AT=1130.05n

.meas tran vdout1_17ck1120 FIND v(dout1_17) AT=1130.05n

.meas tran vdout1_18ck1120 FIND v(dout1_18) AT=1130.05n

.meas tran vdout1_19ck1120 FIND v(dout1_19) AT=1130.05n

.meas tran vdout1_20ck1120 FIND v(dout1_20) AT=1130.05n

.meas tran vdout1_21ck1120 FIND v(dout1_21) AT=1130.05n

.meas tran vdout1_22ck1120 FIND v(dout1_22) AT=1130.05n

.meas tran vdout1_23ck1120 FIND v(dout1_23) AT=1130.05n

.meas tran vdout1_24ck1120 FIND v(dout1_24) AT=1130.05n

.meas tran vdout1_25ck1120 FIND v(dout1_25) AT=1130.05n

.meas tran vdout1_26ck1120 FIND v(dout1_26) AT=1130.05n

.meas tran vdout1_27ck1120 FIND v(dout1_27) AT=1130.05n

.meas tran vdout1_28ck1120 FIND v(dout1_28) AT=1130.05n

.meas tran vdout1_29ck1120 FIND v(dout1_29) AT=1130.05n

.meas tran vdout1_30ck1120 FIND v(dout1_30) AT=1130.05n

.meas tran vdout1_31ck1120 FIND v(dout1_31) AT=1130.05n

.meas tran vdout0_0ck1130 FIND v(dout0_0) AT=1140.05n

.meas tran vdout0_1ck1130 FIND v(dout0_1) AT=1140.05n

.meas tran vdout0_2ck1130 FIND v(dout0_2) AT=1140.05n

.meas tran vdout0_3ck1130 FIND v(dout0_3) AT=1140.05n

.meas tran vdout0_4ck1130 FIND v(dout0_4) AT=1140.05n

.meas tran vdout0_5ck1130 FIND v(dout0_5) AT=1140.05n

.meas tran vdout0_6ck1130 FIND v(dout0_6) AT=1140.05n

.meas tran vdout0_7ck1130 FIND v(dout0_7) AT=1140.05n

.meas tran vdout0_8ck1130 FIND v(dout0_8) AT=1140.05n

.meas tran vdout0_9ck1130 FIND v(dout0_9) AT=1140.05n

.meas tran vdout0_10ck1130 FIND v(dout0_10) AT=1140.05n

.meas tran vdout0_11ck1130 FIND v(dout0_11) AT=1140.05n

.meas tran vdout0_12ck1130 FIND v(dout0_12) AT=1140.05n

.meas tran vdout0_13ck1130 FIND v(dout0_13) AT=1140.05n

.meas tran vdout0_14ck1130 FIND v(dout0_14) AT=1140.05n

.meas tran vdout0_15ck1130 FIND v(dout0_15) AT=1140.05n

.meas tran vdout0_16ck1130 FIND v(dout0_16) AT=1140.05n

.meas tran vdout0_17ck1130 FIND v(dout0_17) AT=1140.05n

.meas tran vdout0_18ck1130 FIND v(dout0_18) AT=1140.05n

.meas tran vdout0_19ck1130 FIND v(dout0_19) AT=1140.05n

.meas tran vdout0_20ck1130 FIND v(dout0_20) AT=1140.05n

.meas tran vdout0_21ck1130 FIND v(dout0_21) AT=1140.05n

.meas tran vdout0_22ck1130 FIND v(dout0_22) AT=1140.05n

.meas tran vdout0_23ck1130 FIND v(dout0_23) AT=1140.05n

.meas tran vdout0_24ck1130 FIND v(dout0_24) AT=1140.05n

.meas tran vdout0_25ck1130 FIND v(dout0_25) AT=1140.05n

.meas tran vdout0_26ck1130 FIND v(dout0_26) AT=1140.05n

.meas tran vdout0_27ck1130 FIND v(dout0_27) AT=1140.05n

.meas tran vdout0_28ck1130 FIND v(dout0_28) AT=1140.05n

.meas tran vdout0_29ck1130 FIND v(dout0_29) AT=1140.05n

.meas tran vdout0_30ck1130 FIND v(dout0_30) AT=1140.05n

.meas tran vdout0_31ck1130 FIND v(dout0_31) AT=1140.05n

.meas tran vdout1_0ck1130 FIND v(dout1_0) AT=1140.05n

.meas tran vdout1_1ck1130 FIND v(dout1_1) AT=1140.05n

.meas tran vdout1_2ck1130 FIND v(dout1_2) AT=1140.05n

.meas tran vdout1_3ck1130 FIND v(dout1_3) AT=1140.05n

.meas tran vdout1_4ck1130 FIND v(dout1_4) AT=1140.05n

.meas tran vdout1_5ck1130 FIND v(dout1_5) AT=1140.05n

.meas tran vdout1_6ck1130 FIND v(dout1_6) AT=1140.05n

.meas tran vdout1_7ck1130 FIND v(dout1_7) AT=1140.05n

.meas tran vdout1_8ck1130 FIND v(dout1_8) AT=1140.05n

.meas tran vdout1_9ck1130 FIND v(dout1_9) AT=1140.05n

.meas tran vdout1_10ck1130 FIND v(dout1_10) AT=1140.05n

.meas tran vdout1_11ck1130 FIND v(dout1_11) AT=1140.05n

.meas tran vdout1_12ck1130 FIND v(dout1_12) AT=1140.05n

.meas tran vdout1_13ck1130 FIND v(dout1_13) AT=1140.05n

.meas tran vdout1_14ck1130 FIND v(dout1_14) AT=1140.05n

.meas tran vdout1_15ck1130 FIND v(dout1_15) AT=1140.05n

.meas tran vdout1_16ck1130 FIND v(dout1_16) AT=1140.05n

.meas tran vdout1_17ck1130 FIND v(dout1_17) AT=1140.05n

.meas tran vdout1_18ck1130 FIND v(dout1_18) AT=1140.05n

.meas tran vdout1_19ck1130 FIND v(dout1_19) AT=1140.05n

.meas tran vdout1_20ck1130 FIND v(dout1_20) AT=1140.05n

.meas tran vdout1_21ck1130 FIND v(dout1_21) AT=1140.05n

.meas tran vdout1_22ck1130 FIND v(dout1_22) AT=1140.05n

.meas tran vdout1_23ck1130 FIND v(dout1_23) AT=1140.05n

.meas tran vdout1_24ck1130 FIND v(dout1_24) AT=1140.05n

.meas tran vdout1_25ck1130 FIND v(dout1_25) AT=1140.05n

.meas tran vdout1_26ck1130 FIND v(dout1_26) AT=1140.05n

.meas tran vdout1_27ck1130 FIND v(dout1_27) AT=1140.05n

.meas tran vdout1_28ck1130 FIND v(dout1_28) AT=1140.05n

.meas tran vdout1_29ck1130 FIND v(dout1_29) AT=1140.05n

.meas tran vdout1_30ck1130 FIND v(dout1_30) AT=1140.05n

.meas tran vdout1_31ck1130 FIND v(dout1_31) AT=1140.05n

.meas tran vdout0_0ck1140 FIND v(dout0_0) AT=1150.05n

.meas tran vdout0_1ck1140 FIND v(dout0_1) AT=1150.05n

.meas tran vdout0_2ck1140 FIND v(dout0_2) AT=1150.05n

.meas tran vdout0_3ck1140 FIND v(dout0_3) AT=1150.05n

.meas tran vdout0_4ck1140 FIND v(dout0_4) AT=1150.05n

.meas tran vdout0_5ck1140 FIND v(dout0_5) AT=1150.05n

.meas tran vdout0_6ck1140 FIND v(dout0_6) AT=1150.05n

.meas tran vdout0_7ck1140 FIND v(dout0_7) AT=1150.05n

.meas tran vdout0_8ck1140 FIND v(dout0_8) AT=1150.05n

.meas tran vdout0_9ck1140 FIND v(dout0_9) AT=1150.05n

.meas tran vdout0_10ck1140 FIND v(dout0_10) AT=1150.05n

.meas tran vdout0_11ck1140 FIND v(dout0_11) AT=1150.05n

.meas tran vdout0_12ck1140 FIND v(dout0_12) AT=1150.05n

.meas tran vdout0_13ck1140 FIND v(dout0_13) AT=1150.05n

.meas tran vdout0_14ck1140 FIND v(dout0_14) AT=1150.05n

.meas tran vdout0_15ck1140 FIND v(dout0_15) AT=1150.05n

.meas tran vdout0_16ck1140 FIND v(dout0_16) AT=1150.05n

.meas tran vdout0_17ck1140 FIND v(dout0_17) AT=1150.05n

.meas tran vdout0_18ck1140 FIND v(dout0_18) AT=1150.05n

.meas tran vdout0_19ck1140 FIND v(dout0_19) AT=1150.05n

.meas tran vdout0_20ck1140 FIND v(dout0_20) AT=1150.05n

.meas tran vdout0_21ck1140 FIND v(dout0_21) AT=1150.05n

.meas tran vdout0_22ck1140 FIND v(dout0_22) AT=1150.05n

.meas tran vdout0_23ck1140 FIND v(dout0_23) AT=1150.05n

.meas tran vdout0_24ck1140 FIND v(dout0_24) AT=1150.05n

.meas tran vdout0_25ck1140 FIND v(dout0_25) AT=1150.05n

.meas tran vdout0_26ck1140 FIND v(dout0_26) AT=1150.05n

.meas tran vdout0_27ck1140 FIND v(dout0_27) AT=1150.05n

.meas tran vdout0_28ck1140 FIND v(dout0_28) AT=1150.05n

.meas tran vdout0_29ck1140 FIND v(dout0_29) AT=1150.05n

.meas tran vdout0_30ck1140 FIND v(dout0_30) AT=1150.05n

.meas tran vdout0_31ck1140 FIND v(dout0_31) AT=1150.05n

.meas tran vdout1_0ck1140 FIND v(dout1_0) AT=1150.05n

.meas tran vdout1_1ck1140 FIND v(dout1_1) AT=1150.05n

.meas tran vdout1_2ck1140 FIND v(dout1_2) AT=1150.05n

.meas tran vdout1_3ck1140 FIND v(dout1_3) AT=1150.05n

.meas tran vdout1_4ck1140 FIND v(dout1_4) AT=1150.05n

.meas tran vdout1_5ck1140 FIND v(dout1_5) AT=1150.05n

.meas tran vdout1_6ck1140 FIND v(dout1_6) AT=1150.05n

.meas tran vdout1_7ck1140 FIND v(dout1_7) AT=1150.05n

.meas tran vdout1_8ck1140 FIND v(dout1_8) AT=1150.05n

.meas tran vdout1_9ck1140 FIND v(dout1_9) AT=1150.05n

.meas tran vdout1_10ck1140 FIND v(dout1_10) AT=1150.05n

.meas tran vdout1_11ck1140 FIND v(dout1_11) AT=1150.05n

.meas tran vdout1_12ck1140 FIND v(dout1_12) AT=1150.05n

.meas tran vdout1_13ck1140 FIND v(dout1_13) AT=1150.05n

.meas tran vdout1_14ck1140 FIND v(dout1_14) AT=1150.05n

.meas tran vdout1_15ck1140 FIND v(dout1_15) AT=1150.05n

.meas tran vdout1_16ck1140 FIND v(dout1_16) AT=1150.05n

.meas tran vdout1_17ck1140 FIND v(dout1_17) AT=1150.05n

.meas tran vdout1_18ck1140 FIND v(dout1_18) AT=1150.05n

.meas tran vdout1_19ck1140 FIND v(dout1_19) AT=1150.05n

.meas tran vdout1_20ck1140 FIND v(dout1_20) AT=1150.05n

.meas tran vdout1_21ck1140 FIND v(dout1_21) AT=1150.05n

.meas tran vdout1_22ck1140 FIND v(dout1_22) AT=1150.05n

.meas tran vdout1_23ck1140 FIND v(dout1_23) AT=1150.05n

.meas tran vdout1_24ck1140 FIND v(dout1_24) AT=1150.05n

.meas tran vdout1_25ck1140 FIND v(dout1_25) AT=1150.05n

.meas tran vdout1_26ck1140 FIND v(dout1_26) AT=1150.05n

.meas tran vdout1_27ck1140 FIND v(dout1_27) AT=1150.05n

.meas tran vdout1_28ck1140 FIND v(dout1_28) AT=1150.05n

.meas tran vdout1_29ck1140 FIND v(dout1_29) AT=1150.05n

.meas tran vdout1_30ck1140 FIND v(dout1_30) AT=1150.05n

.meas tran vdout1_31ck1140 FIND v(dout1_31) AT=1150.05n

.meas tran vdout1_0ck1160 FIND v(dout1_0) AT=1170.05n

.meas tran vdout1_1ck1160 FIND v(dout1_1) AT=1170.05n

.meas tran vdout1_2ck1160 FIND v(dout1_2) AT=1170.05n

.meas tran vdout1_3ck1160 FIND v(dout1_3) AT=1170.05n

.meas tran vdout1_4ck1160 FIND v(dout1_4) AT=1170.05n

.meas tran vdout1_5ck1160 FIND v(dout1_5) AT=1170.05n

.meas tran vdout1_6ck1160 FIND v(dout1_6) AT=1170.05n

.meas tran vdout1_7ck1160 FIND v(dout1_7) AT=1170.05n

.meas tran vdout1_8ck1160 FIND v(dout1_8) AT=1170.05n

.meas tran vdout1_9ck1160 FIND v(dout1_9) AT=1170.05n

.meas tran vdout1_10ck1160 FIND v(dout1_10) AT=1170.05n

.meas tran vdout1_11ck1160 FIND v(dout1_11) AT=1170.05n

.meas tran vdout1_12ck1160 FIND v(dout1_12) AT=1170.05n

.meas tran vdout1_13ck1160 FIND v(dout1_13) AT=1170.05n

.meas tran vdout1_14ck1160 FIND v(dout1_14) AT=1170.05n

.meas tran vdout1_15ck1160 FIND v(dout1_15) AT=1170.05n

.meas tran vdout1_16ck1160 FIND v(dout1_16) AT=1170.05n

.meas tran vdout1_17ck1160 FIND v(dout1_17) AT=1170.05n

.meas tran vdout1_18ck1160 FIND v(dout1_18) AT=1170.05n

.meas tran vdout1_19ck1160 FIND v(dout1_19) AT=1170.05n

.meas tran vdout1_20ck1160 FIND v(dout1_20) AT=1170.05n

.meas tran vdout1_21ck1160 FIND v(dout1_21) AT=1170.05n

.meas tran vdout1_22ck1160 FIND v(dout1_22) AT=1170.05n

.meas tran vdout1_23ck1160 FIND v(dout1_23) AT=1170.05n

.meas tran vdout1_24ck1160 FIND v(dout1_24) AT=1170.05n

.meas tran vdout1_25ck1160 FIND v(dout1_25) AT=1170.05n

.meas tran vdout1_26ck1160 FIND v(dout1_26) AT=1170.05n

.meas tran vdout1_27ck1160 FIND v(dout1_27) AT=1170.05n

.meas tran vdout1_28ck1160 FIND v(dout1_28) AT=1170.05n

.meas tran vdout1_29ck1160 FIND v(dout1_29) AT=1170.05n

.meas tran vdout1_30ck1160 FIND v(dout1_30) AT=1170.05n

.meas tran vdout1_31ck1160 FIND v(dout1_31) AT=1170.05n

.meas tran vdout1_0ck1170 FIND v(dout1_0) AT=1180.05n

.meas tran vdout1_1ck1170 FIND v(dout1_1) AT=1180.05n

.meas tran vdout1_2ck1170 FIND v(dout1_2) AT=1180.05n

.meas tran vdout1_3ck1170 FIND v(dout1_3) AT=1180.05n

.meas tran vdout1_4ck1170 FIND v(dout1_4) AT=1180.05n

.meas tran vdout1_5ck1170 FIND v(dout1_5) AT=1180.05n

.meas tran vdout1_6ck1170 FIND v(dout1_6) AT=1180.05n

.meas tran vdout1_7ck1170 FIND v(dout1_7) AT=1180.05n

.meas tran vdout1_8ck1170 FIND v(dout1_8) AT=1180.05n

.meas tran vdout1_9ck1170 FIND v(dout1_9) AT=1180.05n

.meas tran vdout1_10ck1170 FIND v(dout1_10) AT=1180.05n

.meas tran vdout1_11ck1170 FIND v(dout1_11) AT=1180.05n

.meas tran vdout1_12ck1170 FIND v(dout1_12) AT=1180.05n

.meas tran vdout1_13ck1170 FIND v(dout1_13) AT=1180.05n

.meas tran vdout1_14ck1170 FIND v(dout1_14) AT=1180.05n

.meas tran vdout1_15ck1170 FIND v(dout1_15) AT=1180.05n

.meas tran vdout1_16ck1170 FIND v(dout1_16) AT=1180.05n

.meas tran vdout1_17ck1170 FIND v(dout1_17) AT=1180.05n

.meas tran vdout1_18ck1170 FIND v(dout1_18) AT=1180.05n

.meas tran vdout1_19ck1170 FIND v(dout1_19) AT=1180.05n

.meas tran vdout1_20ck1170 FIND v(dout1_20) AT=1180.05n

.meas tran vdout1_21ck1170 FIND v(dout1_21) AT=1180.05n

.meas tran vdout1_22ck1170 FIND v(dout1_22) AT=1180.05n

.meas tran vdout1_23ck1170 FIND v(dout1_23) AT=1180.05n

.meas tran vdout1_24ck1170 FIND v(dout1_24) AT=1180.05n

.meas tran vdout1_25ck1170 FIND v(dout1_25) AT=1180.05n

.meas tran vdout1_26ck1170 FIND v(dout1_26) AT=1180.05n

.meas tran vdout1_27ck1170 FIND v(dout1_27) AT=1180.05n

.meas tran vdout1_28ck1170 FIND v(dout1_28) AT=1180.05n

.meas tran vdout1_29ck1170 FIND v(dout1_29) AT=1180.05n

.meas tran vdout1_30ck1170 FIND v(dout1_30) AT=1180.05n

.meas tran vdout1_31ck1170 FIND v(dout1_31) AT=1180.05n

.meas tran vdout1_0ck1190 FIND v(dout1_0) AT=1200.05n

.meas tran vdout1_1ck1190 FIND v(dout1_1) AT=1200.05n

.meas tran vdout1_2ck1190 FIND v(dout1_2) AT=1200.05n

.meas tran vdout1_3ck1190 FIND v(dout1_3) AT=1200.05n

.meas tran vdout1_4ck1190 FIND v(dout1_4) AT=1200.05n

.meas tran vdout1_5ck1190 FIND v(dout1_5) AT=1200.05n

.meas tran vdout1_6ck1190 FIND v(dout1_6) AT=1200.05n

.meas tran vdout1_7ck1190 FIND v(dout1_7) AT=1200.05n

.meas tran vdout1_8ck1190 FIND v(dout1_8) AT=1200.05n

.meas tran vdout1_9ck1190 FIND v(dout1_9) AT=1200.05n

.meas tran vdout1_10ck1190 FIND v(dout1_10) AT=1200.05n

.meas tran vdout1_11ck1190 FIND v(dout1_11) AT=1200.05n

.meas tran vdout1_12ck1190 FIND v(dout1_12) AT=1200.05n

.meas tran vdout1_13ck1190 FIND v(dout1_13) AT=1200.05n

.meas tran vdout1_14ck1190 FIND v(dout1_14) AT=1200.05n

.meas tran vdout1_15ck1190 FIND v(dout1_15) AT=1200.05n

.meas tran vdout1_16ck1190 FIND v(dout1_16) AT=1200.05n

.meas tran vdout1_17ck1190 FIND v(dout1_17) AT=1200.05n

.meas tran vdout1_18ck1190 FIND v(dout1_18) AT=1200.05n

.meas tran vdout1_19ck1190 FIND v(dout1_19) AT=1200.05n

.meas tran vdout1_20ck1190 FIND v(dout1_20) AT=1200.05n

.meas tran vdout1_21ck1190 FIND v(dout1_21) AT=1200.05n

.meas tran vdout1_22ck1190 FIND v(dout1_22) AT=1200.05n

.meas tran vdout1_23ck1190 FIND v(dout1_23) AT=1200.05n

.meas tran vdout1_24ck1190 FIND v(dout1_24) AT=1200.05n

.meas tran vdout1_25ck1190 FIND v(dout1_25) AT=1200.05n

.meas tran vdout1_26ck1190 FIND v(dout1_26) AT=1200.05n

.meas tran vdout1_27ck1190 FIND v(dout1_27) AT=1200.05n

.meas tran vdout1_28ck1190 FIND v(dout1_28) AT=1200.05n

.meas tran vdout1_29ck1190 FIND v(dout1_29) AT=1200.05n

.meas tran vdout1_30ck1190 FIND v(dout1_30) AT=1200.05n

.meas tran vdout1_31ck1190 FIND v(dout1_31) AT=1200.05n

.meas tran vdout1_0ck1200 FIND v(dout1_0) AT=1210.05n

.meas tran vdout1_1ck1200 FIND v(dout1_1) AT=1210.05n

.meas tran vdout1_2ck1200 FIND v(dout1_2) AT=1210.05n

.meas tran vdout1_3ck1200 FIND v(dout1_3) AT=1210.05n

.meas tran vdout1_4ck1200 FIND v(dout1_4) AT=1210.05n

.meas tran vdout1_5ck1200 FIND v(dout1_5) AT=1210.05n

.meas tran vdout1_6ck1200 FIND v(dout1_6) AT=1210.05n

.meas tran vdout1_7ck1200 FIND v(dout1_7) AT=1210.05n

.meas tran vdout1_8ck1200 FIND v(dout1_8) AT=1210.05n

.meas tran vdout1_9ck1200 FIND v(dout1_9) AT=1210.05n

.meas tran vdout1_10ck1200 FIND v(dout1_10) AT=1210.05n

.meas tran vdout1_11ck1200 FIND v(dout1_11) AT=1210.05n

.meas tran vdout1_12ck1200 FIND v(dout1_12) AT=1210.05n

.meas tran vdout1_13ck1200 FIND v(dout1_13) AT=1210.05n

.meas tran vdout1_14ck1200 FIND v(dout1_14) AT=1210.05n

.meas tran vdout1_15ck1200 FIND v(dout1_15) AT=1210.05n

.meas tran vdout1_16ck1200 FIND v(dout1_16) AT=1210.05n

.meas tran vdout1_17ck1200 FIND v(dout1_17) AT=1210.05n

.meas tran vdout1_18ck1200 FIND v(dout1_18) AT=1210.05n

.meas tran vdout1_19ck1200 FIND v(dout1_19) AT=1210.05n

.meas tran vdout1_20ck1200 FIND v(dout1_20) AT=1210.05n

.meas tran vdout1_21ck1200 FIND v(dout1_21) AT=1210.05n

.meas tran vdout1_22ck1200 FIND v(dout1_22) AT=1210.05n

.meas tran vdout1_23ck1200 FIND v(dout1_23) AT=1210.05n

.meas tran vdout1_24ck1200 FIND v(dout1_24) AT=1210.05n

.meas tran vdout1_25ck1200 FIND v(dout1_25) AT=1210.05n

.meas tran vdout1_26ck1200 FIND v(dout1_26) AT=1210.05n

.meas tran vdout1_27ck1200 FIND v(dout1_27) AT=1210.05n

.meas tran vdout1_28ck1200 FIND v(dout1_28) AT=1210.05n

.meas tran vdout1_29ck1200 FIND v(dout1_29) AT=1210.05n

.meas tran vdout1_30ck1200 FIND v(dout1_30) AT=1210.05n

.meas tran vdout1_31ck1200 FIND v(dout1_31) AT=1210.05n

.meas tran vdout0_0ck1210 FIND v(dout0_0) AT=1220.05n

.meas tran vdout0_1ck1210 FIND v(dout0_1) AT=1220.05n

.meas tran vdout0_2ck1210 FIND v(dout0_2) AT=1220.05n

.meas tran vdout0_3ck1210 FIND v(dout0_3) AT=1220.05n

.meas tran vdout0_4ck1210 FIND v(dout0_4) AT=1220.05n

.meas tran vdout0_5ck1210 FIND v(dout0_5) AT=1220.05n

.meas tran vdout0_6ck1210 FIND v(dout0_6) AT=1220.05n

.meas tran vdout0_7ck1210 FIND v(dout0_7) AT=1220.05n

.meas tran vdout0_8ck1210 FIND v(dout0_8) AT=1220.05n

.meas tran vdout0_9ck1210 FIND v(dout0_9) AT=1220.05n

.meas tran vdout0_10ck1210 FIND v(dout0_10) AT=1220.05n

.meas tran vdout0_11ck1210 FIND v(dout0_11) AT=1220.05n

.meas tran vdout0_12ck1210 FIND v(dout0_12) AT=1220.05n

.meas tran vdout0_13ck1210 FIND v(dout0_13) AT=1220.05n

.meas tran vdout0_14ck1210 FIND v(dout0_14) AT=1220.05n

.meas tran vdout0_15ck1210 FIND v(dout0_15) AT=1220.05n

.meas tran vdout0_16ck1210 FIND v(dout0_16) AT=1220.05n

.meas tran vdout0_17ck1210 FIND v(dout0_17) AT=1220.05n

.meas tran vdout0_18ck1210 FIND v(dout0_18) AT=1220.05n

.meas tran vdout0_19ck1210 FIND v(dout0_19) AT=1220.05n

.meas tran vdout0_20ck1210 FIND v(dout0_20) AT=1220.05n

.meas tran vdout0_21ck1210 FIND v(dout0_21) AT=1220.05n

.meas tran vdout0_22ck1210 FIND v(dout0_22) AT=1220.05n

.meas tran vdout0_23ck1210 FIND v(dout0_23) AT=1220.05n

.meas tran vdout0_24ck1210 FIND v(dout0_24) AT=1220.05n

.meas tran vdout0_25ck1210 FIND v(dout0_25) AT=1220.05n

.meas tran vdout0_26ck1210 FIND v(dout0_26) AT=1220.05n

.meas tran vdout0_27ck1210 FIND v(dout0_27) AT=1220.05n

.meas tran vdout0_28ck1210 FIND v(dout0_28) AT=1220.05n

.meas tran vdout0_29ck1210 FIND v(dout0_29) AT=1220.05n

.meas tran vdout0_30ck1210 FIND v(dout0_30) AT=1220.05n

.meas tran vdout0_31ck1210 FIND v(dout0_31) AT=1220.05n

.meas tran vdout1_0ck1210 FIND v(dout1_0) AT=1220.05n

.meas tran vdout1_1ck1210 FIND v(dout1_1) AT=1220.05n

.meas tran vdout1_2ck1210 FIND v(dout1_2) AT=1220.05n

.meas tran vdout1_3ck1210 FIND v(dout1_3) AT=1220.05n

.meas tran vdout1_4ck1210 FIND v(dout1_4) AT=1220.05n

.meas tran vdout1_5ck1210 FIND v(dout1_5) AT=1220.05n

.meas tran vdout1_6ck1210 FIND v(dout1_6) AT=1220.05n

.meas tran vdout1_7ck1210 FIND v(dout1_7) AT=1220.05n

.meas tran vdout1_8ck1210 FIND v(dout1_8) AT=1220.05n

.meas tran vdout1_9ck1210 FIND v(dout1_9) AT=1220.05n

.meas tran vdout1_10ck1210 FIND v(dout1_10) AT=1220.05n

.meas tran vdout1_11ck1210 FIND v(dout1_11) AT=1220.05n

.meas tran vdout1_12ck1210 FIND v(dout1_12) AT=1220.05n

.meas tran vdout1_13ck1210 FIND v(dout1_13) AT=1220.05n

.meas tran vdout1_14ck1210 FIND v(dout1_14) AT=1220.05n

.meas tran vdout1_15ck1210 FIND v(dout1_15) AT=1220.05n

.meas tran vdout1_16ck1210 FIND v(dout1_16) AT=1220.05n

.meas tran vdout1_17ck1210 FIND v(dout1_17) AT=1220.05n

.meas tran vdout1_18ck1210 FIND v(dout1_18) AT=1220.05n

.meas tran vdout1_19ck1210 FIND v(dout1_19) AT=1220.05n

.meas tran vdout1_20ck1210 FIND v(dout1_20) AT=1220.05n

.meas tran vdout1_21ck1210 FIND v(dout1_21) AT=1220.05n

.meas tran vdout1_22ck1210 FIND v(dout1_22) AT=1220.05n

.meas tran vdout1_23ck1210 FIND v(dout1_23) AT=1220.05n

.meas tran vdout1_24ck1210 FIND v(dout1_24) AT=1220.05n

.meas tran vdout1_25ck1210 FIND v(dout1_25) AT=1220.05n

.meas tran vdout1_26ck1210 FIND v(dout1_26) AT=1220.05n

.meas tran vdout1_27ck1210 FIND v(dout1_27) AT=1220.05n

.meas tran vdout1_28ck1210 FIND v(dout1_28) AT=1220.05n

.meas tran vdout1_29ck1210 FIND v(dout1_29) AT=1220.05n

.meas tran vdout1_30ck1210 FIND v(dout1_30) AT=1220.05n

.meas tran vdout1_31ck1210 FIND v(dout1_31) AT=1220.05n

.meas tran vdout1_0ck1220 FIND v(dout1_0) AT=1230.05n

.meas tran vdout1_1ck1220 FIND v(dout1_1) AT=1230.05n

.meas tran vdout1_2ck1220 FIND v(dout1_2) AT=1230.05n

.meas tran vdout1_3ck1220 FIND v(dout1_3) AT=1230.05n

.meas tran vdout1_4ck1220 FIND v(dout1_4) AT=1230.05n

.meas tran vdout1_5ck1220 FIND v(dout1_5) AT=1230.05n

.meas tran vdout1_6ck1220 FIND v(dout1_6) AT=1230.05n

.meas tran vdout1_7ck1220 FIND v(dout1_7) AT=1230.05n

.meas tran vdout1_8ck1220 FIND v(dout1_8) AT=1230.05n

.meas tran vdout1_9ck1220 FIND v(dout1_9) AT=1230.05n

.meas tran vdout1_10ck1220 FIND v(dout1_10) AT=1230.05n

.meas tran vdout1_11ck1220 FIND v(dout1_11) AT=1230.05n

.meas tran vdout1_12ck1220 FIND v(dout1_12) AT=1230.05n

.meas tran vdout1_13ck1220 FIND v(dout1_13) AT=1230.05n

.meas tran vdout1_14ck1220 FIND v(dout1_14) AT=1230.05n

.meas tran vdout1_15ck1220 FIND v(dout1_15) AT=1230.05n

.meas tran vdout1_16ck1220 FIND v(dout1_16) AT=1230.05n

.meas tran vdout1_17ck1220 FIND v(dout1_17) AT=1230.05n

.meas tran vdout1_18ck1220 FIND v(dout1_18) AT=1230.05n

.meas tran vdout1_19ck1220 FIND v(dout1_19) AT=1230.05n

.meas tran vdout1_20ck1220 FIND v(dout1_20) AT=1230.05n

.meas tran vdout1_21ck1220 FIND v(dout1_21) AT=1230.05n

.meas tran vdout1_22ck1220 FIND v(dout1_22) AT=1230.05n

.meas tran vdout1_23ck1220 FIND v(dout1_23) AT=1230.05n

.meas tran vdout1_24ck1220 FIND v(dout1_24) AT=1230.05n

.meas tran vdout1_25ck1220 FIND v(dout1_25) AT=1230.05n

.meas tran vdout1_26ck1220 FIND v(dout1_26) AT=1230.05n

.meas tran vdout1_27ck1220 FIND v(dout1_27) AT=1230.05n

.meas tran vdout1_28ck1220 FIND v(dout1_28) AT=1230.05n

.meas tran vdout1_29ck1220 FIND v(dout1_29) AT=1230.05n

.meas tran vdout1_30ck1220 FIND v(dout1_30) AT=1230.05n

.meas tran vdout1_31ck1220 FIND v(dout1_31) AT=1230.05n

.meas tran vdout1_0ck1230 FIND v(dout1_0) AT=1240.05n

.meas tran vdout1_1ck1230 FIND v(dout1_1) AT=1240.05n

.meas tran vdout1_2ck1230 FIND v(dout1_2) AT=1240.05n

.meas tran vdout1_3ck1230 FIND v(dout1_3) AT=1240.05n

.meas tran vdout1_4ck1230 FIND v(dout1_4) AT=1240.05n

.meas tran vdout1_5ck1230 FIND v(dout1_5) AT=1240.05n

.meas tran vdout1_6ck1230 FIND v(dout1_6) AT=1240.05n

.meas tran vdout1_7ck1230 FIND v(dout1_7) AT=1240.05n

.meas tran vdout1_8ck1230 FIND v(dout1_8) AT=1240.05n

.meas tran vdout1_9ck1230 FIND v(dout1_9) AT=1240.05n

.meas tran vdout1_10ck1230 FIND v(dout1_10) AT=1240.05n

.meas tran vdout1_11ck1230 FIND v(dout1_11) AT=1240.05n

.meas tran vdout1_12ck1230 FIND v(dout1_12) AT=1240.05n

.meas tran vdout1_13ck1230 FIND v(dout1_13) AT=1240.05n

.meas tran vdout1_14ck1230 FIND v(dout1_14) AT=1240.05n

.meas tran vdout1_15ck1230 FIND v(dout1_15) AT=1240.05n

.meas tran vdout1_16ck1230 FIND v(dout1_16) AT=1240.05n

.meas tran vdout1_17ck1230 FIND v(dout1_17) AT=1240.05n

.meas tran vdout1_18ck1230 FIND v(dout1_18) AT=1240.05n

.meas tran vdout1_19ck1230 FIND v(dout1_19) AT=1240.05n

.meas tran vdout1_20ck1230 FIND v(dout1_20) AT=1240.05n

.meas tran vdout1_21ck1230 FIND v(dout1_21) AT=1240.05n

.meas tran vdout1_22ck1230 FIND v(dout1_22) AT=1240.05n

.meas tran vdout1_23ck1230 FIND v(dout1_23) AT=1240.05n

.meas tran vdout1_24ck1230 FIND v(dout1_24) AT=1240.05n

.meas tran vdout1_25ck1230 FIND v(dout1_25) AT=1240.05n

.meas tran vdout1_26ck1230 FIND v(dout1_26) AT=1240.05n

.meas tran vdout1_27ck1230 FIND v(dout1_27) AT=1240.05n

.meas tran vdout1_28ck1230 FIND v(dout1_28) AT=1240.05n

.meas tran vdout1_29ck1230 FIND v(dout1_29) AT=1240.05n

.meas tran vdout1_30ck1230 FIND v(dout1_30) AT=1240.05n

.meas tran vdout1_31ck1230 FIND v(dout1_31) AT=1240.05n

.meas tran vdout1_0ck1240 FIND v(dout1_0) AT=1250.05n

.meas tran vdout1_1ck1240 FIND v(dout1_1) AT=1250.05n

.meas tran vdout1_2ck1240 FIND v(dout1_2) AT=1250.05n

.meas tran vdout1_3ck1240 FIND v(dout1_3) AT=1250.05n

.meas tran vdout1_4ck1240 FIND v(dout1_4) AT=1250.05n

.meas tran vdout1_5ck1240 FIND v(dout1_5) AT=1250.05n

.meas tran vdout1_6ck1240 FIND v(dout1_6) AT=1250.05n

.meas tran vdout1_7ck1240 FIND v(dout1_7) AT=1250.05n

.meas tran vdout1_8ck1240 FIND v(dout1_8) AT=1250.05n

.meas tran vdout1_9ck1240 FIND v(dout1_9) AT=1250.05n

.meas tran vdout1_10ck1240 FIND v(dout1_10) AT=1250.05n

.meas tran vdout1_11ck1240 FIND v(dout1_11) AT=1250.05n

.meas tran vdout1_12ck1240 FIND v(dout1_12) AT=1250.05n

.meas tran vdout1_13ck1240 FIND v(dout1_13) AT=1250.05n

.meas tran vdout1_14ck1240 FIND v(dout1_14) AT=1250.05n

.meas tran vdout1_15ck1240 FIND v(dout1_15) AT=1250.05n

.meas tran vdout1_16ck1240 FIND v(dout1_16) AT=1250.05n

.meas tran vdout1_17ck1240 FIND v(dout1_17) AT=1250.05n

.meas tran vdout1_18ck1240 FIND v(dout1_18) AT=1250.05n

.meas tran vdout1_19ck1240 FIND v(dout1_19) AT=1250.05n

.meas tran vdout1_20ck1240 FIND v(dout1_20) AT=1250.05n

.meas tran vdout1_21ck1240 FIND v(dout1_21) AT=1250.05n

.meas tran vdout1_22ck1240 FIND v(dout1_22) AT=1250.05n

.meas tran vdout1_23ck1240 FIND v(dout1_23) AT=1250.05n

.meas tran vdout1_24ck1240 FIND v(dout1_24) AT=1250.05n

.meas tran vdout1_25ck1240 FIND v(dout1_25) AT=1250.05n

.meas tran vdout1_26ck1240 FIND v(dout1_26) AT=1250.05n

.meas tran vdout1_27ck1240 FIND v(dout1_27) AT=1250.05n

.meas tran vdout1_28ck1240 FIND v(dout1_28) AT=1250.05n

.meas tran vdout1_29ck1240 FIND v(dout1_29) AT=1250.05n

.meas tran vdout1_30ck1240 FIND v(dout1_30) AT=1250.05n

.meas tran vdout1_31ck1240 FIND v(dout1_31) AT=1250.05n

.meas tran vdout1_0ck1250 FIND v(dout1_0) AT=1260.05n

.meas tran vdout1_1ck1250 FIND v(dout1_1) AT=1260.05n

.meas tran vdout1_2ck1250 FIND v(dout1_2) AT=1260.05n

.meas tran vdout1_3ck1250 FIND v(dout1_3) AT=1260.05n

.meas tran vdout1_4ck1250 FIND v(dout1_4) AT=1260.05n

.meas tran vdout1_5ck1250 FIND v(dout1_5) AT=1260.05n

.meas tran vdout1_6ck1250 FIND v(dout1_6) AT=1260.05n

.meas tran vdout1_7ck1250 FIND v(dout1_7) AT=1260.05n

.meas tran vdout1_8ck1250 FIND v(dout1_8) AT=1260.05n

.meas tran vdout1_9ck1250 FIND v(dout1_9) AT=1260.05n

.meas tran vdout1_10ck1250 FIND v(dout1_10) AT=1260.05n

.meas tran vdout1_11ck1250 FIND v(dout1_11) AT=1260.05n

.meas tran vdout1_12ck1250 FIND v(dout1_12) AT=1260.05n

.meas tran vdout1_13ck1250 FIND v(dout1_13) AT=1260.05n

.meas tran vdout1_14ck1250 FIND v(dout1_14) AT=1260.05n

.meas tran vdout1_15ck1250 FIND v(dout1_15) AT=1260.05n

.meas tran vdout1_16ck1250 FIND v(dout1_16) AT=1260.05n

.meas tran vdout1_17ck1250 FIND v(dout1_17) AT=1260.05n

.meas tran vdout1_18ck1250 FIND v(dout1_18) AT=1260.05n

.meas tran vdout1_19ck1250 FIND v(dout1_19) AT=1260.05n

.meas tran vdout1_20ck1250 FIND v(dout1_20) AT=1260.05n

.meas tran vdout1_21ck1250 FIND v(dout1_21) AT=1260.05n

.meas tran vdout1_22ck1250 FIND v(dout1_22) AT=1260.05n

.meas tran vdout1_23ck1250 FIND v(dout1_23) AT=1260.05n

.meas tran vdout1_24ck1250 FIND v(dout1_24) AT=1260.05n

.meas tran vdout1_25ck1250 FIND v(dout1_25) AT=1260.05n

.meas tran vdout1_26ck1250 FIND v(dout1_26) AT=1260.05n

.meas tran vdout1_27ck1250 FIND v(dout1_27) AT=1260.05n

.meas tran vdout1_28ck1250 FIND v(dout1_28) AT=1260.05n

.meas tran vdout1_29ck1250 FIND v(dout1_29) AT=1260.05n

.meas tran vdout1_30ck1250 FIND v(dout1_30) AT=1260.05n

.meas tran vdout1_31ck1250 FIND v(dout1_31) AT=1260.05n

.meas tran vdout0_0ck1260 FIND v(dout0_0) AT=1270.05n

.meas tran vdout0_1ck1260 FIND v(dout0_1) AT=1270.05n

.meas tran vdout0_2ck1260 FIND v(dout0_2) AT=1270.05n

.meas tran vdout0_3ck1260 FIND v(dout0_3) AT=1270.05n

.meas tran vdout0_4ck1260 FIND v(dout0_4) AT=1270.05n

.meas tran vdout0_5ck1260 FIND v(dout0_5) AT=1270.05n

.meas tran vdout0_6ck1260 FIND v(dout0_6) AT=1270.05n

.meas tran vdout0_7ck1260 FIND v(dout0_7) AT=1270.05n

.meas tran vdout0_8ck1260 FIND v(dout0_8) AT=1270.05n

.meas tran vdout0_9ck1260 FIND v(dout0_9) AT=1270.05n

.meas tran vdout0_10ck1260 FIND v(dout0_10) AT=1270.05n

.meas tran vdout0_11ck1260 FIND v(dout0_11) AT=1270.05n

.meas tran vdout0_12ck1260 FIND v(dout0_12) AT=1270.05n

.meas tran vdout0_13ck1260 FIND v(dout0_13) AT=1270.05n

.meas tran vdout0_14ck1260 FIND v(dout0_14) AT=1270.05n

.meas tran vdout0_15ck1260 FIND v(dout0_15) AT=1270.05n

.meas tran vdout0_16ck1260 FIND v(dout0_16) AT=1270.05n

.meas tran vdout0_17ck1260 FIND v(dout0_17) AT=1270.05n

.meas tran vdout0_18ck1260 FIND v(dout0_18) AT=1270.05n

.meas tran vdout0_19ck1260 FIND v(dout0_19) AT=1270.05n

.meas tran vdout0_20ck1260 FIND v(dout0_20) AT=1270.05n

.meas tran vdout0_21ck1260 FIND v(dout0_21) AT=1270.05n

.meas tran vdout0_22ck1260 FIND v(dout0_22) AT=1270.05n

.meas tran vdout0_23ck1260 FIND v(dout0_23) AT=1270.05n

.meas tran vdout0_24ck1260 FIND v(dout0_24) AT=1270.05n

.meas tran vdout0_25ck1260 FIND v(dout0_25) AT=1270.05n

.meas tran vdout0_26ck1260 FIND v(dout0_26) AT=1270.05n

.meas tran vdout0_27ck1260 FIND v(dout0_27) AT=1270.05n

.meas tran vdout0_28ck1260 FIND v(dout0_28) AT=1270.05n

.meas tran vdout0_29ck1260 FIND v(dout0_29) AT=1270.05n

.meas tran vdout0_30ck1260 FIND v(dout0_30) AT=1270.05n

.meas tran vdout0_31ck1260 FIND v(dout0_31) AT=1270.05n

.meas tran vdout1_0ck1260 FIND v(dout1_0) AT=1270.05n

.meas tran vdout1_1ck1260 FIND v(dout1_1) AT=1270.05n

.meas tran vdout1_2ck1260 FIND v(dout1_2) AT=1270.05n

.meas tran vdout1_3ck1260 FIND v(dout1_3) AT=1270.05n

.meas tran vdout1_4ck1260 FIND v(dout1_4) AT=1270.05n

.meas tran vdout1_5ck1260 FIND v(dout1_5) AT=1270.05n

.meas tran vdout1_6ck1260 FIND v(dout1_6) AT=1270.05n

.meas tran vdout1_7ck1260 FIND v(dout1_7) AT=1270.05n

.meas tran vdout1_8ck1260 FIND v(dout1_8) AT=1270.05n

.meas tran vdout1_9ck1260 FIND v(dout1_9) AT=1270.05n

.meas tran vdout1_10ck1260 FIND v(dout1_10) AT=1270.05n

.meas tran vdout1_11ck1260 FIND v(dout1_11) AT=1270.05n

.meas tran vdout1_12ck1260 FIND v(dout1_12) AT=1270.05n

.meas tran vdout1_13ck1260 FIND v(dout1_13) AT=1270.05n

.meas tran vdout1_14ck1260 FIND v(dout1_14) AT=1270.05n

.meas tran vdout1_15ck1260 FIND v(dout1_15) AT=1270.05n

.meas tran vdout1_16ck1260 FIND v(dout1_16) AT=1270.05n

.meas tran vdout1_17ck1260 FIND v(dout1_17) AT=1270.05n

.meas tran vdout1_18ck1260 FIND v(dout1_18) AT=1270.05n

.meas tran vdout1_19ck1260 FIND v(dout1_19) AT=1270.05n

.meas tran vdout1_20ck1260 FIND v(dout1_20) AT=1270.05n

.meas tran vdout1_21ck1260 FIND v(dout1_21) AT=1270.05n

.meas tran vdout1_22ck1260 FIND v(dout1_22) AT=1270.05n

.meas tran vdout1_23ck1260 FIND v(dout1_23) AT=1270.05n

.meas tran vdout1_24ck1260 FIND v(dout1_24) AT=1270.05n

.meas tran vdout1_25ck1260 FIND v(dout1_25) AT=1270.05n

.meas tran vdout1_26ck1260 FIND v(dout1_26) AT=1270.05n

.meas tran vdout1_27ck1260 FIND v(dout1_27) AT=1270.05n

.meas tran vdout1_28ck1260 FIND v(dout1_28) AT=1270.05n

.meas tran vdout1_29ck1260 FIND v(dout1_29) AT=1270.05n

.meas tran vdout1_30ck1260 FIND v(dout1_30) AT=1270.05n

.meas tran vdout1_31ck1260 FIND v(dout1_31) AT=1270.05n

.meas tran vdout1_0ck1290 FIND v(dout1_0) AT=1300.05n

.meas tran vdout1_1ck1290 FIND v(dout1_1) AT=1300.05n

.meas tran vdout1_2ck1290 FIND v(dout1_2) AT=1300.05n

.meas tran vdout1_3ck1290 FIND v(dout1_3) AT=1300.05n

.meas tran vdout1_4ck1290 FIND v(dout1_4) AT=1300.05n

.meas tran vdout1_5ck1290 FIND v(dout1_5) AT=1300.05n

.meas tran vdout1_6ck1290 FIND v(dout1_6) AT=1300.05n

.meas tran vdout1_7ck1290 FIND v(dout1_7) AT=1300.05n

.meas tran vdout1_8ck1290 FIND v(dout1_8) AT=1300.05n

.meas tran vdout1_9ck1290 FIND v(dout1_9) AT=1300.05n

.meas tran vdout1_10ck1290 FIND v(dout1_10) AT=1300.05n

.meas tran vdout1_11ck1290 FIND v(dout1_11) AT=1300.05n

.meas tran vdout1_12ck1290 FIND v(dout1_12) AT=1300.05n

.meas tran vdout1_13ck1290 FIND v(dout1_13) AT=1300.05n

.meas tran vdout1_14ck1290 FIND v(dout1_14) AT=1300.05n

.meas tran vdout1_15ck1290 FIND v(dout1_15) AT=1300.05n

.meas tran vdout1_16ck1290 FIND v(dout1_16) AT=1300.05n

.meas tran vdout1_17ck1290 FIND v(dout1_17) AT=1300.05n

.meas tran vdout1_18ck1290 FIND v(dout1_18) AT=1300.05n

.meas tran vdout1_19ck1290 FIND v(dout1_19) AT=1300.05n

.meas tran vdout1_20ck1290 FIND v(dout1_20) AT=1300.05n

.meas tran vdout1_21ck1290 FIND v(dout1_21) AT=1300.05n

.meas tran vdout1_22ck1290 FIND v(dout1_22) AT=1300.05n

.meas tran vdout1_23ck1290 FIND v(dout1_23) AT=1300.05n

.meas tran vdout1_24ck1290 FIND v(dout1_24) AT=1300.05n

.meas tran vdout1_25ck1290 FIND v(dout1_25) AT=1300.05n

.meas tran vdout1_26ck1290 FIND v(dout1_26) AT=1300.05n

.meas tran vdout1_27ck1290 FIND v(dout1_27) AT=1300.05n

.meas tran vdout1_28ck1290 FIND v(dout1_28) AT=1300.05n

.meas tran vdout1_29ck1290 FIND v(dout1_29) AT=1300.05n

.meas tran vdout1_30ck1290 FIND v(dout1_30) AT=1300.05n

.meas tran vdout1_31ck1290 FIND v(dout1_31) AT=1300.05n

.meas tran vdout1_0ck1300 FIND v(dout1_0) AT=1310.05n

.meas tran vdout1_1ck1300 FIND v(dout1_1) AT=1310.05n

.meas tran vdout1_2ck1300 FIND v(dout1_2) AT=1310.05n

.meas tran vdout1_3ck1300 FIND v(dout1_3) AT=1310.05n

.meas tran vdout1_4ck1300 FIND v(dout1_4) AT=1310.05n

.meas tran vdout1_5ck1300 FIND v(dout1_5) AT=1310.05n

.meas tran vdout1_6ck1300 FIND v(dout1_6) AT=1310.05n

.meas tran vdout1_7ck1300 FIND v(dout1_7) AT=1310.05n

.meas tran vdout1_8ck1300 FIND v(dout1_8) AT=1310.05n

.meas tran vdout1_9ck1300 FIND v(dout1_9) AT=1310.05n

.meas tran vdout1_10ck1300 FIND v(dout1_10) AT=1310.05n

.meas tran vdout1_11ck1300 FIND v(dout1_11) AT=1310.05n

.meas tran vdout1_12ck1300 FIND v(dout1_12) AT=1310.05n

.meas tran vdout1_13ck1300 FIND v(dout1_13) AT=1310.05n

.meas tran vdout1_14ck1300 FIND v(dout1_14) AT=1310.05n

.meas tran vdout1_15ck1300 FIND v(dout1_15) AT=1310.05n

.meas tran vdout1_16ck1300 FIND v(dout1_16) AT=1310.05n

.meas tran vdout1_17ck1300 FIND v(dout1_17) AT=1310.05n

.meas tran vdout1_18ck1300 FIND v(dout1_18) AT=1310.05n

.meas tran vdout1_19ck1300 FIND v(dout1_19) AT=1310.05n

.meas tran vdout1_20ck1300 FIND v(dout1_20) AT=1310.05n

.meas tran vdout1_21ck1300 FIND v(dout1_21) AT=1310.05n

.meas tran vdout1_22ck1300 FIND v(dout1_22) AT=1310.05n

.meas tran vdout1_23ck1300 FIND v(dout1_23) AT=1310.05n

.meas tran vdout1_24ck1300 FIND v(dout1_24) AT=1310.05n

.meas tran vdout1_25ck1300 FIND v(dout1_25) AT=1310.05n

.meas tran vdout1_26ck1300 FIND v(dout1_26) AT=1310.05n

.meas tran vdout1_27ck1300 FIND v(dout1_27) AT=1310.05n

.meas tran vdout1_28ck1300 FIND v(dout1_28) AT=1310.05n

.meas tran vdout1_29ck1300 FIND v(dout1_29) AT=1310.05n

.meas tran vdout1_30ck1300 FIND v(dout1_30) AT=1310.05n

.meas tran vdout1_31ck1300 FIND v(dout1_31) AT=1310.05n

.meas tran vdout0_0ck1310 FIND v(dout0_0) AT=1320.05n

.meas tran vdout0_1ck1310 FIND v(dout0_1) AT=1320.05n

.meas tran vdout0_2ck1310 FIND v(dout0_2) AT=1320.05n

.meas tran vdout0_3ck1310 FIND v(dout0_3) AT=1320.05n

.meas tran vdout0_4ck1310 FIND v(dout0_4) AT=1320.05n

.meas tran vdout0_5ck1310 FIND v(dout0_5) AT=1320.05n

.meas tran vdout0_6ck1310 FIND v(dout0_6) AT=1320.05n

.meas tran vdout0_7ck1310 FIND v(dout0_7) AT=1320.05n

.meas tran vdout0_8ck1310 FIND v(dout0_8) AT=1320.05n

.meas tran vdout0_9ck1310 FIND v(dout0_9) AT=1320.05n

.meas tran vdout0_10ck1310 FIND v(dout0_10) AT=1320.05n

.meas tran vdout0_11ck1310 FIND v(dout0_11) AT=1320.05n

.meas tran vdout0_12ck1310 FIND v(dout0_12) AT=1320.05n

.meas tran vdout0_13ck1310 FIND v(dout0_13) AT=1320.05n

.meas tran vdout0_14ck1310 FIND v(dout0_14) AT=1320.05n

.meas tran vdout0_15ck1310 FIND v(dout0_15) AT=1320.05n

.meas tran vdout0_16ck1310 FIND v(dout0_16) AT=1320.05n

.meas tran vdout0_17ck1310 FIND v(dout0_17) AT=1320.05n

.meas tran vdout0_18ck1310 FIND v(dout0_18) AT=1320.05n

.meas tran vdout0_19ck1310 FIND v(dout0_19) AT=1320.05n

.meas tran vdout0_20ck1310 FIND v(dout0_20) AT=1320.05n

.meas tran vdout0_21ck1310 FIND v(dout0_21) AT=1320.05n

.meas tran vdout0_22ck1310 FIND v(dout0_22) AT=1320.05n

.meas tran vdout0_23ck1310 FIND v(dout0_23) AT=1320.05n

.meas tran vdout0_24ck1310 FIND v(dout0_24) AT=1320.05n

.meas tran vdout0_25ck1310 FIND v(dout0_25) AT=1320.05n

.meas tran vdout0_26ck1310 FIND v(dout0_26) AT=1320.05n

.meas tran vdout0_27ck1310 FIND v(dout0_27) AT=1320.05n

.meas tran vdout0_28ck1310 FIND v(dout0_28) AT=1320.05n

.meas tran vdout0_29ck1310 FIND v(dout0_29) AT=1320.05n

.meas tran vdout0_30ck1310 FIND v(dout0_30) AT=1320.05n

.meas tran vdout0_31ck1310 FIND v(dout0_31) AT=1320.05n

.meas tran vdout1_0ck1320 FIND v(dout1_0) AT=1330.05n

.meas tran vdout1_1ck1320 FIND v(dout1_1) AT=1330.05n

.meas tran vdout1_2ck1320 FIND v(dout1_2) AT=1330.05n

.meas tran vdout1_3ck1320 FIND v(dout1_3) AT=1330.05n

.meas tran vdout1_4ck1320 FIND v(dout1_4) AT=1330.05n

.meas tran vdout1_5ck1320 FIND v(dout1_5) AT=1330.05n

.meas tran vdout1_6ck1320 FIND v(dout1_6) AT=1330.05n

.meas tran vdout1_7ck1320 FIND v(dout1_7) AT=1330.05n

.meas tran vdout1_8ck1320 FIND v(dout1_8) AT=1330.05n

.meas tran vdout1_9ck1320 FIND v(dout1_9) AT=1330.05n

.meas tran vdout1_10ck1320 FIND v(dout1_10) AT=1330.05n

.meas tran vdout1_11ck1320 FIND v(dout1_11) AT=1330.05n

.meas tran vdout1_12ck1320 FIND v(dout1_12) AT=1330.05n

.meas tran vdout1_13ck1320 FIND v(dout1_13) AT=1330.05n

.meas tran vdout1_14ck1320 FIND v(dout1_14) AT=1330.05n

.meas tran vdout1_15ck1320 FIND v(dout1_15) AT=1330.05n

.meas tran vdout1_16ck1320 FIND v(dout1_16) AT=1330.05n

.meas tran vdout1_17ck1320 FIND v(dout1_17) AT=1330.05n

.meas tran vdout1_18ck1320 FIND v(dout1_18) AT=1330.05n

.meas tran vdout1_19ck1320 FIND v(dout1_19) AT=1330.05n

.meas tran vdout1_20ck1320 FIND v(dout1_20) AT=1330.05n

.meas tran vdout1_21ck1320 FIND v(dout1_21) AT=1330.05n

.meas tran vdout1_22ck1320 FIND v(dout1_22) AT=1330.05n

.meas tran vdout1_23ck1320 FIND v(dout1_23) AT=1330.05n

.meas tran vdout1_24ck1320 FIND v(dout1_24) AT=1330.05n

.meas tran vdout1_25ck1320 FIND v(dout1_25) AT=1330.05n

.meas tran vdout1_26ck1320 FIND v(dout1_26) AT=1330.05n

.meas tran vdout1_27ck1320 FIND v(dout1_27) AT=1330.05n

.meas tran vdout1_28ck1320 FIND v(dout1_28) AT=1330.05n

.meas tran vdout1_29ck1320 FIND v(dout1_29) AT=1330.05n

.meas tran vdout1_30ck1320 FIND v(dout1_30) AT=1330.05n

.meas tran vdout1_31ck1320 FIND v(dout1_31) AT=1330.05n

.meas tran vdout0_0ck1340 FIND v(dout0_0) AT=1350.05n

.meas tran vdout0_1ck1340 FIND v(dout0_1) AT=1350.05n

.meas tran vdout0_2ck1340 FIND v(dout0_2) AT=1350.05n

.meas tran vdout0_3ck1340 FIND v(dout0_3) AT=1350.05n

.meas tran vdout0_4ck1340 FIND v(dout0_4) AT=1350.05n

.meas tran vdout0_5ck1340 FIND v(dout0_5) AT=1350.05n

.meas tran vdout0_6ck1340 FIND v(dout0_6) AT=1350.05n

.meas tran vdout0_7ck1340 FIND v(dout0_7) AT=1350.05n

.meas tran vdout0_8ck1340 FIND v(dout0_8) AT=1350.05n

.meas tran vdout0_9ck1340 FIND v(dout0_9) AT=1350.05n

.meas tran vdout0_10ck1340 FIND v(dout0_10) AT=1350.05n

.meas tran vdout0_11ck1340 FIND v(dout0_11) AT=1350.05n

.meas tran vdout0_12ck1340 FIND v(dout0_12) AT=1350.05n

.meas tran vdout0_13ck1340 FIND v(dout0_13) AT=1350.05n

.meas tran vdout0_14ck1340 FIND v(dout0_14) AT=1350.05n

.meas tran vdout0_15ck1340 FIND v(dout0_15) AT=1350.05n

.meas tran vdout0_16ck1340 FIND v(dout0_16) AT=1350.05n

.meas tran vdout0_17ck1340 FIND v(dout0_17) AT=1350.05n

.meas tran vdout0_18ck1340 FIND v(dout0_18) AT=1350.05n

.meas tran vdout0_19ck1340 FIND v(dout0_19) AT=1350.05n

.meas tran vdout0_20ck1340 FIND v(dout0_20) AT=1350.05n

.meas tran vdout0_21ck1340 FIND v(dout0_21) AT=1350.05n

.meas tran vdout0_22ck1340 FIND v(dout0_22) AT=1350.05n

.meas tran vdout0_23ck1340 FIND v(dout0_23) AT=1350.05n

.meas tran vdout0_24ck1340 FIND v(dout0_24) AT=1350.05n

.meas tran vdout0_25ck1340 FIND v(dout0_25) AT=1350.05n

.meas tran vdout0_26ck1340 FIND v(dout0_26) AT=1350.05n

.meas tran vdout0_27ck1340 FIND v(dout0_27) AT=1350.05n

.meas tran vdout0_28ck1340 FIND v(dout0_28) AT=1350.05n

.meas tran vdout0_29ck1340 FIND v(dout0_29) AT=1350.05n

.meas tran vdout0_30ck1340 FIND v(dout0_30) AT=1350.05n

.meas tran vdout0_31ck1340 FIND v(dout0_31) AT=1350.05n

.meas tran vdout1_0ck1350 FIND v(dout1_0) AT=1360.05n

.meas tran vdout1_1ck1350 FIND v(dout1_1) AT=1360.05n

.meas tran vdout1_2ck1350 FIND v(dout1_2) AT=1360.05n

.meas tran vdout1_3ck1350 FIND v(dout1_3) AT=1360.05n

.meas tran vdout1_4ck1350 FIND v(dout1_4) AT=1360.05n

.meas tran vdout1_5ck1350 FIND v(dout1_5) AT=1360.05n

.meas tran vdout1_6ck1350 FIND v(dout1_6) AT=1360.05n

.meas tran vdout1_7ck1350 FIND v(dout1_7) AT=1360.05n

.meas tran vdout1_8ck1350 FIND v(dout1_8) AT=1360.05n

.meas tran vdout1_9ck1350 FIND v(dout1_9) AT=1360.05n

.meas tran vdout1_10ck1350 FIND v(dout1_10) AT=1360.05n

.meas tran vdout1_11ck1350 FIND v(dout1_11) AT=1360.05n

.meas tran vdout1_12ck1350 FIND v(dout1_12) AT=1360.05n

.meas tran vdout1_13ck1350 FIND v(dout1_13) AT=1360.05n

.meas tran vdout1_14ck1350 FIND v(dout1_14) AT=1360.05n

.meas tran vdout1_15ck1350 FIND v(dout1_15) AT=1360.05n

.meas tran vdout1_16ck1350 FIND v(dout1_16) AT=1360.05n

.meas tran vdout1_17ck1350 FIND v(dout1_17) AT=1360.05n

.meas tran vdout1_18ck1350 FIND v(dout1_18) AT=1360.05n

.meas tran vdout1_19ck1350 FIND v(dout1_19) AT=1360.05n

.meas tran vdout1_20ck1350 FIND v(dout1_20) AT=1360.05n

.meas tran vdout1_21ck1350 FIND v(dout1_21) AT=1360.05n

.meas tran vdout1_22ck1350 FIND v(dout1_22) AT=1360.05n

.meas tran vdout1_23ck1350 FIND v(dout1_23) AT=1360.05n

.meas tran vdout1_24ck1350 FIND v(dout1_24) AT=1360.05n

.meas tran vdout1_25ck1350 FIND v(dout1_25) AT=1360.05n

.meas tran vdout1_26ck1350 FIND v(dout1_26) AT=1360.05n

.meas tran vdout1_27ck1350 FIND v(dout1_27) AT=1360.05n

.meas tran vdout1_28ck1350 FIND v(dout1_28) AT=1360.05n

.meas tran vdout1_29ck1350 FIND v(dout1_29) AT=1360.05n

.meas tran vdout1_30ck1350 FIND v(dout1_30) AT=1360.05n

.meas tran vdout1_31ck1350 FIND v(dout1_31) AT=1360.05n

.meas tran vdout1_0ck1360 FIND v(dout1_0) AT=1370.05n

.meas tran vdout1_1ck1360 FIND v(dout1_1) AT=1370.05n

.meas tran vdout1_2ck1360 FIND v(dout1_2) AT=1370.05n

.meas tran vdout1_3ck1360 FIND v(dout1_3) AT=1370.05n

.meas tran vdout1_4ck1360 FIND v(dout1_4) AT=1370.05n

.meas tran vdout1_5ck1360 FIND v(dout1_5) AT=1370.05n

.meas tran vdout1_6ck1360 FIND v(dout1_6) AT=1370.05n

.meas tran vdout1_7ck1360 FIND v(dout1_7) AT=1370.05n

.meas tran vdout1_8ck1360 FIND v(dout1_8) AT=1370.05n

.meas tran vdout1_9ck1360 FIND v(dout1_9) AT=1370.05n

.meas tran vdout1_10ck1360 FIND v(dout1_10) AT=1370.05n

.meas tran vdout1_11ck1360 FIND v(dout1_11) AT=1370.05n

.meas tran vdout1_12ck1360 FIND v(dout1_12) AT=1370.05n

.meas tran vdout1_13ck1360 FIND v(dout1_13) AT=1370.05n

.meas tran vdout1_14ck1360 FIND v(dout1_14) AT=1370.05n

.meas tran vdout1_15ck1360 FIND v(dout1_15) AT=1370.05n

.meas tran vdout1_16ck1360 FIND v(dout1_16) AT=1370.05n

.meas tran vdout1_17ck1360 FIND v(dout1_17) AT=1370.05n

.meas tran vdout1_18ck1360 FIND v(dout1_18) AT=1370.05n

.meas tran vdout1_19ck1360 FIND v(dout1_19) AT=1370.05n

.meas tran vdout1_20ck1360 FIND v(dout1_20) AT=1370.05n

.meas tran vdout1_21ck1360 FIND v(dout1_21) AT=1370.05n

.meas tran vdout1_22ck1360 FIND v(dout1_22) AT=1370.05n

.meas tran vdout1_23ck1360 FIND v(dout1_23) AT=1370.05n

.meas tran vdout1_24ck1360 FIND v(dout1_24) AT=1370.05n

.meas tran vdout1_25ck1360 FIND v(dout1_25) AT=1370.05n

.meas tran vdout1_26ck1360 FIND v(dout1_26) AT=1370.05n

.meas tran vdout1_27ck1360 FIND v(dout1_27) AT=1370.05n

.meas tran vdout1_28ck1360 FIND v(dout1_28) AT=1370.05n

.meas tran vdout1_29ck1360 FIND v(dout1_29) AT=1370.05n

.meas tran vdout1_30ck1360 FIND v(dout1_30) AT=1370.05n

.meas tran vdout1_31ck1360 FIND v(dout1_31) AT=1370.05n

.meas tran vdout0_0ck1380 FIND v(dout0_0) AT=1390.05n

.meas tran vdout0_1ck1380 FIND v(dout0_1) AT=1390.05n

.meas tran vdout0_2ck1380 FIND v(dout0_2) AT=1390.05n

.meas tran vdout0_3ck1380 FIND v(dout0_3) AT=1390.05n

.meas tran vdout0_4ck1380 FIND v(dout0_4) AT=1390.05n

.meas tran vdout0_5ck1380 FIND v(dout0_5) AT=1390.05n

.meas tran vdout0_6ck1380 FIND v(dout0_6) AT=1390.05n

.meas tran vdout0_7ck1380 FIND v(dout0_7) AT=1390.05n

.meas tran vdout0_8ck1380 FIND v(dout0_8) AT=1390.05n

.meas tran vdout0_9ck1380 FIND v(dout0_9) AT=1390.05n

.meas tran vdout0_10ck1380 FIND v(dout0_10) AT=1390.05n

.meas tran vdout0_11ck1380 FIND v(dout0_11) AT=1390.05n

.meas tran vdout0_12ck1380 FIND v(dout0_12) AT=1390.05n

.meas tran vdout0_13ck1380 FIND v(dout0_13) AT=1390.05n

.meas tran vdout0_14ck1380 FIND v(dout0_14) AT=1390.05n

.meas tran vdout0_15ck1380 FIND v(dout0_15) AT=1390.05n

.meas tran vdout0_16ck1380 FIND v(dout0_16) AT=1390.05n

.meas tran vdout0_17ck1380 FIND v(dout0_17) AT=1390.05n

.meas tran vdout0_18ck1380 FIND v(dout0_18) AT=1390.05n

.meas tran vdout0_19ck1380 FIND v(dout0_19) AT=1390.05n

.meas tran vdout0_20ck1380 FIND v(dout0_20) AT=1390.05n

.meas tran vdout0_21ck1380 FIND v(dout0_21) AT=1390.05n

.meas tran vdout0_22ck1380 FIND v(dout0_22) AT=1390.05n

.meas tran vdout0_23ck1380 FIND v(dout0_23) AT=1390.05n

.meas tran vdout0_24ck1380 FIND v(dout0_24) AT=1390.05n

.meas tran vdout0_25ck1380 FIND v(dout0_25) AT=1390.05n

.meas tran vdout0_26ck1380 FIND v(dout0_26) AT=1390.05n

.meas tran vdout0_27ck1380 FIND v(dout0_27) AT=1390.05n

.meas tran vdout0_28ck1380 FIND v(dout0_28) AT=1390.05n

.meas tran vdout0_29ck1380 FIND v(dout0_29) AT=1390.05n

.meas tran vdout0_30ck1380 FIND v(dout0_30) AT=1390.05n

.meas tran vdout0_31ck1380 FIND v(dout0_31) AT=1390.05n

.meas tran vdout0_0ck1400 FIND v(dout0_0) AT=1410.05n

.meas tran vdout0_1ck1400 FIND v(dout0_1) AT=1410.05n

.meas tran vdout0_2ck1400 FIND v(dout0_2) AT=1410.05n

.meas tran vdout0_3ck1400 FIND v(dout0_3) AT=1410.05n

.meas tran vdout0_4ck1400 FIND v(dout0_4) AT=1410.05n

.meas tran vdout0_5ck1400 FIND v(dout0_5) AT=1410.05n

.meas tran vdout0_6ck1400 FIND v(dout0_6) AT=1410.05n

.meas tran vdout0_7ck1400 FIND v(dout0_7) AT=1410.05n

.meas tran vdout0_8ck1400 FIND v(dout0_8) AT=1410.05n

.meas tran vdout0_9ck1400 FIND v(dout0_9) AT=1410.05n

.meas tran vdout0_10ck1400 FIND v(dout0_10) AT=1410.05n

.meas tran vdout0_11ck1400 FIND v(dout0_11) AT=1410.05n

.meas tran vdout0_12ck1400 FIND v(dout0_12) AT=1410.05n

.meas tran vdout0_13ck1400 FIND v(dout0_13) AT=1410.05n

.meas tran vdout0_14ck1400 FIND v(dout0_14) AT=1410.05n

.meas tran vdout0_15ck1400 FIND v(dout0_15) AT=1410.05n

.meas tran vdout0_16ck1400 FIND v(dout0_16) AT=1410.05n

.meas tran vdout0_17ck1400 FIND v(dout0_17) AT=1410.05n

.meas tran vdout0_18ck1400 FIND v(dout0_18) AT=1410.05n

.meas tran vdout0_19ck1400 FIND v(dout0_19) AT=1410.05n

.meas tran vdout0_20ck1400 FIND v(dout0_20) AT=1410.05n

.meas tran vdout0_21ck1400 FIND v(dout0_21) AT=1410.05n

.meas tran vdout0_22ck1400 FIND v(dout0_22) AT=1410.05n

.meas tran vdout0_23ck1400 FIND v(dout0_23) AT=1410.05n

.meas tran vdout0_24ck1400 FIND v(dout0_24) AT=1410.05n

.meas tran vdout0_25ck1400 FIND v(dout0_25) AT=1410.05n

.meas tran vdout0_26ck1400 FIND v(dout0_26) AT=1410.05n

.meas tran vdout0_27ck1400 FIND v(dout0_27) AT=1410.05n

.meas tran vdout0_28ck1400 FIND v(dout0_28) AT=1410.05n

.meas tran vdout0_29ck1400 FIND v(dout0_29) AT=1410.05n

.meas tran vdout0_30ck1400 FIND v(dout0_30) AT=1410.05n

.meas tran vdout0_31ck1400 FIND v(dout0_31) AT=1410.05n

.meas tran vdout1_0ck1400 FIND v(dout1_0) AT=1410.05n

.meas tran vdout1_1ck1400 FIND v(dout1_1) AT=1410.05n

.meas tran vdout1_2ck1400 FIND v(dout1_2) AT=1410.05n

.meas tran vdout1_3ck1400 FIND v(dout1_3) AT=1410.05n

.meas tran vdout1_4ck1400 FIND v(dout1_4) AT=1410.05n

.meas tran vdout1_5ck1400 FIND v(dout1_5) AT=1410.05n

.meas tran vdout1_6ck1400 FIND v(dout1_6) AT=1410.05n

.meas tran vdout1_7ck1400 FIND v(dout1_7) AT=1410.05n

.meas tran vdout1_8ck1400 FIND v(dout1_8) AT=1410.05n

.meas tran vdout1_9ck1400 FIND v(dout1_9) AT=1410.05n

.meas tran vdout1_10ck1400 FIND v(dout1_10) AT=1410.05n

.meas tran vdout1_11ck1400 FIND v(dout1_11) AT=1410.05n

.meas tran vdout1_12ck1400 FIND v(dout1_12) AT=1410.05n

.meas tran vdout1_13ck1400 FIND v(dout1_13) AT=1410.05n

.meas tran vdout1_14ck1400 FIND v(dout1_14) AT=1410.05n

.meas tran vdout1_15ck1400 FIND v(dout1_15) AT=1410.05n

.meas tran vdout1_16ck1400 FIND v(dout1_16) AT=1410.05n

.meas tran vdout1_17ck1400 FIND v(dout1_17) AT=1410.05n

.meas tran vdout1_18ck1400 FIND v(dout1_18) AT=1410.05n

.meas tran vdout1_19ck1400 FIND v(dout1_19) AT=1410.05n

.meas tran vdout1_20ck1400 FIND v(dout1_20) AT=1410.05n

.meas tran vdout1_21ck1400 FIND v(dout1_21) AT=1410.05n

.meas tran vdout1_22ck1400 FIND v(dout1_22) AT=1410.05n

.meas tran vdout1_23ck1400 FIND v(dout1_23) AT=1410.05n

.meas tran vdout1_24ck1400 FIND v(dout1_24) AT=1410.05n

.meas tran vdout1_25ck1400 FIND v(dout1_25) AT=1410.05n

.meas tran vdout1_26ck1400 FIND v(dout1_26) AT=1410.05n

.meas tran vdout1_27ck1400 FIND v(dout1_27) AT=1410.05n

.meas tran vdout1_28ck1400 FIND v(dout1_28) AT=1410.05n

.meas tran vdout1_29ck1400 FIND v(dout1_29) AT=1410.05n

.meas tran vdout1_30ck1400 FIND v(dout1_30) AT=1410.05n

.meas tran vdout1_31ck1400 FIND v(dout1_31) AT=1410.05n

.meas tran vdout1_0ck1420 FIND v(dout1_0) AT=1430.05n

.meas tran vdout1_1ck1420 FIND v(dout1_1) AT=1430.05n

.meas tran vdout1_2ck1420 FIND v(dout1_2) AT=1430.05n

.meas tran vdout1_3ck1420 FIND v(dout1_3) AT=1430.05n

.meas tran vdout1_4ck1420 FIND v(dout1_4) AT=1430.05n

.meas tran vdout1_5ck1420 FIND v(dout1_5) AT=1430.05n

.meas tran vdout1_6ck1420 FIND v(dout1_6) AT=1430.05n

.meas tran vdout1_7ck1420 FIND v(dout1_7) AT=1430.05n

.meas tran vdout1_8ck1420 FIND v(dout1_8) AT=1430.05n

.meas tran vdout1_9ck1420 FIND v(dout1_9) AT=1430.05n

.meas tran vdout1_10ck1420 FIND v(dout1_10) AT=1430.05n

.meas tran vdout1_11ck1420 FIND v(dout1_11) AT=1430.05n

.meas tran vdout1_12ck1420 FIND v(dout1_12) AT=1430.05n

.meas tran vdout1_13ck1420 FIND v(dout1_13) AT=1430.05n

.meas tran vdout1_14ck1420 FIND v(dout1_14) AT=1430.05n

.meas tran vdout1_15ck1420 FIND v(dout1_15) AT=1430.05n

.meas tran vdout1_16ck1420 FIND v(dout1_16) AT=1430.05n

.meas tran vdout1_17ck1420 FIND v(dout1_17) AT=1430.05n

.meas tran vdout1_18ck1420 FIND v(dout1_18) AT=1430.05n

.meas tran vdout1_19ck1420 FIND v(dout1_19) AT=1430.05n

.meas tran vdout1_20ck1420 FIND v(dout1_20) AT=1430.05n

.meas tran vdout1_21ck1420 FIND v(dout1_21) AT=1430.05n

.meas tran vdout1_22ck1420 FIND v(dout1_22) AT=1430.05n

.meas tran vdout1_23ck1420 FIND v(dout1_23) AT=1430.05n

.meas tran vdout1_24ck1420 FIND v(dout1_24) AT=1430.05n

.meas tran vdout1_25ck1420 FIND v(dout1_25) AT=1430.05n

.meas tran vdout1_26ck1420 FIND v(dout1_26) AT=1430.05n

.meas tran vdout1_27ck1420 FIND v(dout1_27) AT=1430.05n

.meas tran vdout1_28ck1420 FIND v(dout1_28) AT=1430.05n

.meas tran vdout1_29ck1420 FIND v(dout1_29) AT=1430.05n

.meas tran vdout1_30ck1420 FIND v(dout1_30) AT=1430.05n

.meas tran vdout1_31ck1420 FIND v(dout1_31) AT=1430.05n

.meas tran vdout0_0ck1430 FIND v(dout0_0) AT=1440.05n

.meas tran vdout0_1ck1430 FIND v(dout0_1) AT=1440.05n

.meas tran vdout0_2ck1430 FIND v(dout0_2) AT=1440.05n

.meas tran vdout0_3ck1430 FIND v(dout0_3) AT=1440.05n

.meas tran vdout0_4ck1430 FIND v(dout0_4) AT=1440.05n

.meas tran vdout0_5ck1430 FIND v(dout0_5) AT=1440.05n

.meas tran vdout0_6ck1430 FIND v(dout0_6) AT=1440.05n

.meas tran vdout0_7ck1430 FIND v(dout0_7) AT=1440.05n

.meas tran vdout0_8ck1430 FIND v(dout0_8) AT=1440.05n

.meas tran vdout0_9ck1430 FIND v(dout0_9) AT=1440.05n

.meas tran vdout0_10ck1430 FIND v(dout0_10) AT=1440.05n

.meas tran vdout0_11ck1430 FIND v(dout0_11) AT=1440.05n

.meas tran vdout0_12ck1430 FIND v(dout0_12) AT=1440.05n

.meas tran vdout0_13ck1430 FIND v(dout0_13) AT=1440.05n

.meas tran vdout0_14ck1430 FIND v(dout0_14) AT=1440.05n

.meas tran vdout0_15ck1430 FIND v(dout0_15) AT=1440.05n

.meas tran vdout0_16ck1430 FIND v(dout0_16) AT=1440.05n

.meas tran vdout0_17ck1430 FIND v(dout0_17) AT=1440.05n

.meas tran vdout0_18ck1430 FIND v(dout0_18) AT=1440.05n

.meas tran vdout0_19ck1430 FIND v(dout0_19) AT=1440.05n

.meas tran vdout0_20ck1430 FIND v(dout0_20) AT=1440.05n

.meas tran vdout0_21ck1430 FIND v(dout0_21) AT=1440.05n

.meas tran vdout0_22ck1430 FIND v(dout0_22) AT=1440.05n

.meas tran vdout0_23ck1430 FIND v(dout0_23) AT=1440.05n

.meas tran vdout0_24ck1430 FIND v(dout0_24) AT=1440.05n

.meas tran vdout0_25ck1430 FIND v(dout0_25) AT=1440.05n

.meas tran vdout0_26ck1430 FIND v(dout0_26) AT=1440.05n

.meas tran vdout0_27ck1430 FIND v(dout0_27) AT=1440.05n

.meas tran vdout0_28ck1430 FIND v(dout0_28) AT=1440.05n

.meas tran vdout0_29ck1430 FIND v(dout0_29) AT=1440.05n

.meas tran vdout0_30ck1430 FIND v(dout0_30) AT=1440.05n

.meas tran vdout0_31ck1430 FIND v(dout0_31) AT=1440.05n

.meas tran vdout1_0ck1430 FIND v(dout1_0) AT=1440.05n

.meas tran vdout1_1ck1430 FIND v(dout1_1) AT=1440.05n

.meas tran vdout1_2ck1430 FIND v(dout1_2) AT=1440.05n

.meas tran vdout1_3ck1430 FIND v(dout1_3) AT=1440.05n

.meas tran vdout1_4ck1430 FIND v(dout1_4) AT=1440.05n

.meas tran vdout1_5ck1430 FIND v(dout1_5) AT=1440.05n

.meas tran vdout1_6ck1430 FIND v(dout1_6) AT=1440.05n

.meas tran vdout1_7ck1430 FIND v(dout1_7) AT=1440.05n

.meas tran vdout1_8ck1430 FIND v(dout1_8) AT=1440.05n

.meas tran vdout1_9ck1430 FIND v(dout1_9) AT=1440.05n

.meas tran vdout1_10ck1430 FIND v(dout1_10) AT=1440.05n

.meas tran vdout1_11ck1430 FIND v(dout1_11) AT=1440.05n

.meas tran vdout1_12ck1430 FIND v(dout1_12) AT=1440.05n

.meas tran vdout1_13ck1430 FIND v(dout1_13) AT=1440.05n

.meas tran vdout1_14ck1430 FIND v(dout1_14) AT=1440.05n

.meas tran vdout1_15ck1430 FIND v(dout1_15) AT=1440.05n

.meas tran vdout1_16ck1430 FIND v(dout1_16) AT=1440.05n

.meas tran vdout1_17ck1430 FIND v(dout1_17) AT=1440.05n

.meas tran vdout1_18ck1430 FIND v(dout1_18) AT=1440.05n

.meas tran vdout1_19ck1430 FIND v(dout1_19) AT=1440.05n

.meas tran vdout1_20ck1430 FIND v(dout1_20) AT=1440.05n

.meas tran vdout1_21ck1430 FIND v(dout1_21) AT=1440.05n

.meas tran vdout1_22ck1430 FIND v(dout1_22) AT=1440.05n

.meas tran vdout1_23ck1430 FIND v(dout1_23) AT=1440.05n

.meas tran vdout1_24ck1430 FIND v(dout1_24) AT=1440.05n

.meas tran vdout1_25ck1430 FIND v(dout1_25) AT=1440.05n

.meas tran vdout1_26ck1430 FIND v(dout1_26) AT=1440.05n

.meas tran vdout1_27ck1430 FIND v(dout1_27) AT=1440.05n

.meas tran vdout1_28ck1430 FIND v(dout1_28) AT=1440.05n

.meas tran vdout1_29ck1430 FIND v(dout1_29) AT=1440.05n

.meas tran vdout1_30ck1430 FIND v(dout1_30) AT=1440.05n

.meas tran vdout1_31ck1430 FIND v(dout1_31) AT=1440.05n

.meas tran vdout1_0ck1440 FIND v(dout1_0) AT=1450.05n

.meas tran vdout1_1ck1440 FIND v(dout1_1) AT=1450.05n

.meas tran vdout1_2ck1440 FIND v(dout1_2) AT=1450.05n

.meas tran vdout1_3ck1440 FIND v(dout1_3) AT=1450.05n

.meas tran vdout1_4ck1440 FIND v(dout1_4) AT=1450.05n

.meas tran vdout1_5ck1440 FIND v(dout1_5) AT=1450.05n

.meas tran vdout1_6ck1440 FIND v(dout1_6) AT=1450.05n

.meas tran vdout1_7ck1440 FIND v(dout1_7) AT=1450.05n

.meas tran vdout1_8ck1440 FIND v(dout1_8) AT=1450.05n

.meas tran vdout1_9ck1440 FIND v(dout1_9) AT=1450.05n

.meas tran vdout1_10ck1440 FIND v(dout1_10) AT=1450.05n

.meas tran vdout1_11ck1440 FIND v(dout1_11) AT=1450.05n

.meas tran vdout1_12ck1440 FIND v(dout1_12) AT=1450.05n

.meas tran vdout1_13ck1440 FIND v(dout1_13) AT=1450.05n

.meas tran vdout1_14ck1440 FIND v(dout1_14) AT=1450.05n

.meas tran vdout1_15ck1440 FIND v(dout1_15) AT=1450.05n

.meas tran vdout1_16ck1440 FIND v(dout1_16) AT=1450.05n

.meas tran vdout1_17ck1440 FIND v(dout1_17) AT=1450.05n

.meas tran vdout1_18ck1440 FIND v(dout1_18) AT=1450.05n

.meas tran vdout1_19ck1440 FIND v(dout1_19) AT=1450.05n

.meas tran vdout1_20ck1440 FIND v(dout1_20) AT=1450.05n

.meas tran vdout1_21ck1440 FIND v(dout1_21) AT=1450.05n

.meas tran vdout1_22ck1440 FIND v(dout1_22) AT=1450.05n

.meas tran vdout1_23ck1440 FIND v(dout1_23) AT=1450.05n

.meas tran vdout1_24ck1440 FIND v(dout1_24) AT=1450.05n

.meas tran vdout1_25ck1440 FIND v(dout1_25) AT=1450.05n

.meas tran vdout1_26ck1440 FIND v(dout1_26) AT=1450.05n

.meas tran vdout1_27ck1440 FIND v(dout1_27) AT=1450.05n

.meas tran vdout1_28ck1440 FIND v(dout1_28) AT=1450.05n

.meas tran vdout1_29ck1440 FIND v(dout1_29) AT=1450.05n

.meas tran vdout1_30ck1440 FIND v(dout1_30) AT=1450.05n

.meas tran vdout1_31ck1440 FIND v(dout1_31) AT=1450.05n

.meas tran vdout0_0ck1450 FIND v(dout0_0) AT=1460.05n

.meas tran vdout0_1ck1450 FIND v(dout0_1) AT=1460.05n

.meas tran vdout0_2ck1450 FIND v(dout0_2) AT=1460.05n

.meas tran vdout0_3ck1450 FIND v(dout0_3) AT=1460.05n

.meas tran vdout0_4ck1450 FIND v(dout0_4) AT=1460.05n

.meas tran vdout0_5ck1450 FIND v(dout0_5) AT=1460.05n

.meas tran vdout0_6ck1450 FIND v(dout0_6) AT=1460.05n

.meas tran vdout0_7ck1450 FIND v(dout0_7) AT=1460.05n

.meas tran vdout0_8ck1450 FIND v(dout0_8) AT=1460.05n

.meas tran vdout0_9ck1450 FIND v(dout0_9) AT=1460.05n

.meas tran vdout0_10ck1450 FIND v(dout0_10) AT=1460.05n

.meas tran vdout0_11ck1450 FIND v(dout0_11) AT=1460.05n

.meas tran vdout0_12ck1450 FIND v(dout0_12) AT=1460.05n

.meas tran vdout0_13ck1450 FIND v(dout0_13) AT=1460.05n

.meas tran vdout0_14ck1450 FIND v(dout0_14) AT=1460.05n

.meas tran vdout0_15ck1450 FIND v(dout0_15) AT=1460.05n

.meas tran vdout0_16ck1450 FIND v(dout0_16) AT=1460.05n

.meas tran vdout0_17ck1450 FIND v(dout0_17) AT=1460.05n

.meas tran vdout0_18ck1450 FIND v(dout0_18) AT=1460.05n

.meas tran vdout0_19ck1450 FIND v(dout0_19) AT=1460.05n

.meas tran vdout0_20ck1450 FIND v(dout0_20) AT=1460.05n

.meas tran vdout0_21ck1450 FIND v(dout0_21) AT=1460.05n

.meas tran vdout0_22ck1450 FIND v(dout0_22) AT=1460.05n

.meas tran vdout0_23ck1450 FIND v(dout0_23) AT=1460.05n

.meas tran vdout0_24ck1450 FIND v(dout0_24) AT=1460.05n

.meas tran vdout0_25ck1450 FIND v(dout0_25) AT=1460.05n

.meas tran vdout0_26ck1450 FIND v(dout0_26) AT=1460.05n

.meas tran vdout0_27ck1450 FIND v(dout0_27) AT=1460.05n

.meas tran vdout0_28ck1450 FIND v(dout0_28) AT=1460.05n

.meas tran vdout0_29ck1450 FIND v(dout0_29) AT=1460.05n

.meas tran vdout0_30ck1450 FIND v(dout0_30) AT=1460.05n

.meas tran vdout0_31ck1450 FIND v(dout0_31) AT=1460.05n

.meas tran vdout1_0ck1450 FIND v(dout1_0) AT=1460.05n

.meas tran vdout1_1ck1450 FIND v(dout1_1) AT=1460.05n

.meas tran vdout1_2ck1450 FIND v(dout1_2) AT=1460.05n

.meas tran vdout1_3ck1450 FIND v(dout1_3) AT=1460.05n

.meas tran vdout1_4ck1450 FIND v(dout1_4) AT=1460.05n

.meas tran vdout1_5ck1450 FIND v(dout1_5) AT=1460.05n

.meas tran vdout1_6ck1450 FIND v(dout1_6) AT=1460.05n

.meas tran vdout1_7ck1450 FIND v(dout1_7) AT=1460.05n

.meas tran vdout1_8ck1450 FIND v(dout1_8) AT=1460.05n

.meas tran vdout1_9ck1450 FIND v(dout1_9) AT=1460.05n

.meas tran vdout1_10ck1450 FIND v(dout1_10) AT=1460.05n

.meas tran vdout1_11ck1450 FIND v(dout1_11) AT=1460.05n

.meas tran vdout1_12ck1450 FIND v(dout1_12) AT=1460.05n

.meas tran vdout1_13ck1450 FIND v(dout1_13) AT=1460.05n

.meas tran vdout1_14ck1450 FIND v(dout1_14) AT=1460.05n

.meas tran vdout1_15ck1450 FIND v(dout1_15) AT=1460.05n

.meas tran vdout1_16ck1450 FIND v(dout1_16) AT=1460.05n

.meas tran vdout1_17ck1450 FIND v(dout1_17) AT=1460.05n

.meas tran vdout1_18ck1450 FIND v(dout1_18) AT=1460.05n

.meas tran vdout1_19ck1450 FIND v(dout1_19) AT=1460.05n

.meas tran vdout1_20ck1450 FIND v(dout1_20) AT=1460.05n

.meas tran vdout1_21ck1450 FIND v(dout1_21) AT=1460.05n

.meas tran vdout1_22ck1450 FIND v(dout1_22) AT=1460.05n

.meas tran vdout1_23ck1450 FIND v(dout1_23) AT=1460.05n

.meas tran vdout1_24ck1450 FIND v(dout1_24) AT=1460.05n

.meas tran vdout1_25ck1450 FIND v(dout1_25) AT=1460.05n

.meas tran vdout1_26ck1450 FIND v(dout1_26) AT=1460.05n

.meas tran vdout1_27ck1450 FIND v(dout1_27) AT=1460.05n

.meas tran vdout1_28ck1450 FIND v(dout1_28) AT=1460.05n

.meas tran vdout1_29ck1450 FIND v(dout1_29) AT=1460.05n

.meas tran vdout1_30ck1450 FIND v(dout1_30) AT=1460.05n

.meas tran vdout1_31ck1450 FIND v(dout1_31) AT=1460.05n

.meas tran vdout1_0ck1460 FIND v(dout1_0) AT=1470.05n

.meas tran vdout1_1ck1460 FIND v(dout1_1) AT=1470.05n

.meas tran vdout1_2ck1460 FIND v(dout1_2) AT=1470.05n

.meas tran vdout1_3ck1460 FIND v(dout1_3) AT=1470.05n

.meas tran vdout1_4ck1460 FIND v(dout1_4) AT=1470.05n

.meas tran vdout1_5ck1460 FIND v(dout1_5) AT=1470.05n

.meas tran vdout1_6ck1460 FIND v(dout1_6) AT=1470.05n

.meas tran vdout1_7ck1460 FIND v(dout1_7) AT=1470.05n

.meas tran vdout1_8ck1460 FIND v(dout1_8) AT=1470.05n

.meas tran vdout1_9ck1460 FIND v(dout1_9) AT=1470.05n

.meas tran vdout1_10ck1460 FIND v(dout1_10) AT=1470.05n

.meas tran vdout1_11ck1460 FIND v(dout1_11) AT=1470.05n

.meas tran vdout1_12ck1460 FIND v(dout1_12) AT=1470.05n

.meas tran vdout1_13ck1460 FIND v(dout1_13) AT=1470.05n

.meas tran vdout1_14ck1460 FIND v(dout1_14) AT=1470.05n

.meas tran vdout1_15ck1460 FIND v(dout1_15) AT=1470.05n

.meas tran vdout1_16ck1460 FIND v(dout1_16) AT=1470.05n

.meas tran vdout1_17ck1460 FIND v(dout1_17) AT=1470.05n

.meas tran vdout1_18ck1460 FIND v(dout1_18) AT=1470.05n

.meas tran vdout1_19ck1460 FIND v(dout1_19) AT=1470.05n

.meas tran vdout1_20ck1460 FIND v(dout1_20) AT=1470.05n

.meas tran vdout1_21ck1460 FIND v(dout1_21) AT=1470.05n

.meas tran vdout1_22ck1460 FIND v(dout1_22) AT=1470.05n

.meas tran vdout1_23ck1460 FIND v(dout1_23) AT=1470.05n

.meas tran vdout1_24ck1460 FIND v(dout1_24) AT=1470.05n

.meas tran vdout1_25ck1460 FIND v(dout1_25) AT=1470.05n

.meas tran vdout1_26ck1460 FIND v(dout1_26) AT=1470.05n

.meas tran vdout1_27ck1460 FIND v(dout1_27) AT=1470.05n

.meas tran vdout1_28ck1460 FIND v(dout1_28) AT=1470.05n

.meas tran vdout1_29ck1460 FIND v(dout1_29) AT=1470.05n

.meas tran vdout1_30ck1460 FIND v(dout1_30) AT=1470.05n

.meas tran vdout1_31ck1460 FIND v(dout1_31) AT=1470.05n

.meas tran vdout0_0ck1480 FIND v(dout0_0) AT=1490.05n

.meas tran vdout0_1ck1480 FIND v(dout0_1) AT=1490.05n

.meas tran vdout0_2ck1480 FIND v(dout0_2) AT=1490.05n

.meas tran vdout0_3ck1480 FIND v(dout0_3) AT=1490.05n

.meas tran vdout0_4ck1480 FIND v(dout0_4) AT=1490.05n

.meas tran vdout0_5ck1480 FIND v(dout0_5) AT=1490.05n

.meas tran vdout0_6ck1480 FIND v(dout0_6) AT=1490.05n

.meas tran vdout0_7ck1480 FIND v(dout0_7) AT=1490.05n

.meas tran vdout0_8ck1480 FIND v(dout0_8) AT=1490.05n

.meas tran vdout0_9ck1480 FIND v(dout0_9) AT=1490.05n

.meas tran vdout0_10ck1480 FIND v(dout0_10) AT=1490.05n

.meas tran vdout0_11ck1480 FIND v(dout0_11) AT=1490.05n

.meas tran vdout0_12ck1480 FIND v(dout0_12) AT=1490.05n

.meas tran vdout0_13ck1480 FIND v(dout0_13) AT=1490.05n

.meas tran vdout0_14ck1480 FIND v(dout0_14) AT=1490.05n

.meas tran vdout0_15ck1480 FIND v(dout0_15) AT=1490.05n

.meas tran vdout0_16ck1480 FIND v(dout0_16) AT=1490.05n

.meas tran vdout0_17ck1480 FIND v(dout0_17) AT=1490.05n

.meas tran vdout0_18ck1480 FIND v(dout0_18) AT=1490.05n

.meas tran vdout0_19ck1480 FIND v(dout0_19) AT=1490.05n

.meas tran vdout0_20ck1480 FIND v(dout0_20) AT=1490.05n

.meas tran vdout0_21ck1480 FIND v(dout0_21) AT=1490.05n

.meas tran vdout0_22ck1480 FIND v(dout0_22) AT=1490.05n

.meas tran vdout0_23ck1480 FIND v(dout0_23) AT=1490.05n

.meas tran vdout0_24ck1480 FIND v(dout0_24) AT=1490.05n

.meas tran vdout0_25ck1480 FIND v(dout0_25) AT=1490.05n

.meas tran vdout0_26ck1480 FIND v(dout0_26) AT=1490.05n

.meas tran vdout0_27ck1480 FIND v(dout0_27) AT=1490.05n

.meas tran vdout0_28ck1480 FIND v(dout0_28) AT=1490.05n

.meas tran vdout0_29ck1480 FIND v(dout0_29) AT=1490.05n

.meas tran vdout0_30ck1480 FIND v(dout0_30) AT=1490.05n

.meas tran vdout0_31ck1480 FIND v(dout0_31) AT=1490.05n

.meas tran vdout0_0ck1500 FIND v(dout0_0) AT=1510.05n

.meas tran vdout0_1ck1500 FIND v(dout0_1) AT=1510.05n

.meas tran vdout0_2ck1500 FIND v(dout0_2) AT=1510.05n

.meas tran vdout0_3ck1500 FIND v(dout0_3) AT=1510.05n

.meas tran vdout0_4ck1500 FIND v(dout0_4) AT=1510.05n

.meas tran vdout0_5ck1500 FIND v(dout0_5) AT=1510.05n

.meas tran vdout0_6ck1500 FIND v(dout0_6) AT=1510.05n

.meas tran vdout0_7ck1500 FIND v(dout0_7) AT=1510.05n

.meas tran vdout0_8ck1500 FIND v(dout0_8) AT=1510.05n

.meas tran vdout0_9ck1500 FIND v(dout0_9) AT=1510.05n

.meas tran vdout0_10ck1500 FIND v(dout0_10) AT=1510.05n

.meas tran vdout0_11ck1500 FIND v(dout0_11) AT=1510.05n

.meas tran vdout0_12ck1500 FIND v(dout0_12) AT=1510.05n

.meas tran vdout0_13ck1500 FIND v(dout0_13) AT=1510.05n

.meas tran vdout0_14ck1500 FIND v(dout0_14) AT=1510.05n

.meas tran vdout0_15ck1500 FIND v(dout0_15) AT=1510.05n

.meas tran vdout0_16ck1500 FIND v(dout0_16) AT=1510.05n

.meas tran vdout0_17ck1500 FIND v(dout0_17) AT=1510.05n

.meas tran vdout0_18ck1500 FIND v(dout0_18) AT=1510.05n

.meas tran vdout0_19ck1500 FIND v(dout0_19) AT=1510.05n

.meas tran vdout0_20ck1500 FIND v(dout0_20) AT=1510.05n

.meas tran vdout0_21ck1500 FIND v(dout0_21) AT=1510.05n

.meas tran vdout0_22ck1500 FIND v(dout0_22) AT=1510.05n

.meas tran vdout0_23ck1500 FIND v(dout0_23) AT=1510.05n

.meas tran vdout0_24ck1500 FIND v(dout0_24) AT=1510.05n

.meas tran vdout0_25ck1500 FIND v(dout0_25) AT=1510.05n

.meas tran vdout0_26ck1500 FIND v(dout0_26) AT=1510.05n

.meas tran vdout0_27ck1500 FIND v(dout0_27) AT=1510.05n

.meas tran vdout0_28ck1500 FIND v(dout0_28) AT=1510.05n

.meas tran vdout0_29ck1500 FIND v(dout0_29) AT=1510.05n

.meas tran vdout0_30ck1500 FIND v(dout0_30) AT=1510.05n

.meas tran vdout0_31ck1500 FIND v(dout0_31) AT=1510.05n

.meas tran vdout1_0ck1500 FIND v(dout1_0) AT=1510.05n

.meas tran vdout1_1ck1500 FIND v(dout1_1) AT=1510.05n

.meas tran vdout1_2ck1500 FIND v(dout1_2) AT=1510.05n

.meas tran vdout1_3ck1500 FIND v(dout1_3) AT=1510.05n

.meas tran vdout1_4ck1500 FIND v(dout1_4) AT=1510.05n

.meas tran vdout1_5ck1500 FIND v(dout1_5) AT=1510.05n

.meas tran vdout1_6ck1500 FIND v(dout1_6) AT=1510.05n

.meas tran vdout1_7ck1500 FIND v(dout1_7) AT=1510.05n

.meas tran vdout1_8ck1500 FIND v(dout1_8) AT=1510.05n

.meas tran vdout1_9ck1500 FIND v(dout1_9) AT=1510.05n

.meas tran vdout1_10ck1500 FIND v(dout1_10) AT=1510.05n

.meas tran vdout1_11ck1500 FIND v(dout1_11) AT=1510.05n

.meas tran vdout1_12ck1500 FIND v(dout1_12) AT=1510.05n

.meas tran vdout1_13ck1500 FIND v(dout1_13) AT=1510.05n

.meas tran vdout1_14ck1500 FIND v(dout1_14) AT=1510.05n

.meas tran vdout1_15ck1500 FIND v(dout1_15) AT=1510.05n

.meas tran vdout1_16ck1500 FIND v(dout1_16) AT=1510.05n

.meas tran vdout1_17ck1500 FIND v(dout1_17) AT=1510.05n

.meas tran vdout1_18ck1500 FIND v(dout1_18) AT=1510.05n

.meas tran vdout1_19ck1500 FIND v(dout1_19) AT=1510.05n

.meas tran vdout1_20ck1500 FIND v(dout1_20) AT=1510.05n

.meas tran vdout1_21ck1500 FIND v(dout1_21) AT=1510.05n

.meas tran vdout1_22ck1500 FIND v(dout1_22) AT=1510.05n

.meas tran vdout1_23ck1500 FIND v(dout1_23) AT=1510.05n

.meas tran vdout1_24ck1500 FIND v(dout1_24) AT=1510.05n

.meas tran vdout1_25ck1500 FIND v(dout1_25) AT=1510.05n

.meas tran vdout1_26ck1500 FIND v(dout1_26) AT=1510.05n

.meas tran vdout1_27ck1500 FIND v(dout1_27) AT=1510.05n

.meas tran vdout1_28ck1500 FIND v(dout1_28) AT=1510.05n

.meas tran vdout1_29ck1500 FIND v(dout1_29) AT=1510.05n

.meas tran vdout1_30ck1500 FIND v(dout1_30) AT=1510.05n

.meas tran vdout1_31ck1500 FIND v(dout1_31) AT=1510.05n

.meas tran vdout0_0ck1520 FIND v(dout0_0) AT=1530.05n

.meas tran vdout0_1ck1520 FIND v(dout0_1) AT=1530.05n

.meas tran vdout0_2ck1520 FIND v(dout0_2) AT=1530.05n

.meas tran vdout0_3ck1520 FIND v(dout0_3) AT=1530.05n

.meas tran vdout0_4ck1520 FIND v(dout0_4) AT=1530.05n

.meas tran vdout0_5ck1520 FIND v(dout0_5) AT=1530.05n

.meas tran vdout0_6ck1520 FIND v(dout0_6) AT=1530.05n

.meas tran vdout0_7ck1520 FIND v(dout0_7) AT=1530.05n

.meas tran vdout0_8ck1520 FIND v(dout0_8) AT=1530.05n

.meas tran vdout0_9ck1520 FIND v(dout0_9) AT=1530.05n

.meas tran vdout0_10ck1520 FIND v(dout0_10) AT=1530.05n

.meas tran vdout0_11ck1520 FIND v(dout0_11) AT=1530.05n

.meas tran vdout0_12ck1520 FIND v(dout0_12) AT=1530.05n

.meas tran vdout0_13ck1520 FIND v(dout0_13) AT=1530.05n

.meas tran vdout0_14ck1520 FIND v(dout0_14) AT=1530.05n

.meas tran vdout0_15ck1520 FIND v(dout0_15) AT=1530.05n

.meas tran vdout0_16ck1520 FIND v(dout0_16) AT=1530.05n

.meas tran vdout0_17ck1520 FIND v(dout0_17) AT=1530.05n

.meas tran vdout0_18ck1520 FIND v(dout0_18) AT=1530.05n

.meas tran vdout0_19ck1520 FIND v(dout0_19) AT=1530.05n

.meas tran vdout0_20ck1520 FIND v(dout0_20) AT=1530.05n

.meas tran vdout0_21ck1520 FIND v(dout0_21) AT=1530.05n

.meas tran vdout0_22ck1520 FIND v(dout0_22) AT=1530.05n

.meas tran vdout0_23ck1520 FIND v(dout0_23) AT=1530.05n

.meas tran vdout0_24ck1520 FIND v(dout0_24) AT=1530.05n

.meas tran vdout0_25ck1520 FIND v(dout0_25) AT=1530.05n

.meas tran vdout0_26ck1520 FIND v(dout0_26) AT=1530.05n

.meas tran vdout0_27ck1520 FIND v(dout0_27) AT=1530.05n

.meas tran vdout0_28ck1520 FIND v(dout0_28) AT=1530.05n

.meas tran vdout0_29ck1520 FIND v(dout0_29) AT=1530.05n

.meas tran vdout0_30ck1520 FIND v(dout0_30) AT=1530.05n

.meas tran vdout0_31ck1520 FIND v(dout0_31) AT=1530.05n

.meas tran vdout1_0ck1530 FIND v(dout1_0) AT=1540.05n

.meas tran vdout1_1ck1530 FIND v(dout1_1) AT=1540.05n

.meas tran vdout1_2ck1530 FIND v(dout1_2) AT=1540.05n

.meas tran vdout1_3ck1530 FIND v(dout1_3) AT=1540.05n

.meas tran vdout1_4ck1530 FIND v(dout1_4) AT=1540.05n

.meas tran vdout1_5ck1530 FIND v(dout1_5) AT=1540.05n

.meas tran vdout1_6ck1530 FIND v(dout1_6) AT=1540.05n

.meas tran vdout1_7ck1530 FIND v(dout1_7) AT=1540.05n

.meas tran vdout1_8ck1530 FIND v(dout1_8) AT=1540.05n

.meas tran vdout1_9ck1530 FIND v(dout1_9) AT=1540.05n

.meas tran vdout1_10ck1530 FIND v(dout1_10) AT=1540.05n

.meas tran vdout1_11ck1530 FIND v(dout1_11) AT=1540.05n

.meas tran vdout1_12ck1530 FIND v(dout1_12) AT=1540.05n

.meas tran vdout1_13ck1530 FIND v(dout1_13) AT=1540.05n

.meas tran vdout1_14ck1530 FIND v(dout1_14) AT=1540.05n

.meas tran vdout1_15ck1530 FIND v(dout1_15) AT=1540.05n

.meas tran vdout1_16ck1530 FIND v(dout1_16) AT=1540.05n

.meas tran vdout1_17ck1530 FIND v(dout1_17) AT=1540.05n

.meas tran vdout1_18ck1530 FIND v(dout1_18) AT=1540.05n

.meas tran vdout1_19ck1530 FIND v(dout1_19) AT=1540.05n

.meas tran vdout1_20ck1530 FIND v(dout1_20) AT=1540.05n

.meas tran vdout1_21ck1530 FIND v(dout1_21) AT=1540.05n

.meas tran vdout1_22ck1530 FIND v(dout1_22) AT=1540.05n

.meas tran vdout1_23ck1530 FIND v(dout1_23) AT=1540.05n

.meas tran vdout1_24ck1530 FIND v(dout1_24) AT=1540.05n

.meas tran vdout1_25ck1530 FIND v(dout1_25) AT=1540.05n

.meas tran vdout1_26ck1530 FIND v(dout1_26) AT=1540.05n

.meas tran vdout1_27ck1530 FIND v(dout1_27) AT=1540.05n

.meas tran vdout1_28ck1530 FIND v(dout1_28) AT=1540.05n

.meas tran vdout1_29ck1530 FIND v(dout1_29) AT=1540.05n

.meas tran vdout1_30ck1530 FIND v(dout1_30) AT=1540.05n

.meas tran vdout1_31ck1530 FIND v(dout1_31) AT=1540.05n

.meas tran vdout0_0ck1540 FIND v(dout0_0) AT=1550.05n

.meas tran vdout0_1ck1540 FIND v(dout0_1) AT=1550.05n

.meas tran vdout0_2ck1540 FIND v(dout0_2) AT=1550.05n

.meas tran vdout0_3ck1540 FIND v(dout0_3) AT=1550.05n

.meas tran vdout0_4ck1540 FIND v(dout0_4) AT=1550.05n

.meas tran vdout0_5ck1540 FIND v(dout0_5) AT=1550.05n

.meas tran vdout0_6ck1540 FIND v(dout0_6) AT=1550.05n

.meas tran vdout0_7ck1540 FIND v(dout0_7) AT=1550.05n

.meas tran vdout0_8ck1540 FIND v(dout0_8) AT=1550.05n

.meas tran vdout0_9ck1540 FIND v(dout0_9) AT=1550.05n

.meas tran vdout0_10ck1540 FIND v(dout0_10) AT=1550.05n

.meas tran vdout0_11ck1540 FIND v(dout0_11) AT=1550.05n

.meas tran vdout0_12ck1540 FIND v(dout0_12) AT=1550.05n

.meas tran vdout0_13ck1540 FIND v(dout0_13) AT=1550.05n

.meas tran vdout0_14ck1540 FIND v(dout0_14) AT=1550.05n

.meas tran vdout0_15ck1540 FIND v(dout0_15) AT=1550.05n

.meas tran vdout0_16ck1540 FIND v(dout0_16) AT=1550.05n

.meas tran vdout0_17ck1540 FIND v(dout0_17) AT=1550.05n

.meas tran vdout0_18ck1540 FIND v(dout0_18) AT=1550.05n

.meas tran vdout0_19ck1540 FIND v(dout0_19) AT=1550.05n

.meas tran vdout0_20ck1540 FIND v(dout0_20) AT=1550.05n

.meas tran vdout0_21ck1540 FIND v(dout0_21) AT=1550.05n

.meas tran vdout0_22ck1540 FIND v(dout0_22) AT=1550.05n

.meas tran vdout0_23ck1540 FIND v(dout0_23) AT=1550.05n

.meas tran vdout0_24ck1540 FIND v(dout0_24) AT=1550.05n

.meas tran vdout0_25ck1540 FIND v(dout0_25) AT=1550.05n

.meas tran vdout0_26ck1540 FIND v(dout0_26) AT=1550.05n

.meas tran vdout0_27ck1540 FIND v(dout0_27) AT=1550.05n

.meas tran vdout0_28ck1540 FIND v(dout0_28) AT=1550.05n

.meas tran vdout0_29ck1540 FIND v(dout0_29) AT=1550.05n

.meas tran vdout0_30ck1540 FIND v(dout0_30) AT=1550.05n

.meas tran vdout0_31ck1540 FIND v(dout0_31) AT=1550.05n

.meas tran vdout1_0ck1550 FIND v(dout1_0) AT=1560.05n

.meas tran vdout1_1ck1550 FIND v(dout1_1) AT=1560.05n

.meas tran vdout1_2ck1550 FIND v(dout1_2) AT=1560.05n

.meas tran vdout1_3ck1550 FIND v(dout1_3) AT=1560.05n

.meas tran vdout1_4ck1550 FIND v(dout1_4) AT=1560.05n

.meas tran vdout1_5ck1550 FIND v(dout1_5) AT=1560.05n

.meas tran vdout1_6ck1550 FIND v(dout1_6) AT=1560.05n

.meas tran vdout1_7ck1550 FIND v(dout1_7) AT=1560.05n

.meas tran vdout1_8ck1550 FIND v(dout1_8) AT=1560.05n

.meas tran vdout1_9ck1550 FIND v(dout1_9) AT=1560.05n

.meas tran vdout1_10ck1550 FIND v(dout1_10) AT=1560.05n

.meas tran vdout1_11ck1550 FIND v(dout1_11) AT=1560.05n

.meas tran vdout1_12ck1550 FIND v(dout1_12) AT=1560.05n

.meas tran vdout1_13ck1550 FIND v(dout1_13) AT=1560.05n

.meas tran vdout1_14ck1550 FIND v(dout1_14) AT=1560.05n

.meas tran vdout1_15ck1550 FIND v(dout1_15) AT=1560.05n

.meas tran vdout1_16ck1550 FIND v(dout1_16) AT=1560.05n

.meas tran vdout1_17ck1550 FIND v(dout1_17) AT=1560.05n

.meas tran vdout1_18ck1550 FIND v(dout1_18) AT=1560.05n

.meas tran vdout1_19ck1550 FIND v(dout1_19) AT=1560.05n

.meas tran vdout1_20ck1550 FIND v(dout1_20) AT=1560.05n

.meas tran vdout1_21ck1550 FIND v(dout1_21) AT=1560.05n

.meas tran vdout1_22ck1550 FIND v(dout1_22) AT=1560.05n

.meas tran vdout1_23ck1550 FIND v(dout1_23) AT=1560.05n

.meas tran vdout1_24ck1550 FIND v(dout1_24) AT=1560.05n

.meas tran vdout1_25ck1550 FIND v(dout1_25) AT=1560.05n

.meas tran vdout1_26ck1550 FIND v(dout1_26) AT=1560.05n

.meas tran vdout1_27ck1550 FIND v(dout1_27) AT=1560.05n

.meas tran vdout1_28ck1550 FIND v(dout1_28) AT=1560.05n

.meas tran vdout1_29ck1550 FIND v(dout1_29) AT=1560.05n

.meas tran vdout1_30ck1550 FIND v(dout1_30) AT=1560.05n

.meas tran vdout1_31ck1550 FIND v(dout1_31) AT=1560.05n

.meas tran vdout0_0ck1560 FIND v(dout0_0) AT=1570.05n

.meas tran vdout0_1ck1560 FIND v(dout0_1) AT=1570.05n

.meas tran vdout0_2ck1560 FIND v(dout0_2) AT=1570.05n

.meas tran vdout0_3ck1560 FIND v(dout0_3) AT=1570.05n

.meas tran vdout0_4ck1560 FIND v(dout0_4) AT=1570.05n

.meas tran vdout0_5ck1560 FIND v(dout0_5) AT=1570.05n

.meas tran vdout0_6ck1560 FIND v(dout0_6) AT=1570.05n

.meas tran vdout0_7ck1560 FIND v(dout0_7) AT=1570.05n

.meas tran vdout0_8ck1560 FIND v(dout0_8) AT=1570.05n

.meas tran vdout0_9ck1560 FIND v(dout0_9) AT=1570.05n

.meas tran vdout0_10ck1560 FIND v(dout0_10) AT=1570.05n

.meas tran vdout0_11ck1560 FIND v(dout0_11) AT=1570.05n

.meas tran vdout0_12ck1560 FIND v(dout0_12) AT=1570.05n

.meas tran vdout0_13ck1560 FIND v(dout0_13) AT=1570.05n

.meas tran vdout0_14ck1560 FIND v(dout0_14) AT=1570.05n

.meas tran vdout0_15ck1560 FIND v(dout0_15) AT=1570.05n

.meas tran vdout0_16ck1560 FIND v(dout0_16) AT=1570.05n

.meas tran vdout0_17ck1560 FIND v(dout0_17) AT=1570.05n

.meas tran vdout0_18ck1560 FIND v(dout0_18) AT=1570.05n

.meas tran vdout0_19ck1560 FIND v(dout0_19) AT=1570.05n

.meas tran vdout0_20ck1560 FIND v(dout0_20) AT=1570.05n

.meas tran vdout0_21ck1560 FIND v(dout0_21) AT=1570.05n

.meas tran vdout0_22ck1560 FIND v(dout0_22) AT=1570.05n

.meas tran vdout0_23ck1560 FIND v(dout0_23) AT=1570.05n

.meas tran vdout0_24ck1560 FIND v(dout0_24) AT=1570.05n

.meas tran vdout0_25ck1560 FIND v(dout0_25) AT=1570.05n

.meas tran vdout0_26ck1560 FIND v(dout0_26) AT=1570.05n

.meas tran vdout0_27ck1560 FIND v(dout0_27) AT=1570.05n

.meas tran vdout0_28ck1560 FIND v(dout0_28) AT=1570.05n

.meas tran vdout0_29ck1560 FIND v(dout0_29) AT=1570.05n

.meas tran vdout0_30ck1560 FIND v(dout0_30) AT=1570.05n

.meas tran vdout0_31ck1560 FIND v(dout0_31) AT=1570.05n

.meas tran vdout1_0ck1560 FIND v(dout1_0) AT=1570.05n

.meas tran vdout1_1ck1560 FIND v(dout1_1) AT=1570.05n

.meas tran vdout1_2ck1560 FIND v(dout1_2) AT=1570.05n

.meas tran vdout1_3ck1560 FIND v(dout1_3) AT=1570.05n

.meas tran vdout1_4ck1560 FIND v(dout1_4) AT=1570.05n

.meas tran vdout1_5ck1560 FIND v(dout1_5) AT=1570.05n

.meas tran vdout1_6ck1560 FIND v(dout1_6) AT=1570.05n

.meas tran vdout1_7ck1560 FIND v(dout1_7) AT=1570.05n

.meas tran vdout1_8ck1560 FIND v(dout1_8) AT=1570.05n

.meas tran vdout1_9ck1560 FIND v(dout1_9) AT=1570.05n

.meas tran vdout1_10ck1560 FIND v(dout1_10) AT=1570.05n

.meas tran vdout1_11ck1560 FIND v(dout1_11) AT=1570.05n

.meas tran vdout1_12ck1560 FIND v(dout1_12) AT=1570.05n

.meas tran vdout1_13ck1560 FIND v(dout1_13) AT=1570.05n

.meas tran vdout1_14ck1560 FIND v(dout1_14) AT=1570.05n

.meas tran vdout1_15ck1560 FIND v(dout1_15) AT=1570.05n

.meas tran vdout1_16ck1560 FIND v(dout1_16) AT=1570.05n

.meas tran vdout1_17ck1560 FIND v(dout1_17) AT=1570.05n

.meas tran vdout1_18ck1560 FIND v(dout1_18) AT=1570.05n

.meas tran vdout1_19ck1560 FIND v(dout1_19) AT=1570.05n

.meas tran vdout1_20ck1560 FIND v(dout1_20) AT=1570.05n

.meas tran vdout1_21ck1560 FIND v(dout1_21) AT=1570.05n

.meas tran vdout1_22ck1560 FIND v(dout1_22) AT=1570.05n

.meas tran vdout1_23ck1560 FIND v(dout1_23) AT=1570.05n

.meas tran vdout1_24ck1560 FIND v(dout1_24) AT=1570.05n

.meas tran vdout1_25ck1560 FIND v(dout1_25) AT=1570.05n

.meas tran vdout1_26ck1560 FIND v(dout1_26) AT=1570.05n

.meas tran vdout1_27ck1560 FIND v(dout1_27) AT=1570.05n

.meas tran vdout1_28ck1560 FIND v(dout1_28) AT=1570.05n

.meas tran vdout1_29ck1560 FIND v(dout1_29) AT=1570.05n

.meas tran vdout1_30ck1560 FIND v(dout1_30) AT=1570.05n

.meas tran vdout1_31ck1560 FIND v(dout1_31) AT=1570.05n

.meas tran vdout0_0ck1580 FIND v(dout0_0) AT=1590.05n

.meas tran vdout0_1ck1580 FIND v(dout0_1) AT=1590.05n

.meas tran vdout0_2ck1580 FIND v(dout0_2) AT=1590.05n

.meas tran vdout0_3ck1580 FIND v(dout0_3) AT=1590.05n

.meas tran vdout0_4ck1580 FIND v(dout0_4) AT=1590.05n

.meas tran vdout0_5ck1580 FIND v(dout0_5) AT=1590.05n

.meas tran vdout0_6ck1580 FIND v(dout0_6) AT=1590.05n

.meas tran vdout0_7ck1580 FIND v(dout0_7) AT=1590.05n

.meas tran vdout0_8ck1580 FIND v(dout0_8) AT=1590.05n

.meas tran vdout0_9ck1580 FIND v(dout0_9) AT=1590.05n

.meas tran vdout0_10ck1580 FIND v(dout0_10) AT=1590.05n

.meas tran vdout0_11ck1580 FIND v(dout0_11) AT=1590.05n

.meas tran vdout0_12ck1580 FIND v(dout0_12) AT=1590.05n

.meas tran vdout0_13ck1580 FIND v(dout0_13) AT=1590.05n

.meas tran vdout0_14ck1580 FIND v(dout0_14) AT=1590.05n

.meas tran vdout0_15ck1580 FIND v(dout0_15) AT=1590.05n

.meas tran vdout0_16ck1580 FIND v(dout0_16) AT=1590.05n

.meas tran vdout0_17ck1580 FIND v(dout0_17) AT=1590.05n

.meas tran vdout0_18ck1580 FIND v(dout0_18) AT=1590.05n

.meas tran vdout0_19ck1580 FIND v(dout0_19) AT=1590.05n

.meas tran vdout0_20ck1580 FIND v(dout0_20) AT=1590.05n

.meas tran vdout0_21ck1580 FIND v(dout0_21) AT=1590.05n

.meas tran vdout0_22ck1580 FIND v(dout0_22) AT=1590.05n

.meas tran vdout0_23ck1580 FIND v(dout0_23) AT=1590.05n

.meas tran vdout0_24ck1580 FIND v(dout0_24) AT=1590.05n

.meas tran vdout0_25ck1580 FIND v(dout0_25) AT=1590.05n

.meas tran vdout0_26ck1580 FIND v(dout0_26) AT=1590.05n

.meas tran vdout0_27ck1580 FIND v(dout0_27) AT=1590.05n

.meas tran vdout0_28ck1580 FIND v(dout0_28) AT=1590.05n

.meas tran vdout0_29ck1580 FIND v(dout0_29) AT=1590.05n

.meas tran vdout0_30ck1580 FIND v(dout0_30) AT=1590.05n

.meas tran vdout0_31ck1580 FIND v(dout0_31) AT=1590.05n

.meas tran vdout1_0ck1580 FIND v(dout1_0) AT=1590.05n

.meas tran vdout1_1ck1580 FIND v(dout1_1) AT=1590.05n

.meas tran vdout1_2ck1580 FIND v(dout1_2) AT=1590.05n

.meas tran vdout1_3ck1580 FIND v(dout1_3) AT=1590.05n

.meas tran vdout1_4ck1580 FIND v(dout1_4) AT=1590.05n

.meas tran vdout1_5ck1580 FIND v(dout1_5) AT=1590.05n

.meas tran vdout1_6ck1580 FIND v(dout1_6) AT=1590.05n

.meas tran vdout1_7ck1580 FIND v(dout1_7) AT=1590.05n

.meas tran vdout1_8ck1580 FIND v(dout1_8) AT=1590.05n

.meas tran vdout1_9ck1580 FIND v(dout1_9) AT=1590.05n

.meas tran vdout1_10ck1580 FIND v(dout1_10) AT=1590.05n

.meas tran vdout1_11ck1580 FIND v(dout1_11) AT=1590.05n

.meas tran vdout1_12ck1580 FIND v(dout1_12) AT=1590.05n

.meas tran vdout1_13ck1580 FIND v(dout1_13) AT=1590.05n

.meas tran vdout1_14ck1580 FIND v(dout1_14) AT=1590.05n

.meas tran vdout1_15ck1580 FIND v(dout1_15) AT=1590.05n

.meas tran vdout1_16ck1580 FIND v(dout1_16) AT=1590.05n

.meas tran vdout1_17ck1580 FIND v(dout1_17) AT=1590.05n

.meas tran vdout1_18ck1580 FIND v(dout1_18) AT=1590.05n

.meas tran vdout1_19ck1580 FIND v(dout1_19) AT=1590.05n

.meas tran vdout1_20ck1580 FIND v(dout1_20) AT=1590.05n

.meas tran vdout1_21ck1580 FIND v(dout1_21) AT=1590.05n

.meas tran vdout1_22ck1580 FIND v(dout1_22) AT=1590.05n

.meas tran vdout1_23ck1580 FIND v(dout1_23) AT=1590.05n

.meas tran vdout1_24ck1580 FIND v(dout1_24) AT=1590.05n

.meas tran vdout1_25ck1580 FIND v(dout1_25) AT=1590.05n

.meas tran vdout1_26ck1580 FIND v(dout1_26) AT=1590.05n

.meas tran vdout1_27ck1580 FIND v(dout1_27) AT=1590.05n

.meas tran vdout1_28ck1580 FIND v(dout1_28) AT=1590.05n

.meas tran vdout1_29ck1580 FIND v(dout1_29) AT=1590.05n

.meas tran vdout1_30ck1580 FIND v(dout1_30) AT=1590.05n

.meas tran vdout1_31ck1580 FIND v(dout1_31) AT=1590.05n

.meas tran vdout0_0ck1590 FIND v(dout0_0) AT=1600.05n

.meas tran vdout0_1ck1590 FIND v(dout0_1) AT=1600.05n

.meas tran vdout0_2ck1590 FIND v(dout0_2) AT=1600.05n

.meas tran vdout0_3ck1590 FIND v(dout0_3) AT=1600.05n

.meas tran vdout0_4ck1590 FIND v(dout0_4) AT=1600.05n

.meas tran vdout0_5ck1590 FIND v(dout0_5) AT=1600.05n

.meas tran vdout0_6ck1590 FIND v(dout0_6) AT=1600.05n

.meas tran vdout0_7ck1590 FIND v(dout0_7) AT=1600.05n

.meas tran vdout0_8ck1590 FIND v(dout0_8) AT=1600.05n

.meas tran vdout0_9ck1590 FIND v(dout0_9) AT=1600.05n

.meas tran vdout0_10ck1590 FIND v(dout0_10) AT=1600.05n

.meas tran vdout0_11ck1590 FIND v(dout0_11) AT=1600.05n

.meas tran vdout0_12ck1590 FIND v(dout0_12) AT=1600.05n

.meas tran vdout0_13ck1590 FIND v(dout0_13) AT=1600.05n

.meas tran vdout0_14ck1590 FIND v(dout0_14) AT=1600.05n

.meas tran vdout0_15ck1590 FIND v(dout0_15) AT=1600.05n

.meas tran vdout0_16ck1590 FIND v(dout0_16) AT=1600.05n

.meas tran vdout0_17ck1590 FIND v(dout0_17) AT=1600.05n

.meas tran vdout0_18ck1590 FIND v(dout0_18) AT=1600.05n

.meas tran vdout0_19ck1590 FIND v(dout0_19) AT=1600.05n

.meas tran vdout0_20ck1590 FIND v(dout0_20) AT=1600.05n

.meas tran vdout0_21ck1590 FIND v(dout0_21) AT=1600.05n

.meas tran vdout0_22ck1590 FIND v(dout0_22) AT=1600.05n

.meas tran vdout0_23ck1590 FIND v(dout0_23) AT=1600.05n

.meas tran vdout0_24ck1590 FIND v(dout0_24) AT=1600.05n

.meas tran vdout0_25ck1590 FIND v(dout0_25) AT=1600.05n

.meas tran vdout0_26ck1590 FIND v(dout0_26) AT=1600.05n

.meas tran vdout0_27ck1590 FIND v(dout0_27) AT=1600.05n

.meas tran vdout0_28ck1590 FIND v(dout0_28) AT=1600.05n

.meas tran vdout0_29ck1590 FIND v(dout0_29) AT=1600.05n

.meas tran vdout0_30ck1590 FIND v(dout0_30) AT=1600.05n

.meas tran vdout0_31ck1590 FIND v(dout0_31) AT=1600.05n

.meas tran vdout1_0ck1590 FIND v(dout1_0) AT=1600.05n

.meas tran vdout1_1ck1590 FIND v(dout1_1) AT=1600.05n

.meas tran vdout1_2ck1590 FIND v(dout1_2) AT=1600.05n

.meas tran vdout1_3ck1590 FIND v(dout1_3) AT=1600.05n

.meas tran vdout1_4ck1590 FIND v(dout1_4) AT=1600.05n

.meas tran vdout1_5ck1590 FIND v(dout1_5) AT=1600.05n

.meas tran vdout1_6ck1590 FIND v(dout1_6) AT=1600.05n

.meas tran vdout1_7ck1590 FIND v(dout1_7) AT=1600.05n

.meas tran vdout1_8ck1590 FIND v(dout1_8) AT=1600.05n

.meas tran vdout1_9ck1590 FIND v(dout1_9) AT=1600.05n

.meas tran vdout1_10ck1590 FIND v(dout1_10) AT=1600.05n

.meas tran vdout1_11ck1590 FIND v(dout1_11) AT=1600.05n

.meas tran vdout1_12ck1590 FIND v(dout1_12) AT=1600.05n

.meas tran vdout1_13ck1590 FIND v(dout1_13) AT=1600.05n

.meas tran vdout1_14ck1590 FIND v(dout1_14) AT=1600.05n

.meas tran vdout1_15ck1590 FIND v(dout1_15) AT=1600.05n

.meas tran vdout1_16ck1590 FIND v(dout1_16) AT=1600.05n

.meas tran vdout1_17ck1590 FIND v(dout1_17) AT=1600.05n

.meas tran vdout1_18ck1590 FIND v(dout1_18) AT=1600.05n

.meas tran vdout1_19ck1590 FIND v(dout1_19) AT=1600.05n

.meas tran vdout1_20ck1590 FIND v(dout1_20) AT=1600.05n

.meas tran vdout1_21ck1590 FIND v(dout1_21) AT=1600.05n

.meas tran vdout1_22ck1590 FIND v(dout1_22) AT=1600.05n

.meas tran vdout1_23ck1590 FIND v(dout1_23) AT=1600.05n

.meas tran vdout1_24ck1590 FIND v(dout1_24) AT=1600.05n

.meas tran vdout1_25ck1590 FIND v(dout1_25) AT=1600.05n

.meas tran vdout1_26ck1590 FIND v(dout1_26) AT=1600.05n

.meas tran vdout1_27ck1590 FIND v(dout1_27) AT=1600.05n

.meas tran vdout1_28ck1590 FIND v(dout1_28) AT=1600.05n

.meas tran vdout1_29ck1590 FIND v(dout1_29) AT=1600.05n

.meas tran vdout1_30ck1590 FIND v(dout1_30) AT=1600.05n

.meas tran vdout1_31ck1590 FIND v(dout1_31) AT=1600.05n

.meas tran vdout1_0ck1620 FIND v(dout1_0) AT=1630.05n

.meas tran vdout1_1ck1620 FIND v(dout1_1) AT=1630.05n

.meas tran vdout1_2ck1620 FIND v(dout1_2) AT=1630.05n

.meas tran vdout1_3ck1620 FIND v(dout1_3) AT=1630.05n

.meas tran vdout1_4ck1620 FIND v(dout1_4) AT=1630.05n

.meas tran vdout1_5ck1620 FIND v(dout1_5) AT=1630.05n

.meas tran vdout1_6ck1620 FIND v(dout1_6) AT=1630.05n

.meas tran vdout1_7ck1620 FIND v(dout1_7) AT=1630.05n

.meas tran vdout1_8ck1620 FIND v(dout1_8) AT=1630.05n

.meas tran vdout1_9ck1620 FIND v(dout1_9) AT=1630.05n

.meas tran vdout1_10ck1620 FIND v(dout1_10) AT=1630.05n

.meas tran vdout1_11ck1620 FIND v(dout1_11) AT=1630.05n

.meas tran vdout1_12ck1620 FIND v(dout1_12) AT=1630.05n

.meas tran vdout1_13ck1620 FIND v(dout1_13) AT=1630.05n

.meas tran vdout1_14ck1620 FIND v(dout1_14) AT=1630.05n

.meas tran vdout1_15ck1620 FIND v(dout1_15) AT=1630.05n

.meas tran vdout1_16ck1620 FIND v(dout1_16) AT=1630.05n

.meas tran vdout1_17ck1620 FIND v(dout1_17) AT=1630.05n

.meas tran vdout1_18ck1620 FIND v(dout1_18) AT=1630.05n

.meas tran vdout1_19ck1620 FIND v(dout1_19) AT=1630.05n

.meas tran vdout1_20ck1620 FIND v(dout1_20) AT=1630.05n

.meas tran vdout1_21ck1620 FIND v(dout1_21) AT=1630.05n

.meas tran vdout1_22ck1620 FIND v(dout1_22) AT=1630.05n

.meas tran vdout1_23ck1620 FIND v(dout1_23) AT=1630.05n

.meas tran vdout1_24ck1620 FIND v(dout1_24) AT=1630.05n

.meas tran vdout1_25ck1620 FIND v(dout1_25) AT=1630.05n

.meas tran vdout1_26ck1620 FIND v(dout1_26) AT=1630.05n

.meas tran vdout1_27ck1620 FIND v(dout1_27) AT=1630.05n

.meas tran vdout1_28ck1620 FIND v(dout1_28) AT=1630.05n

.meas tran vdout1_29ck1620 FIND v(dout1_29) AT=1630.05n

.meas tran vdout1_30ck1620 FIND v(dout1_30) AT=1630.05n

.meas tran vdout1_31ck1620 FIND v(dout1_31) AT=1630.05n

.meas tran vdout1_0ck1640 FIND v(dout1_0) AT=1650.05n

.meas tran vdout1_1ck1640 FIND v(dout1_1) AT=1650.05n

.meas tran vdout1_2ck1640 FIND v(dout1_2) AT=1650.05n

.meas tran vdout1_3ck1640 FIND v(dout1_3) AT=1650.05n

.meas tran vdout1_4ck1640 FIND v(dout1_4) AT=1650.05n

.meas tran vdout1_5ck1640 FIND v(dout1_5) AT=1650.05n

.meas tran vdout1_6ck1640 FIND v(dout1_6) AT=1650.05n

.meas tran vdout1_7ck1640 FIND v(dout1_7) AT=1650.05n

.meas tran vdout1_8ck1640 FIND v(dout1_8) AT=1650.05n

.meas tran vdout1_9ck1640 FIND v(dout1_9) AT=1650.05n

.meas tran vdout1_10ck1640 FIND v(dout1_10) AT=1650.05n

.meas tran vdout1_11ck1640 FIND v(dout1_11) AT=1650.05n

.meas tran vdout1_12ck1640 FIND v(dout1_12) AT=1650.05n

.meas tran vdout1_13ck1640 FIND v(dout1_13) AT=1650.05n

.meas tran vdout1_14ck1640 FIND v(dout1_14) AT=1650.05n

.meas tran vdout1_15ck1640 FIND v(dout1_15) AT=1650.05n

.meas tran vdout1_16ck1640 FIND v(dout1_16) AT=1650.05n

.meas tran vdout1_17ck1640 FIND v(dout1_17) AT=1650.05n

.meas tran vdout1_18ck1640 FIND v(dout1_18) AT=1650.05n

.meas tran vdout1_19ck1640 FIND v(dout1_19) AT=1650.05n

.meas tran vdout1_20ck1640 FIND v(dout1_20) AT=1650.05n

.meas tran vdout1_21ck1640 FIND v(dout1_21) AT=1650.05n

.meas tran vdout1_22ck1640 FIND v(dout1_22) AT=1650.05n

.meas tran vdout1_23ck1640 FIND v(dout1_23) AT=1650.05n

.meas tran vdout1_24ck1640 FIND v(dout1_24) AT=1650.05n

.meas tran vdout1_25ck1640 FIND v(dout1_25) AT=1650.05n

.meas tran vdout1_26ck1640 FIND v(dout1_26) AT=1650.05n

.meas tran vdout1_27ck1640 FIND v(dout1_27) AT=1650.05n

.meas tran vdout1_28ck1640 FIND v(dout1_28) AT=1650.05n

.meas tran vdout1_29ck1640 FIND v(dout1_29) AT=1650.05n

.meas tran vdout1_30ck1640 FIND v(dout1_30) AT=1650.05n

.meas tran vdout1_31ck1640 FIND v(dout1_31) AT=1650.05n

.meas tran vdout1_0ck1650 FIND v(dout1_0) AT=1660.05n

.meas tran vdout1_1ck1650 FIND v(dout1_1) AT=1660.05n

.meas tran vdout1_2ck1650 FIND v(dout1_2) AT=1660.05n

.meas tran vdout1_3ck1650 FIND v(dout1_3) AT=1660.05n

.meas tran vdout1_4ck1650 FIND v(dout1_4) AT=1660.05n

.meas tran vdout1_5ck1650 FIND v(dout1_5) AT=1660.05n

.meas tran vdout1_6ck1650 FIND v(dout1_6) AT=1660.05n

.meas tran vdout1_7ck1650 FIND v(dout1_7) AT=1660.05n

.meas tran vdout1_8ck1650 FIND v(dout1_8) AT=1660.05n

.meas tran vdout1_9ck1650 FIND v(dout1_9) AT=1660.05n

.meas tran vdout1_10ck1650 FIND v(dout1_10) AT=1660.05n

.meas tran vdout1_11ck1650 FIND v(dout1_11) AT=1660.05n

.meas tran vdout1_12ck1650 FIND v(dout1_12) AT=1660.05n

.meas tran vdout1_13ck1650 FIND v(dout1_13) AT=1660.05n

.meas tran vdout1_14ck1650 FIND v(dout1_14) AT=1660.05n

.meas tran vdout1_15ck1650 FIND v(dout1_15) AT=1660.05n

.meas tran vdout1_16ck1650 FIND v(dout1_16) AT=1660.05n

.meas tran vdout1_17ck1650 FIND v(dout1_17) AT=1660.05n

.meas tran vdout1_18ck1650 FIND v(dout1_18) AT=1660.05n

.meas tran vdout1_19ck1650 FIND v(dout1_19) AT=1660.05n

.meas tran vdout1_20ck1650 FIND v(dout1_20) AT=1660.05n

.meas tran vdout1_21ck1650 FIND v(dout1_21) AT=1660.05n

.meas tran vdout1_22ck1650 FIND v(dout1_22) AT=1660.05n

.meas tran vdout1_23ck1650 FIND v(dout1_23) AT=1660.05n

.meas tran vdout1_24ck1650 FIND v(dout1_24) AT=1660.05n

.meas tran vdout1_25ck1650 FIND v(dout1_25) AT=1660.05n

.meas tran vdout1_26ck1650 FIND v(dout1_26) AT=1660.05n

.meas tran vdout1_27ck1650 FIND v(dout1_27) AT=1660.05n

.meas tran vdout1_28ck1650 FIND v(dout1_28) AT=1660.05n

.meas tran vdout1_29ck1650 FIND v(dout1_29) AT=1660.05n

.meas tran vdout1_30ck1650 FIND v(dout1_30) AT=1660.05n

.meas tran vdout1_31ck1650 FIND v(dout1_31) AT=1660.05n

.meas tran vdout0_0ck1680 FIND v(dout0_0) AT=1690.05n

.meas tran vdout0_1ck1680 FIND v(dout0_1) AT=1690.05n

.meas tran vdout0_2ck1680 FIND v(dout0_2) AT=1690.05n

.meas tran vdout0_3ck1680 FIND v(dout0_3) AT=1690.05n

.meas tran vdout0_4ck1680 FIND v(dout0_4) AT=1690.05n

.meas tran vdout0_5ck1680 FIND v(dout0_5) AT=1690.05n

.meas tran vdout0_6ck1680 FIND v(dout0_6) AT=1690.05n

.meas tran vdout0_7ck1680 FIND v(dout0_7) AT=1690.05n

.meas tran vdout0_8ck1680 FIND v(dout0_8) AT=1690.05n

.meas tran vdout0_9ck1680 FIND v(dout0_9) AT=1690.05n

.meas tran vdout0_10ck1680 FIND v(dout0_10) AT=1690.05n

.meas tran vdout0_11ck1680 FIND v(dout0_11) AT=1690.05n

.meas tran vdout0_12ck1680 FIND v(dout0_12) AT=1690.05n

.meas tran vdout0_13ck1680 FIND v(dout0_13) AT=1690.05n

.meas tran vdout0_14ck1680 FIND v(dout0_14) AT=1690.05n

.meas tran vdout0_15ck1680 FIND v(dout0_15) AT=1690.05n

.meas tran vdout0_16ck1680 FIND v(dout0_16) AT=1690.05n

.meas tran vdout0_17ck1680 FIND v(dout0_17) AT=1690.05n

.meas tran vdout0_18ck1680 FIND v(dout0_18) AT=1690.05n

.meas tran vdout0_19ck1680 FIND v(dout0_19) AT=1690.05n

.meas tran vdout0_20ck1680 FIND v(dout0_20) AT=1690.05n

.meas tran vdout0_21ck1680 FIND v(dout0_21) AT=1690.05n

.meas tran vdout0_22ck1680 FIND v(dout0_22) AT=1690.05n

.meas tran vdout0_23ck1680 FIND v(dout0_23) AT=1690.05n

.meas tran vdout0_24ck1680 FIND v(dout0_24) AT=1690.05n

.meas tran vdout0_25ck1680 FIND v(dout0_25) AT=1690.05n

.meas tran vdout0_26ck1680 FIND v(dout0_26) AT=1690.05n

.meas tran vdout0_27ck1680 FIND v(dout0_27) AT=1690.05n

.meas tran vdout0_28ck1680 FIND v(dout0_28) AT=1690.05n

.meas tran vdout0_29ck1680 FIND v(dout0_29) AT=1690.05n

.meas tran vdout0_30ck1680 FIND v(dout0_30) AT=1690.05n

.meas tran vdout0_31ck1680 FIND v(dout0_31) AT=1690.05n

.meas tran vdout0_0ck1690 FIND v(dout0_0) AT=1700.05n

.meas tran vdout0_1ck1690 FIND v(dout0_1) AT=1700.05n

.meas tran vdout0_2ck1690 FIND v(dout0_2) AT=1700.05n

.meas tran vdout0_3ck1690 FIND v(dout0_3) AT=1700.05n

.meas tran vdout0_4ck1690 FIND v(dout0_4) AT=1700.05n

.meas tran vdout0_5ck1690 FIND v(dout0_5) AT=1700.05n

.meas tran vdout0_6ck1690 FIND v(dout0_6) AT=1700.05n

.meas tran vdout0_7ck1690 FIND v(dout0_7) AT=1700.05n

.meas tran vdout0_8ck1690 FIND v(dout0_8) AT=1700.05n

.meas tran vdout0_9ck1690 FIND v(dout0_9) AT=1700.05n

.meas tran vdout0_10ck1690 FIND v(dout0_10) AT=1700.05n

.meas tran vdout0_11ck1690 FIND v(dout0_11) AT=1700.05n

.meas tran vdout0_12ck1690 FIND v(dout0_12) AT=1700.05n

.meas tran vdout0_13ck1690 FIND v(dout0_13) AT=1700.05n

.meas tran vdout0_14ck1690 FIND v(dout0_14) AT=1700.05n

.meas tran vdout0_15ck1690 FIND v(dout0_15) AT=1700.05n

.meas tran vdout0_16ck1690 FIND v(dout0_16) AT=1700.05n

.meas tran vdout0_17ck1690 FIND v(dout0_17) AT=1700.05n

.meas tran vdout0_18ck1690 FIND v(dout0_18) AT=1700.05n

.meas tran vdout0_19ck1690 FIND v(dout0_19) AT=1700.05n

.meas tran vdout0_20ck1690 FIND v(dout0_20) AT=1700.05n

.meas tran vdout0_21ck1690 FIND v(dout0_21) AT=1700.05n

.meas tran vdout0_22ck1690 FIND v(dout0_22) AT=1700.05n

.meas tran vdout0_23ck1690 FIND v(dout0_23) AT=1700.05n

.meas tran vdout0_24ck1690 FIND v(dout0_24) AT=1700.05n

.meas tran vdout0_25ck1690 FIND v(dout0_25) AT=1700.05n

.meas tran vdout0_26ck1690 FIND v(dout0_26) AT=1700.05n

.meas tran vdout0_27ck1690 FIND v(dout0_27) AT=1700.05n

.meas tran vdout0_28ck1690 FIND v(dout0_28) AT=1700.05n

.meas tran vdout0_29ck1690 FIND v(dout0_29) AT=1700.05n

.meas tran vdout0_30ck1690 FIND v(dout0_30) AT=1700.05n

.meas tran vdout0_31ck1690 FIND v(dout0_31) AT=1700.05n

.meas tran vdout1_0ck1730 FIND v(dout1_0) AT=1740.05n

.meas tran vdout1_1ck1730 FIND v(dout1_1) AT=1740.05n

.meas tran vdout1_2ck1730 FIND v(dout1_2) AT=1740.05n

.meas tran vdout1_3ck1730 FIND v(dout1_3) AT=1740.05n

.meas tran vdout1_4ck1730 FIND v(dout1_4) AT=1740.05n

.meas tran vdout1_5ck1730 FIND v(dout1_5) AT=1740.05n

.meas tran vdout1_6ck1730 FIND v(dout1_6) AT=1740.05n

.meas tran vdout1_7ck1730 FIND v(dout1_7) AT=1740.05n

.meas tran vdout1_8ck1730 FIND v(dout1_8) AT=1740.05n

.meas tran vdout1_9ck1730 FIND v(dout1_9) AT=1740.05n

.meas tran vdout1_10ck1730 FIND v(dout1_10) AT=1740.05n

.meas tran vdout1_11ck1730 FIND v(dout1_11) AT=1740.05n

.meas tran vdout1_12ck1730 FIND v(dout1_12) AT=1740.05n

.meas tran vdout1_13ck1730 FIND v(dout1_13) AT=1740.05n

.meas tran vdout1_14ck1730 FIND v(dout1_14) AT=1740.05n

.meas tran vdout1_15ck1730 FIND v(dout1_15) AT=1740.05n

.meas tran vdout1_16ck1730 FIND v(dout1_16) AT=1740.05n

.meas tran vdout1_17ck1730 FIND v(dout1_17) AT=1740.05n

.meas tran vdout1_18ck1730 FIND v(dout1_18) AT=1740.05n

.meas tran vdout1_19ck1730 FIND v(dout1_19) AT=1740.05n

.meas tran vdout1_20ck1730 FIND v(dout1_20) AT=1740.05n

.meas tran vdout1_21ck1730 FIND v(dout1_21) AT=1740.05n

.meas tran vdout1_22ck1730 FIND v(dout1_22) AT=1740.05n

.meas tran vdout1_23ck1730 FIND v(dout1_23) AT=1740.05n

.meas tran vdout1_24ck1730 FIND v(dout1_24) AT=1740.05n

.meas tran vdout1_25ck1730 FIND v(dout1_25) AT=1740.05n

.meas tran vdout1_26ck1730 FIND v(dout1_26) AT=1740.05n

.meas tran vdout1_27ck1730 FIND v(dout1_27) AT=1740.05n

.meas tran vdout1_28ck1730 FIND v(dout1_28) AT=1740.05n

.meas tran vdout1_29ck1730 FIND v(dout1_29) AT=1740.05n

.meas tran vdout1_30ck1730 FIND v(dout1_30) AT=1740.05n

.meas tran vdout1_31ck1730 FIND v(dout1_31) AT=1740.05n

.meas tran vdout0_0ck1740 FIND v(dout0_0) AT=1750.05n

.meas tran vdout0_1ck1740 FIND v(dout0_1) AT=1750.05n

.meas tran vdout0_2ck1740 FIND v(dout0_2) AT=1750.05n

.meas tran vdout0_3ck1740 FIND v(dout0_3) AT=1750.05n

.meas tran vdout0_4ck1740 FIND v(dout0_4) AT=1750.05n

.meas tran vdout0_5ck1740 FIND v(dout0_5) AT=1750.05n

.meas tran vdout0_6ck1740 FIND v(dout0_6) AT=1750.05n

.meas tran vdout0_7ck1740 FIND v(dout0_7) AT=1750.05n

.meas tran vdout0_8ck1740 FIND v(dout0_8) AT=1750.05n

.meas tran vdout0_9ck1740 FIND v(dout0_9) AT=1750.05n

.meas tran vdout0_10ck1740 FIND v(dout0_10) AT=1750.05n

.meas tran vdout0_11ck1740 FIND v(dout0_11) AT=1750.05n

.meas tran vdout0_12ck1740 FIND v(dout0_12) AT=1750.05n

.meas tran vdout0_13ck1740 FIND v(dout0_13) AT=1750.05n

.meas tran vdout0_14ck1740 FIND v(dout0_14) AT=1750.05n

.meas tran vdout0_15ck1740 FIND v(dout0_15) AT=1750.05n

.meas tran vdout0_16ck1740 FIND v(dout0_16) AT=1750.05n

.meas tran vdout0_17ck1740 FIND v(dout0_17) AT=1750.05n

.meas tran vdout0_18ck1740 FIND v(dout0_18) AT=1750.05n

.meas tran vdout0_19ck1740 FIND v(dout0_19) AT=1750.05n

.meas tran vdout0_20ck1740 FIND v(dout0_20) AT=1750.05n

.meas tran vdout0_21ck1740 FIND v(dout0_21) AT=1750.05n

.meas tran vdout0_22ck1740 FIND v(dout0_22) AT=1750.05n

.meas tran vdout0_23ck1740 FIND v(dout0_23) AT=1750.05n

.meas tran vdout0_24ck1740 FIND v(dout0_24) AT=1750.05n

.meas tran vdout0_25ck1740 FIND v(dout0_25) AT=1750.05n

.meas tran vdout0_26ck1740 FIND v(dout0_26) AT=1750.05n

.meas tran vdout0_27ck1740 FIND v(dout0_27) AT=1750.05n

.meas tran vdout0_28ck1740 FIND v(dout0_28) AT=1750.05n

.meas tran vdout0_29ck1740 FIND v(dout0_29) AT=1750.05n

.meas tran vdout0_30ck1740 FIND v(dout0_30) AT=1750.05n

.meas tran vdout0_31ck1740 FIND v(dout0_31) AT=1750.05n

.meas tran vdout1_0ck1740 FIND v(dout1_0) AT=1750.05n

.meas tran vdout1_1ck1740 FIND v(dout1_1) AT=1750.05n

.meas tran vdout1_2ck1740 FIND v(dout1_2) AT=1750.05n

.meas tran vdout1_3ck1740 FIND v(dout1_3) AT=1750.05n

.meas tran vdout1_4ck1740 FIND v(dout1_4) AT=1750.05n

.meas tran vdout1_5ck1740 FIND v(dout1_5) AT=1750.05n

.meas tran vdout1_6ck1740 FIND v(dout1_6) AT=1750.05n

.meas tran vdout1_7ck1740 FIND v(dout1_7) AT=1750.05n

.meas tran vdout1_8ck1740 FIND v(dout1_8) AT=1750.05n

.meas tran vdout1_9ck1740 FIND v(dout1_9) AT=1750.05n

.meas tran vdout1_10ck1740 FIND v(dout1_10) AT=1750.05n

.meas tran vdout1_11ck1740 FIND v(dout1_11) AT=1750.05n

.meas tran vdout1_12ck1740 FIND v(dout1_12) AT=1750.05n

.meas tran vdout1_13ck1740 FIND v(dout1_13) AT=1750.05n

.meas tran vdout1_14ck1740 FIND v(dout1_14) AT=1750.05n

.meas tran vdout1_15ck1740 FIND v(dout1_15) AT=1750.05n

.meas tran vdout1_16ck1740 FIND v(dout1_16) AT=1750.05n

.meas tran vdout1_17ck1740 FIND v(dout1_17) AT=1750.05n

.meas tran vdout1_18ck1740 FIND v(dout1_18) AT=1750.05n

.meas tran vdout1_19ck1740 FIND v(dout1_19) AT=1750.05n

.meas tran vdout1_20ck1740 FIND v(dout1_20) AT=1750.05n

.meas tran vdout1_21ck1740 FIND v(dout1_21) AT=1750.05n

.meas tran vdout1_22ck1740 FIND v(dout1_22) AT=1750.05n

.meas tran vdout1_23ck1740 FIND v(dout1_23) AT=1750.05n

.meas tran vdout1_24ck1740 FIND v(dout1_24) AT=1750.05n

.meas tran vdout1_25ck1740 FIND v(dout1_25) AT=1750.05n

.meas tran vdout1_26ck1740 FIND v(dout1_26) AT=1750.05n

.meas tran vdout1_27ck1740 FIND v(dout1_27) AT=1750.05n

.meas tran vdout1_28ck1740 FIND v(dout1_28) AT=1750.05n

.meas tran vdout1_29ck1740 FIND v(dout1_29) AT=1750.05n

.meas tran vdout1_30ck1740 FIND v(dout1_30) AT=1750.05n

.meas tran vdout1_31ck1740 FIND v(dout1_31) AT=1750.05n

.meas tran vdout0_0ck1750 FIND v(dout0_0) AT=1760.05n

.meas tran vdout0_1ck1750 FIND v(dout0_1) AT=1760.05n

.meas tran vdout0_2ck1750 FIND v(dout0_2) AT=1760.05n

.meas tran vdout0_3ck1750 FIND v(dout0_3) AT=1760.05n

.meas tran vdout0_4ck1750 FIND v(dout0_4) AT=1760.05n

.meas tran vdout0_5ck1750 FIND v(dout0_5) AT=1760.05n

.meas tran vdout0_6ck1750 FIND v(dout0_6) AT=1760.05n

.meas tran vdout0_7ck1750 FIND v(dout0_7) AT=1760.05n

.meas tran vdout0_8ck1750 FIND v(dout0_8) AT=1760.05n

.meas tran vdout0_9ck1750 FIND v(dout0_9) AT=1760.05n

.meas tran vdout0_10ck1750 FIND v(dout0_10) AT=1760.05n

.meas tran vdout0_11ck1750 FIND v(dout0_11) AT=1760.05n

.meas tran vdout0_12ck1750 FIND v(dout0_12) AT=1760.05n

.meas tran vdout0_13ck1750 FIND v(dout0_13) AT=1760.05n

.meas tran vdout0_14ck1750 FIND v(dout0_14) AT=1760.05n

.meas tran vdout0_15ck1750 FIND v(dout0_15) AT=1760.05n

.meas tran vdout0_16ck1750 FIND v(dout0_16) AT=1760.05n

.meas tran vdout0_17ck1750 FIND v(dout0_17) AT=1760.05n

.meas tran vdout0_18ck1750 FIND v(dout0_18) AT=1760.05n

.meas tran vdout0_19ck1750 FIND v(dout0_19) AT=1760.05n

.meas tran vdout0_20ck1750 FIND v(dout0_20) AT=1760.05n

.meas tran vdout0_21ck1750 FIND v(dout0_21) AT=1760.05n

.meas tran vdout0_22ck1750 FIND v(dout0_22) AT=1760.05n

.meas tran vdout0_23ck1750 FIND v(dout0_23) AT=1760.05n

.meas tran vdout0_24ck1750 FIND v(dout0_24) AT=1760.05n

.meas tran vdout0_25ck1750 FIND v(dout0_25) AT=1760.05n

.meas tran vdout0_26ck1750 FIND v(dout0_26) AT=1760.05n

.meas tran vdout0_27ck1750 FIND v(dout0_27) AT=1760.05n

.meas tran vdout0_28ck1750 FIND v(dout0_28) AT=1760.05n

.meas tran vdout0_29ck1750 FIND v(dout0_29) AT=1760.05n

.meas tran vdout0_30ck1750 FIND v(dout0_30) AT=1760.05n

.meas tran vdout0_31ck1750 FIND v(dout0_31) AT=1760.05n

.meas tran vdout1_0ck1780 FIND v(dout1_0) AT=1790.05n

.meas tran vdout1_1ck1780 FIND v(dout1_1) AT=1790.05n

.meas tran vdout1_2ck1780 FIND v(dout1_2) AT=1790.05n

.meas tran vdout1_3ck1780 FIND v(dout1_3) AT=1790.05n

.meas tran vdout1_4ck1780 FIND v(dout1_4) AT=1790.05n

.meas tran vdout1_5ck1780 FIND v(dout1_5) AT=1790.05n

.meas tran vdout1_6ck1780 FIND v(dout1_6) AT=1790.05n

.meas tran vdout1_7ck1780 FIND v(dout1_7) AT=1790.05n

.meas tran vdout1_8ck1780 FIND v(dout1_8) AT=1790.05n

.meas tran vdout1_9ck1780 FIND v(dout1_9) AT=1790.05n

.meas tran vdout1_10ck1780 FIND v(dout1_10) AT=1790.05n

.meas tran vdout1_11ck1780 FIND v(dout1_11) AT=1790.05n

.meas tran vdout1_12ck1780 FIND v(dout1_12) AT=1790.05n

.meas tran vdout1_13ck1780 FIND v(dout1_13) AT=1790.05n

.meas tran vdout1_14ck1780 FIND v(dout1_14) AT=1790.05n

.meas tran vdout1_15ck1780 FIND v(dout1_15) AT=1790.05n

.meas tran vdout1_16ck1780 FIND v(dout1_16) AT=1790.05n

.meas tran vdout1_17ck1780 FIND v(dout1_17) AT=1790.05n

.meas tran vdout1_18ck1780 FIND v(dout1_18) AT=1790.05n

.meas tran vdout1_19ck1780 FIND v(dout1_19) AT=1790.05n

.meas tran vdout1_20ck1780 FIND v(dout1_20) AT=1790.05n

.meas tran vdout1_21ck1780 FIND v(dout1_21) AT=1790.05n

.meas tran vdout1_22ck1780 FIND v(dout1_22) AT=1790.05n

.meas tran vdout1_23ck1780 FIND v(dout1_23) AT=1790.05n

.meas tran vdout1_24ck1780 FIND v(dout1_24) AT=1790.05n

.meas tran vdout1_25ck1780 FIND v(dout1_25) AT=1790.05n

.meas tran vdout1_26ck1780 FIND v(dout1_26) AT=1790.05n

.meas tran vdout1_27ck1780 FIND v(dout1_27) AT=1790.05n

.meas tran vdout1_28ck1780 FIND v(dout1_28) AT=1790.05n

.meas tran vdout1_29ck1780 FIND v(dout1_29) AT=1790.05n

.meas tran vdout1_30ck1780 FIND v(dout1_30) AT=1790.05n

.meas tran vdout1_31ck1780 FIND v(dout1_31) AT=1790.05n

.meas tran vdout0_0ck1790 FIND v(dout0_0) AT=1800.05n

.meas tran vdout0_1ck1790 FIND v(dout0_1) AT=1800.05n

.meas tran vdout0_2ck1790 FIND v(dout0_2) AT=1800.05n

.meas tran vdout0_3ck1790 FIND v(dout0_3) AT=1800.05n

.meas tran vdout0_4ck1790 FIND v(dout0_4) AT=1800.05n

.meas tran vdout0_5ck1790 FIND v(dout0_5) AT=1800.05n

.meas tran vdout0_6ck1790 FIND v(dout0_6) AT=1800.05n

.meas tran vdout0_7ck1790 FIND v(dout0_7) AT=1800.05n

.meas tran vdout0_8ck1790 FIND v(dout0_8) AT=1800.05n

.meas tran vdout0_9ck1790 FIND v(dout0_9) AT=1800.05n

.meas tran vdout0_10ck1790 FIND v(dout0_10) AT=1800.05n

.meas tran vdout0_11ck1790 FIND v(dout0_11) AT=1800.05n

.meas tran vdout0_12ck1790 FIND v(dout0_12) AT=1800.05n

.meas tran vdout0_13ck1790 FIND v(dout0_13) AT=1800.05n

.meas tran vdout0_14ck1790 FIND v(dout0_14) AT=1800.05n

.meas tran vdout0_15ck1790 FIND v(dout0_15) AT=1800.05n

.meas tran vdout0_16ck1790 FIND v(dout0_16) AT=1800.05n

.meas tran vdout0_17ck1790 FIND v(dout0_17) AT=1800.05n

.meas tran vdout0_18ck1790 FIND v(dout0_18) AT=1800.05n

.meas tran vdout0_19ck1790 FIND v(dout0_19) AT=1800.05n

.meas tran vdout0_20ck1790 FIND v(dout0_20) AT=1800.05n

.meas tran vdout0_21ck1790 FIND v(dout0_21) AT=1800.05n

.meas tran vdout0_22ck1790 FIND v(dout0_22) AT=1800.05n

.meas tran vdout0_23ck1790 FIND v(dout0_23) AT=1800.05n

.meas tran vdout0_24ck1790 FIND v(dout0_24) AT=1800.05n

.meas tran vdout0_25ck1790 FIND v(dout0_25) AT=1800.05n

.meas tran vdout0_26ck1790 FIND v(dout0_26) AT=1800.05n

.meas tran vdout0_27ck1790 FIND v(dout0_27) AT=1800.05n

.meas tran vdout0_28ck1790 FIND v(dout0_28) AT=1800.05n

.meas tran vdout0_29ck1790 FIND v(dout0_29) AT=1800.05n

.meas tran vdout0_30ck1790 FIND v(dout0_30) AT=1800.05n

.meas tran vdout0_31ck1790 FIND v(dout0_31) AT=1800.05n

.meas tran vdout1_0ck1790 FIND v(dout1_0) AT=1800.05n

.meas tran vdout1_1ck1790 FIND v(dout1_1) AT=1800.05n

.meas tran vdout1_2ck1790 FIND v(dout1_2) AT=1800.05n

.meas tran vdout1_3ck1790 FIND v(dout1_3) AT=1800.05n

.meas tran vdout1_4ck1790 FIND v(dout1_4) AT=1800.05n

.meas tran vdout1_5ck1790 FIND v(dout1_5) AT=1800.05n

.meas tran vdout1_6ck1790 FIND v(dout1_6) AT=1800.05n

.meas tran vdout1_7ck1790 FIND v(dout1_7) AT=1800.05n

.meas tran vdout1_8ck1790 FIND v(dout1_8) AT=1800.05n

.meas tran vdout1_9ck1790 FIND v(dout1_9) AT=1800.05n

.meas tran vdout1_10ck1790 FIND v(dout1_10) AT=1800.05n

.meas tran vdout1_11ck1790 FIND v(dout1_11) AT=1800.05n

.meas tran vdout1_12ck1790 FIND v(dout1_12) AT=1800.05n

.meas tran vdout1_13ck1790 FIND v(dout1_13) AT=1800.05n

.meas tran vdout1_14ck1790 FIND v(dout1_14) AT=1800.05n

.meas tran vdout1_15ck1790 FIND v(dout1_15) AT=1800.05n

.meas tran vdout1_16ck1790 FIND v(dout1_16) AT=1800.05n

.meas tran vdout1_17ck1790 FIND v(dout1_17) AT=1800.05n

.meas tran vdout1_18ck1790 FIND v(dout1_18) AT=1800.05n

.meas tran vdout1_19ck1790 FIND v(dout1_19) AT=1800.05n

.meas tran vdout1_20ck1790 FIND v(dout1_20) AT=1800.05n

.meas tran vdout1_21ck1790 FIND v(dout1_21) AT=1800.05n

.meas tran vdout1_22ck1790 FIND v(dout1_22) AT=1800.05n

.meas tran vdout1_23ck1790 FIND v(dout1_23) AT=1800.05n

.meas tran vdout1_24ck1790 FIND v(dout1_24) AT=1800.05n

.meas tran vdout1_25ck1790 FIND v(dout1_25) AT=1800.05n

.meas tran vdout1_26ck1790 FIND v(dout1_26) AT=1800.05n

.meas tran vdout1_27ck1790 FIND v(dout1_27) AT=1800.05n

.meas tran vdout1_28ck1790 FIND v(dout1_28) AT=1800.05n

.meas tran vdout1_29ck1790 FIND v(dout1_29) AT=1800.05n

.meas tran vdout1_30ck1790 FIND v(dout1_30) AT=1800.05n

.meas tran vdout1_31ck1790 FIND v(dout1_31) AT=1800.05n

.meas tran vdout0_0ck1800 FIND v(dout0_0) AT=1810.05n

.meas tran vdout0_1ck1800 FIND v(dout0_1) AT=1810.05n

.meas tran vdout0_2ck1800 FIND v(dout0_2) AT=1810.05n

.meas tran vdout0_3ck1800 FIND v(dout0_3) AT=1810.05n

.meas tran vdout0_4ck1800 FIND v(dout0_4) AT=1810.05n

.meas tran vdout0_5ck1800 FIND v(dout0_5) AT=1810.05n

.meas tran vdout0_6ck1800 FIND v(dout0_6) AT=1810.05n

.meas tran vdout0_7ck1800 FIND v(dout0_7) AT=1810.05n

.meas tran vdout0_8ck1800 FIND v(dout0_8) AT=1810.05n

.meas tran vdout0_9ck1800 FIND v(dout0_9) AT=1810.05n

.meas tran vdout0_10ck1800 FIND v(dout0_10) AT=1810.05n

.meas tran vdout0_11ck1800 FIND v(dout0_11) AT=1810.05n

.meas tran vdout0_12ck1800 FIND v(dout0_12) AT=1810.05n

.meas tran vdout0_13ck1800 FIND v(dout0_13) AT=1810.05n

.meas tran vdout0_14ck1800 FIND v(dout0_14) AT=1810.05n

.meas tran vdout0_15ck1800 FIND v(dout0_15) AT=1810.05n

.meas tran vdout0_16ck1800 FIND v(dout0_16) AT=1810.05n

.meas tran vdout0_17ck1800 FIND v(dout0_17) AT=1810.05n

.meas tran vdout0_18ck1800 FIND v(dout0_18) AT=1810.05n

.meas tran vdout0_19ck1800 FIND v(dout0_19) AT=1810.05n

.meas tran vdout0_20ck1800 FIND v(dout0_20) AT=1810.05n

.meas tran vdout0_21ck1800 FIND v(dout0_21) AT=1810.05n

.meas tran vdout0_22ck1800 FIND v(dout0_22) AT=1810.05n

.meas tran vdout0_23ck1800 FIND v(dout0_23) AT=1810.05n

.meas tran vdout0_24ck1800 FIND v(dout0_24) AT=1810.05n

.meas tran vdout0_25ck1800 FIND v(dout0_25) AT=1810.05n

.meas tran vdout0_26ck1800 FIND v(dout0_26) AT=1810.05n

.meas tran vdout0_27ck1800 FIND v(dout0_27) AT=1810.05n

.meas tran vdout0_28ck1800 FIND v(dout0_28) AT=1810.05n

.meas tran vdout0_29ck1800 FIND v(dout0_29) AT=1810.05n

.meas tran vdout0_30ck1800 FIND v(dout0_30) AT=1810.05n

.meas tran vdout0_31ck1800 FIND v(dout0_31) AT=1810.05n

.meas tran vdout0_0ck1810 FIND v(dout0_0) AT=1820.05n

.meas tran vdout0_1ck1810 FIND v(dout0_1) AT=1820.05n

.meas tran vdout0_2ck1810 FIND v(dout0_2) AT=1820.05n

.meas tran vdout0_3ck1810 FIND v(dout0_3) AT=1820.05n

.meas tran vdout0_4ck1810 FIND v(dout0_4) AT=1820.05n

.meas tran vdout0_5ck1810 FIND v(dout0_5) AT=1820.05n

.meas tran vdout0_6ck1810 FIND v(dout0_6) AT=1820.05n

.meas tran vdout0_7ck1810 FIND v(dout0_7) AT=1820.05n

.meas tran vdout0_8ck1810 FIND v(dout0_8) AT=1820.05n

.meas tran vdout0_9ck1810 FIND v(dout0_9) AT=1820.05n

.meas tran vdout0_10ck1810 FIND v(dout0_10) AT=1820.05n

.meas tran vdout0_11ck1810 FIND v(dout0_11) AT=1820.05n

.meas tran vdout0_12ck1810 FIND v(dout0_12) AT=1820.05n

.meas tran vdout0_13ck1810 FIND v(dout0_13) AT=1820.05n

.meas tran vdout0_14ck1810 FIND v(dout0_14) AT=1820.05n

.meas tran vdout0_15ck1810 FIND v(dout0_15) AT=1820.05n

.meas tran vdout0_16ck1810 FIND v(dout0_16) AT=1820.05n

.meas tran vdout0_17ck1810 FIND v(dout0_17) AT=1820.05n

.meas tran vdout0_18ck1810 FIND v(dout0_18) AT=1820.05n

.meas tran vdout0_19ck1810 FIND v(dout0_19) AT=1820.05n

.meas tran vdout0_20ck1810 FIND v(dout0_20) AT=1820.05n

.meas tran vdout0_21ck1810 FIND v(dout0_21) AT=1820.05n

.meas tran vdout0_22ck1810 FIND v(dout0_22) AT=1820.05n

.meas tran vdout0_23ck1810 FIND v(dout0_23) AT=1820.05n

.meas tran vdout0_24ck1810 FIND v(dout0_24) AT=1820.05n

.meas tran vdout0_25ck1810 FIND v(dout0_25) AT=1820.05n

.meas tran vdout0_26ck1810 FIND v(dout0_26) AT=1820.05n

.meas tran vdout0_27ck1810 FIND v(dout0_27) AT=1820.05n

.meas tran vdout0_28ck1810 FIND v(dout0_28) AT=1820.05n

.meas tran vdout0_29ck1810 FIND v(dout0_29) AT=1820.05n

.meas tran vdout0_30ck1810 FIND v(dout0_30) AT=1820.05n

.meas tran vdout0_31ck1810 FIND v(dout0_31) AT=1820.05n

.meas tran vdout1_0ck1810 FIND v(dout1_0) AT=1820.05n

.meas tran vdout1_1ck1810 FIND v(dout1_1) AT=1820.05n

.meas tran vdout1_2ck1810 FIND v(dout1_2) AT=1820.05n

.meas tran vdout1_3ck1810 FIND v(dout1_3) AT=1820.05n

.meas tran vdout1_4ck1810 FIND v(dout1_4) AT=1820.05n

.meas tran vdout1_5ck1810 FIND v(dout1_5) AT=1820.05n

.meas tran vdout1_6ck1810 FIND v(dout1_6) AT=1820.05n

.meas tran vdout1_7ck1810 FIND v(dout1_7) AT=1820.05n

.meas tran vdout1_8ck1810 FIND v(dout1_8) AT=1820.05n

.meas tran vdout1_9ck1810 FIND v(dout1_9) AT=1820.05n

.meas tran vdout1_10ck1810 FIND v(dout1_10) AT=1820.05n

.meas tran vdout1_11ck1810 FIND v(dout1_11) AT=1820.05n

.meas tran vdout1_12ck1810 FIND v(dout1_12) AT=1820.05n

.meas tran vdout1_13ck1810 FIND v(dout1_13) AT=1820.05n

.meas tran vdout1_14ck1810 FIND v(dout1_14) AT=1820.05n

.meas tran vdout1_15ck1810 FIND v(dout1_15) AT=1820.05n

.meas tran vdout1_16ck1810 FIND v(dout1_16) AT=1820.05n

.meas tran vdout1_17ck1810 FIND v(dout1_17) AT=1820.05n

.meas tran vdout1_18ck1810 FIND v(dout1_18) AT=1820.05n

.meas tran vdout1_19ck1810 FIND v(dout1_19) AT=1820.05n

.meas tran vdout1_20ck1810 FIND v(dout1_20) AT=1820.05n

.meas tran vdout1_21ck1810 FIND v(dout1_21) AT=1820.05n

.meas tran vdout1_22ck1810 FIND v(dout1_22) AT=1820.05n

.meas tran vdout1_23ck1810 FIND v(dout1_23) AT=1820.05n

.meas tran vdout1_24ck1810 FIND v(dout1_24) AT=1820.05n

.meas tran vdout1_25ck1810 FIND v(dout1_25) AT=1820.05n

.meas tran vdout1_26ck1810 FIND v(dout1_26) AT=1820.05n

.meas tran vdout1_27ck1810 FIND v(dout1_27) AT=1820.05n

.meas tran vdout1_28ck1810 FIND v(dout1_28) AT=1820.05n

.meas tran vdout1_29ck1810 FIND v(dout1_29) AT=1820.05n

.meas tran vdout1_30ck1810 FIND v(dout1_30) AT=1820.05n

.meas tran vdout1_31ck1810 FIND v(dout1_31) AT=1820.05n

.meas tran vdout0_0ck1830 FIND v(dout0_0) AT=1840.05n

.meas tran vdout0_1ck1830 FIND v(dout0_1) AT=1840.05n

.meas tran vdout0_2ck1830 FIND v(dout0_2) AT=1840.05n

.meas tran vdout0_3ck1830 FIND v(dout0_3) AT=1840.05n

.meas tran vdout0_4ck1830 FIND v(dout0_4) AT=1840.05n

.meas tran vdout0_5ck1830 FIND v(dout0_5) AT=1840.05n

.meas tran vdout0_6ck1830 FIND v(dout0_6) AT=1840.05n

.meas tran vdout0_7ck1830 FIND v(dout0_7) AT=1840.05n

.meas tran vdout0_8ck1830 FIND v(dout0_8) AT=1840.05n

.meas tran vdout0_9ck1830 FIND v(dout0_9) AT=1840.05n

.meas tran vdout0_10ck1830 FIND v(dout0_10) AT=1840.05n

.meas tran vdout0_11ck1830 FIND v(dout0_11) AT=1840.05n

.meas tran vdout0_12ck1830 FIND v(dout0_12) AT=1840.05n

.meas tran vdout0_13ck1830 FIND v(dout0_13) AT=1840.05n

.meas tran vdout0_14ck1830 FIND v(dout0_14) AT=1840.05n

.meas tran vdout0_15ck1830 FIND v(dout0_15) AT=1840.05n

.meas tran vdout0_16ck1830 FIND v(dout0_16) AT=1840.05n

.meas tran vdout0_17ck1830 FIND v(dout0_17) AT=1840.05n

.meas tran vdout0_18ck1830 FIND v(dout0_18) AT=1840.05n

.meas tran vdout0_19ck1830 FIND v(dout0_19) AT=1840.05n

.meas tran vdout0_20ck1830 FIND v(dout0_20) AT=1840.05n

.meas tran vdout0_21ck1830 FIND v(dout0_21) AT=1840.05n

.meas tran vdout0_22ck1830 FIND v(dout0_22) AT=1840.05n

.meas tran vdout0_23ck1830 FIND v(dout0_23) AT=1840.05n

.meas tran vdout0_24ck1830 FIND v(dout0_24) AT=1840.05n

.meas tran vdout0_25ck1830 FIND v(dout0_25) AT=1840.05n

.meas tran vdout0_26ck1830 FIND v(dout0_26) AT=1840.05n

.meas tran vdout0_27ck1830 FIND v(dout0_27) AT=1840.05n

.meas tran vdout0_28ck1830 FIND v(dout0_28) AT=1840.05n

.meas tran vdout0_29ck1830 FIND v(dout0_29) AT=1840.05n

.meas tran vdout0_30ck1830 FIND v(dout0_30) AT=1840.05n

.meas tran vdout0_31ck1830 FIND v(dout0_31) AT=1840.05n

.meas tran vdout1_0ck1830 FIND v(dout1_0) AT=1840.05n

.meas tran vdout1_1ck1830 FIND v(dout1_1) AT=1840.05n

.meas tran vdout1_2ck1830 FIND v(dout1_2) AT=1840.05n

.meas tran vdout1_3ck1830 FIND v(dout1_3) AT=1840.05n

.meas tran vdout1_4ck1830 FIND v(dout1_4) AT=1840.05n

.meas tran vdout1_5ck1830 FIND v(dout1_5) AT=1840.05n

.meas tran vdout1_6ck1830 FIND v(dout1_6) AT=1840.05n

.meas tran vdout1_7ck1830 FIND v(dout1_7) AT=1840.05n

.meas tran vdout1_8ck1830 FIND v(dout1_8) AT=1840.05n

.meas tran vdout1_9ck1830 FIND v(dout1_9) AT=1840.05n

.meas tran vdout1_10ck1830 FIND v(dout1_10) AT=1840.05n

.meas tran vdout1_11ck1830 FIND v(dout1_11) AT=1840.05n

.meas tran vdout1_12ck1830 FIND v(dout1_12) AT=1840.05n

.meas tran vdout1_13ck1830 FIND v(dout1_13) AT=1840.05n

.meas tran vdout1_14ck1830 FIND v(dout1_14) AT=1840.05n

.meas tran vdout1_15ck1830 FIND v(dout1_15) AT=1840.05n

.meas tran vdout1_16ck1830 FIND v(dout1_16) AT=1840.05n

.meas tran vdout1_17ck1830 FIND v(dout1_17) AT=1840.05n

.meas tran vdout1_18ck1830 FIND v(dout1_18) AT=1840.05n

.meas tran vdout1_19ck1830 FIND v(dout1_19) AT=1840.05n

.meas tran vdout1_20ck1830 FIND v(dout1_20) AT=1840.05n

.meas tran vdout1_21ck1830 FIND v(dout1_21) AT=1840.05n

.meas tran vdout1_22ck1830 FIND v(dout1_22) AT=1840.05n

.meas tran vdout1_23ck1830 FIND v(dout1_23) AT=1840.05n

.meas tran vdout1_24ck1830 FIND v(dout1_24) AT=1840.05n

.meas tran vdout1_25ck1830 FIND v(dout1_25) AT=1840.05n

.meas tran vdout1_26ck1830 FIND v(dout1_26) AT=1840.05n

.meas tran vdout1_27ck1830 FIND v(dout1_27) AT=1840.05n

.meas tran vdout1_28ck1830 FIND v(dout1_28) AT=1840.05n

.meas tran vdout1_29ck1830 FIND v(dout1_29) AT=1840.05n

.meas tran vdout1_30ck1830 FIND v(dout1_30) AT=1840.05n

.meas tran vdout1_31ck1830 FIND v(dout1_31) AT=1840.05n

.meas tran vdout0_0ck1840 FIND v(dout0_0) AT=1850.05n

.meas tran vdout0_1ck1840 FIND v(dout0_1) AT=1850.05n

.meas tran vdout0_2ck1840 FIND v(dout0_2) AT=1850.05n

.meas tran vdout0_3ck1840 FIND v(dout0_3) AT=1850.05n

.meas tran vdout0_4ck1840 FIND v(dout0_4) AT=1850.05n

.meas tran vdout0_5ck1840 FIND v(dout0_5) AT=1850.05n

.meas tran vdout0_6ck1840 FIND v(dout0_6) AT=1850.05n

.meas tran vdout0_7ck1840 FIND v(dout0_7) AT=1850.05n

.meas tran vdout0_8ck1840 FIND v(dout0_8) AT=1850.05n

.meas tran vdout0_9ck1840 FIND v(dout0_9) AT=1850.05n

.meas tran vdout0_10ck1840 FIND v(dout0_10) AT=1850.05n

.meas tran vdout0_11ck1840 FIND v(dout0_11) AT=1850.05n

.meas tran vdout0_12ck1840 FIND v(dout0_12) AT=1850.05n

.meas tran vdout0_13ck1840 FIND v(dout0_13) AT=1850.05n

.meas tran vdout0_14ck1840 FIND v(dout0_14) AT=1850.05n

.meas tran vdout0_15ck1840 FIND v(dout0_15) AT=1850.05n

.meas tran vdout0_16ck1840 FIND v(dout0_16) AT=1850.05n

.meas tran vdout0_17ck1840 FIND v(dout0_17) AT=1850.05n

.meas tran vdout0_18ck1840 FIND v(dout0_18) AT=1850.05n

.meas tran vdout0_19ck1840 FIND v(dout0_19) AT=1850.05n

.meas tran vdout0_20ck1840 FIND v(dout0_20) AT=1850.05n

.meas tran vdout0_21ck1840 FIND v(dout0_21) AT=1850.05n

.meas tran vdout0_22ck1840 FIND v(dout0_22) AT=1850.05n

.meas tran vdout0_23ck1840 FIND v(dout0_23) AT=1850.05n

.meas tran vdout0_24ck1840 FIND v(dout0_24) AT=1850.05n

.meas tran vdout0_25ck1840 FIND v(dout0_25) AT=1850.05n

.meas tran vdout0_26ck1840 FIND v(dout0_26) AT=1850.05n

.meas tran vdout0_27ck1840 FIND v(dout0_27) AT=1850.05n

.meas tran vdout0_28ck1840 FIND v(dout0_28) AT=1850.05n

.meas tran vdout0_29ck1840 FIND v(dout0_29) AT=1850.05n

.meas tran vdout0_30ck1840 FIND v(dout0_30) AT=1850.05n

.meas tran vdout0_31ck1840 FIND v(dout0_31) AT=1850.05n

.meas tran vdout1_0ck1840 FIND v(dout1_0) AT=1850.05n

.meas tran vdout1_1ck1840 FIND v(dout1_1) AT=1850.05n

.meas tran vdout1_2ck1840 FIND v(dout1_2) AT=1850.05n

.meas tran vdout1_3ck1840 FIND v(dout1_3) AT=1850.05n

.meas tran vdout1_4ck1840 FIND v(dout1_4) AT=1850.05n

.meas tran vdout1_5ck1840 FIND v(dout1_5) AT=1850.05n

.meas tran vdout1_6ck1840 FIND v(dout1_6) AT=1850.05n

.meas tran vdout1_7ck1840 FIND v(dout1_7) AT=1850.05n

.meas tran vdout1_8ck1840 FIND v(dout1_8) AT=1850.05n

.meas tran vdout1_9ck1840 FIND v(dout1_9) AT=1850.05n

.meas tran vdout1_10ck1840 FIND v(dout1_10) AT=1850.05n

.meas tran vdout1_11ck1840 FIND v(dout1_11) AT=1850.05n

.meas tran vdout1_12ck1840 FIND v(dout1_12) AT=1850.05n

.meas tran vdout1_13ck1840 FIND v(dout1_13) AT=1850.05n

.meas tran vdout1_14ck1840 FIND v(dout1_14) AT=1850.05n

.meas tran vdout1_15ck1840 FIND v(dout1_15) AT=1850.05n

.meas tran vdout1_16ck1840 FIND v(dout1_16) AT=1850.05n

.meas tran vdout1_17ck1840 FIND v(dout1_17) AT=1850.05n

.meas tran vdout1_18ck1840 FIND v(dout1_18) AT=1850.05n

.meas tran vdout1_19ck1840 FIND v(dout1_19) AT=1850.05n

.meas tran vdout1_20ck1840 FIND v(dout1_20) AT=1850.05n

.meas tran vdout1_21ck1840 FIND v(dout1_21) AT=1850.05n

.meas tran vdout1_22ck1840 FIND v(dout1_22) AT=1850.05n

.meas tran vdout1_23ck1840 FIND v(dout1_23) AT=1850.05n

.meas tran vdout1_24ck1840 FIND v(dout1_24) AT=1850.05n

.meas tran vdout1_25ck1840 FIND v(dout1_25) AT=1850.05n

.meas tran vdout1_26ck1840 FIND v(dout1_26) AT=1850.05n

.meas tran vdout1_27ck1840 FIND v(dout1_27) AT=1850.05n

.meas tran vdout1_28ck1840 FIND v(dout1_28) AT=1850.05n

.meas tran vdout1_29ck1840 FIND v(dout1_29) AT=1850.05n

.meas tran vdout1_30ck1840 FIND v(dout1_30) AT=1850.05n

.meas tran vdout1_31ck1840 FIND v(dout1_31) AT=1850.05n

.meas tran vdout1_0ck1850 FIND v(dout1_0) AT=1860.05n

.meas tran vdout1_1ck1850 FIND v(dout1_1) AT=1860.05n

.meas tran vdout1_2ck1850 FIND v(dout1_2) AT=1860.05n

.meas tran vdout1_3ck1850 FIND v(dout1_3) AT=1860.05n

.meas tran vdout1_4ck1850 FIND v(dout1_4) AT=1860.05n

.meas tran vdout1_5ck1850 FIND v(dout1_5) AT=1860.05n

.meas tran vdout1_6ck1850 FIND v(dout1_6) AT=1860.05n

.meas tran vdout1_7ck1850 FIND v(dout1_7) AT=1860.05n

.meas tran vdout1_8ck1850 FIND v(dout1_8) AT=1860.05n

.meas tran vdout1_9ck1850 FIND v(dout1_9) AT=1860.05n

.meas tran vdout1_10ck1850 FIND v(dout1_10) AT=1860.05n

.meas tran vdout1_11ck1850 FIND v(dout1_11) AT=1860.05n

.meas tran vdout1_12ck1850 FIND v(dout1_12) AT=1860.05n

.meas tran vdout1_13ck1850 FIND v(dout1_13) AT=1860.05n

.meas tran vdout1_14ck1850 FIND v(dout1_14) AT=1860.05n

.meas tran vdout1_15ck1850 FIND v(dout1_15) AT=1860.05n

.meas tran vdout1_16ck1850 FIND v(dout1_16) AT=1860.05n

.meas tran vdout1_17ck1850 FIND v(dout1_17) AT=1860.05n

.meas tran vdout1_18ck1850 FIND v(dout1_18) AT=1860.05n

.meas tran vdout1_19ck1850 FIND v(dout1_19) AT=1860.05n

.meas tran vdout1_20ck1850 FIND v(dout1_20) AT=1860.05n

.meas tran vdout1_21ck1850 FIND v(dout1_21) AT=1860.05n

.meas tran vdout1_22ck1850 FIND v(dout1_22) AT=1860.05n

.meas tran vdout1_23ck1850 FIND v(dout1_23) AT=1860.05n

.meas tran vdout1_24ck1850 FIND v(dout1_24) AT=1860.05n

.meas tran vdout1_25ck1850 FIND v(dout1_25) AT=1860.05n

.meas tran vdout1_26ck1850 FIND v(dout1_26) AT=1860.05n

.meas tran vdout1_27ck1850 FIND v(dout1_27) AT=1860.05n

.meas tran vdout1_28ck1850 FIND v(dout1_28) AT=1860.05n

.meas tran vdout1_29ck1850 FIND v(dout1_29) AT=1860.05n

.meas tran vdout1_30ck1850 FIND v(dout1_30) AT=1860.05n

.meas tran vdout1_31ck1850 FIND v(dout1_31) AT=1860.05n

.meas tran vdout1_0ck1870 FIND v(dout1_0) AT=1880.05n

.meas tran vdout1_1ck1870 FIND v(dout1_1) AT=1880.05n

.meas tran vdout1_2ck1870 FIND v(dout1_2) AT=1880.05n

.meas tran vdout1_3ck1870 FIND v(dout1_3) AT=1880.05n

.meas tran vdout1_4ck1870 FIND v(dout1_4) AT=1880.05n

.meas tran vdout1_5ck1870 FIND v(dout1_5) AT=1880.05n

.meas tran vdout1_6ck1870 FIND v(dout1_6) AT=1880.05n

.meas tran vdout1_7ck1870 FIND v(dout1_7) AT=1880.05n

.meas tran vdout1_8ck1870 FIND v(dout1_8) AT=1880.05n

.meas tran vdout1_9ck1870 FIND v(dout1_9) AT=1880.05n

.meas tran vdout1_10ck1870 FIND v(dout1_10) AT=1880.05n

.meas tran vdout1_11ck1870 FIND v(dout1_11) AT=1880.05n

.meas tran vdout1_12ck1870 FIND v(dout1_12) AT=1880.05n

.meas tran vdout1_13ck1870 FIND v(dout1_13) AT=1880.05n

.meas tran vdout1_14ck1870 FIND v(dout1_14) AT=1880.05n

.meas tran vdout1_15ck1870 FIND v(dout1_15) AT=1880.05n

.meas tran vdout1_16ck1870 FIND v(dout1_16) AT=1880.05n

.meas tran vdout1_17ck1870 FIND v(dout1_17) AT=1880.05n

.meas tran vdout1_18ck1870 FIND v(dout1_18) AT=1880.05n

.meas tran vdout1_19ck1870 FIND v(dout1_19) AT=1880.05n

.meas tran vdout1_20ck1870 FIND v(dout1_20) AT=1880.05n

.meas tran vdout1_21ck1870 FIND v(dout1_21) AT=1880.05n

.meas tran vdout1_22ck1870 FIND v(dout1_22) AT=1880.05n

.meas tran vdout1_23ck1870 FIND v(dout1_23) AT=1880.05n

.meas tran vdout1_24ck1870 FIND v(dout1_24) AT=1880.05n

.meas tran vdout1_25ck1870 FIND v(dout1_25) AT=1880.05n

.meas tran vdout1_26ck1870 FIND v(dout1_26) AT=1880.05n

.meas tran vdout1_27ck1870 FIND v(dout1_27) AT=1880.05n

.meas tran vdout1_28ck1870 FIND v(dout1_28) AT=1880.05n

.meas tran vdout1_29ck1870 FIND v(dout1_29) AT=1880.05n

.meas tran vdout1_30ck1870 FIND v(dout1_30) AT=1880.05n

.meas tran vdout1_31ck1870 FIND v(dout1_31) AT=1880.05n

.meas tran vdout1_0ck1910 FIND v(dout1_0) AT=1920.05n

.meas tran vdout1_1ck1910 FIND v(dout1_1) AT=1920.05n

.meas tran vdout1_2ck1910 FIND v(dout1_2) AT=1920.05n

.meas tran vdout1_3ck1910 FIND v(dout1_3) AT=1920.05n

.meas tran vdout1_4ck1910 FIND v(dout1_4) AT=1920.05n

.meas tran vdout1_5ck1910 FIND v(dout1_5) AT=1920.05n

.meas tran vdout1_6ck1910 FIND v(dout1_6) AT=1920.05n

.meas tran vdout1_7ck1910 FIND v(dout1_7) AT=1920.05n

.meas tran vdout1_8ck1910 FIND v(dout1_8) AT=1920.05n

.meas tran vdout1_9ck1910 FIND v(dout1_9) AT=1920.05n

.meas tran vdout1_10ck1910 FIND v(dout1_10) AT=1920.05n

.meas tran vdout1_11ck1910 FIND v(dout1_11) AT=1920.05n

.meas tran vdout1_12ck1910 FIND v(dout1_12) AT=1920.05n

.meas tran vdout1_13ck1910 FIND v(dout1_13) AT=1920.05n

.meas tran vdout1_14ck1910 FIND v(dout1_14) AT=1920.05n

.meas tran vdout1_15ck1910 FIND v(dout1_15) AT=1920.05n

.meas tran vdout1_16ck1910 FIND v(dout1_16) AT=1920.05n

.meas tran vdout1_17ck1910 FIND v(dout1_17) AT=1920.05n

.meas tran vdout1_18ck1910 FIND v(dout1_18) AT=1920.05n

.meas tran vdout1_19ck1910 FIND v(dout1_19) AT=1920.05n

.meas tran vdout1_20ck1910 FIND v(dout1_20) AT=1920.05n

.meas tran vdout1_21ck1910 FIND v(dout1_21) AT=1920.05n

.meas tran vdout1_22ck1910 FIND v(dout1_22) AT=1920.05n

.meas tran vdout1_23ck1910 FIND v(dout1_23) AT=1920.05n

.meas tran vdout1_24ck1910 FIND v(dout1_24) AT=1920.05n

.meas tran vdout1_25ck1910 FIND v(dout1_25) AT=1920.05n

.meas tran vdout1_26ck1910 FIND v(dout1_26) AT=1920.05n

.meas tran vdout1_27ck1910 FIND v(dout1_27) AT=1920.05n

.meas tran vdout1_28ck1910 FIND v(dout1_28) AT=1920.05n

.meas tran vdout1_29ck1910 FIND v(dout1_29) AT=1920.05n

.meas tran vdout1_30ck1910 FIND v(dout1_30) AT=1920.05n

.meas tran vdout1_31ck1910 FIND v(dout1_31) AT=1920.05n

.meas tran vdout1_0ck1920 FIND v(dout1_0) AT=1930.05n

.meas tran vdout1_1ck1920 FIND v(dout1_1) AT=1930.05n

.meas tran vdout1_2ck1920 FIND v(dout1_2) AT=1930.05n

.meas tran vdout1_3ck1920 FIND v(dout1_3) AT=1930.05n

.meas tran vdout1_4ck1920 FIND v(dout1_4) AT=1930.05n

.meas tran vdout1_5ck1920 FIND v(dout1_5) AT=1930.05n

.meas tran vdout1_6ck1920 FIND v(dout1_6) AT=1930.05n

.meas tran vdout1_7ck1920 FIND v(dout1_7) AT=1930.05n

.meas tran vdout1_8ck1920 FIND v(dout1_8) AT=1930.05n

.meas tran vdout1_9ck1920 FIND v(dout1_9) AT=1930.05n

.meas tran vdout1_10ck1920 FIND v(dout1_10) AT=1930.05n

.meas tran vdout1_11ck1920 FIND v(dout1_11) AT=1930.05n

.meas tran vdout1_12ck1920 FIND v(dout1_12) AT=1930.05n

.meas tran vdout1_13ck1920 FIND v(dout1_13) AT=1930.05n

.meas tran vdout1_14ck1920 FIND v(dout1_14) AT=1930.05n

.meas tran vdout1_15ck1920 FIND v(dout1_15) AT=1930.05n

.meas tran vdout1_16ck1920 FIND v(dout1_16) AT=1930.05n

.meas tran vdout1_17ck1920 FIND v(dout1_17) AT=1930.05n

.meas tran vdout1_18ck1920 FIND v(dout1_18) AT=1930.05n

.meas tran vdout1_19ck1920 FIND v(dout1_19) AT=1930.05n

.meas tran vdout1_20ck1920 FIND v(dout1_20) AT=1930.05n

.meas tran vdout1_21ck1920 FIND v(dout1_21) AT=1930.05n

.meas tran vdout1_22ck1920 FIND v(dout1_22) AT=1930.05n

.meas tran vdout1_23ck1920 FIND v(dout1_23) AT=1930.05n

.meas tran vdout1_24ck1920 FIND v(dout1_24) AT=1930.05n

.meas tran vdout1_25ck1920 FIND v(dout1_25) AT=1930.05n

.meas tran vdout1_26ck1920 FIND v(dout1_26) AT=1930.05n

.meas tran vdout1_27ck1920 FIND v(dout1_27) AT=1930.05n

.meas tran vdout1_28ck1920 FIND v(dout1_28) AT=1930.05n

.meas tran vdout1_29ck1920 FIND v(dout1_29) AT=1930.05n

.meas tran vdout1_30ck1920 FIND v(dout1_30) AT=1930.05n

.meas tran vdout1_31ck1920 FIND v(dout1_31) AT=1930.05n

.meas tran vdout1_0ck1930 FIND v(dout1_0) AT=1940.05n

.meas tran vdout1_1ck1930 FIND v(dout1_1) AT=1940.05n

.meas tran vdout1_2ck1930 FIND v(dout1_2) AT=1940.05n

.meas tran vdout1_3ck1930 FIND v(dout1_3) AT=1940.05n

.meas tran vdout1_4ck1930 FIND v(dout1_4) AT=1940.05n

.meas tran vdout1_5ck1930 FIND v(dout1_5) AT=1940.05n

.meas tran vdout1_6ck1930 FIND v(dout1_6) AT=1940.05n

.meas tran vdout1_7ck1930 FIND v(dout1_7) AT=1940.05n

.meas tran vdout1_8ck1930 FIND v(dout1_8) AT=1940.05n

.meas tran vdout1_9ck1930 FIND v(dout1_9) AT=1940.05n

.meas tran vdout1_10ck1930 FIND v(dout1_10) AT=1940.05n

.meas tran vdout1_11ck1930 FIND v(dout1_11) AT=1940.05n

.meas tran vdout1_12ck1930 FIND v(dout1_12) AT=1940.05n

.meas tran vdout1_13ck1930 FIND v(dout1_13) AT=1940.05n

.meas tran vdout1_14ck1930 FIND v(dout1_14) AT=1940.05n

.meas tran vdout1_15ck1930 FIND v(dout1_15) AT=1940.05n

.meas tran vdout1_16ck1930 FIND v(dout1_16) AT=1940.05n

.meas tran vdout1_17ck1930 FIND v(dout1_17) AT=1940.05n

.meas tran vdout1_18ck1930 FIND v(dout1_18) AT=1940.05n

.meas tran vdout1_19ck1930 FIND v(dout1_19) AT=1940.05n

.meas tran vdout1_20ck1930 FIND v(dout1_20) AT=1940.05n

.meas tran vdout1_21ck1930 FIND v(dout1_21) AT=1940.05n

.meas tran vdout1_22ck1930 FIND v(dout1_22) AT=1940.05n

.meas tran vdout1_23ck1930 FIND v(dout1_23) AT=1940.05n

.meas tran vdout1_24ck1930 FIND v(dout1_24) AT=1940.05n

.meas tran vdout1_25ck1930 FIND v(dout1_25) AT=1940.05n

.meas tran vdout1_26ck1930 FIND v(dout1_26) AT=1940.05n

.meas tran vdout1_27ck1930 FIND v(dout1_27) AT=1940.05n

.meas tran vdout1_28ck1930 FIND v(dout1_28) AT=1940.05n

.meas tran vdout1_29ck1930 FIND v(dout1_29) AT=1940.05n

.meas tran vdout1_30ck1930 FIND v(dout1_30) AT=1940.05n

.meas tran vdout1_31ck1930 FIND v(dout1_31) AT=1940.05n

.meas tran vdout0_0ck1960 FIND v(dout0_0) AT=1970.05n

.meas tran vdout0_1ck1960 FIND v(dout0_1) AT=1970.05n

.meas tran vdout0_2ck1960 FIND v(dout0_2) AT=1970.05n

.meas tran vdout0_3ck1960 FIND v(dout0_3) AT=1970.05n

.meas tran vdout0_4ck1960 FIND v(dout0_4) AT=1970.05n

.meas tran vdout0_5ck1960 FIND v(dout0_5) AT=1970.05n

.meas tran vdout0_6ck1960 FIND v(dout0_6) AT=1970.05n

.meas tran vdout0_7ck1960 FIND v(dout0_7) AT=1970.05n

.meas tran vdout0_8ck1960 FIND v(dout0_8) AT=1970.05n

.meas tran vdout0_9ck1960 FIND v(dout0_9) AT=1970.05n

.meas tran vdout0_10ck1960 FIND v(dout0_10) AT=1970.05n

.meas tran vdout0_11ck1960 FIND v(dout0_11) AT=1970.05n

.meas tran vdout0_12ck1960 FIND v(dout0_12) AT=1970.05n

.meas tran vdout0_13ck1960 FIND v(dout0_13) AT=1970.05n

.meas tran vdout0_14ck1960 FIND v(dout0_14) AT=1970.05n

.meas tran vdout0_15ck1960 FIND v(dout0_15) AT=1970.05n

.meas tran vdout0_16ck1960 FIND v(dout0_16) AT=1970.05n

.meas tran vdout0_17ck1960 FIND v(dout0_17) AT=1970.05n

.meas tran vdout0_18ck1960 FIND v(dout0_18) AT=1970.05n

.meas tran vdout0_19ck1960 FIND v(dout0_19) AT=1970.05n

.meas tran vdout0_20ck1960 FIND v(dout0_20) AT=1970.05n

.meas tran vdout0_21ck1960 FIND v(dout0_21) AT=1970.05n

.meas tran vdout0_22ck1960 FIND v(dout0_22) AT=1970.05n

.meas tran vdout0_23ck1960 FIND v(dout0_23) AT=1970.05n

.meas tran vdout0_24ck1960 FIND v(dout0_24) AT=1970.05n

.meas tran vdout0_25ck1960 FIND v(dout0_25) AT=1970.05n

.meas tran vdout0_26ck1960 FIND v(dout0_26) AT=1970.05n

.meas tran vdout0_27ck1960 FIND v(dout0_27) AT=1970.05n

.meas tran vdout0_28ck1960 FIND v(dout0_28) AT=1970.05n

.meas tran vdout0_29ck1960 FIND v(dout0_29) AT=1970.05n

.meas tran vdout0_30ck1960 FIND v(dout0_30) AT=1970.05n

.meas tran vdout0_31ck1960 FIND v(dout0_31) AT=1970.05n

.meas tran vdout1_0ck1960 FIND v(dout1_0) AT=1970.05n

.meas tran vdout1_1ck1960 FIND v(dout1_1) AT=1970.05n

.meas tran vdout1_2ck1960 FIND v(dout1_2) AT=1970.05n

.meas tran vdout1_3ck1960 FIND v(dout1_3) AT=1970.05n

.meas tran vdout1_4ck1960 FIND v(dout1_4) AT=1970.05n

.meas tran vdout1_5ck1960 FIND v(dout1_5) AT=1970.05n

.meas tran vdout1_6ck1960 FIND v(dout1_6) AT=1970.05n

.meas tran vdout1_7ck1960 FIND v(dout1_7) AT=1970.05n

.meas tran vdout1_8ck1960 FIND v(dout1_8) AT=1970.05n

.meas tran vdout1_9ck1960 FIND v(dout1_9) AT=1970.05n

.meas tran vdout1_10ck1960 FIND v(dout1_10) AT=1970.05n

.meas tran vdout1_11ck1960 FIND v(dout1_11) AT=1970.05n

.meas tran vdout1_12ck1960 FIND v(dout1_12) AT=1970.05n

.meas tran vdout1_13ck1960 FIND v(dout1_13) AT=1970.05n

.meas tran vdout1_14ck1960 FIND v(dout1_14) AT=1970.05n

.meas tran vdout1_15ck1960 FIND v(dout1_15) AT=1970.05n

.meas tran vdout1_16ck1960 FIND v(dout1_16) AT=1970.05n

.meas tran vdout1_17ck1960 FIND v(dout1_17) AT=1970.05n

.meas tran vdout1_18ck1960 FIND v(dout1_18) AT=1970.05n

.meas tran vdout1_19ck1960 FIND v(dout1_19) AT=1970.05n

.meas tran vdout1_20ck1960 FIND v(dout1_20) AT=1970.05n

.meas tran vdout1_21ck1960 FIND v(dout1_21) AT=1970.05n

.meas tran vdout1_22ck1960 FIND v(dout1_22) AT=1970.05n

.meas tran vdout1_23ck1960 FIND v(dout1_23) AT=1970.05n

.meas tran vdout1_24ck1960 FIND v(dout1_24) AT=1970.05n

.meas tran vdout1_25ck1960 FIND v(dout1_25) AT=1970.05n

.meas tran vdout1_26ck1960 FIND v(dout1_26) AT=1970.05n

.meas tran vdout1_27ck1960 FIND v(dout1_27) AT=1970.05n

.meas tran vdout1_28ck1960 FIND v(dout1_28) AT=1970.05n

.meas tran vdout1_29ck1960 FIND v(dout1_29) AT=1970.05n

.meas tran vdout1_30ck1960 FIND v(dout1_30) AT=1970.05n

.meas tran vdout1_31ck1960 FIND v(dout1_31) AT=1970.05n

.meas tran vdout0_0ck1970 FIND v(dout0_0) AT=1980.05n

.meas tran vdout0_1ck1970 FIND v(dout0_1) AT=1980.05n

.meas tran vdout0_2ck1970 FIND v(dout0_2) AT=1980.05n

.meas tran vdout0_3ck1970 FIND v(dout0_3) AT=1980.05n

.meas tran vdout0_4ck1970 FIND v(dout0_4) AT=1980.05n

.meas tran vdout0_5ck1970 FIND v(dout0_5) AT=1980.05n

.meas tran vdout0_6ck1970 FIND v(dout0_6) AT=1980.05n

.meas tran vdout0_7ck1970 FIND v(dout0_7) AT=1980.05n

.meas tran vdout0_8ck1970 FIND v(dout0_8) AT=1980.05n

.meas tran vdout0_9ck1970 FIND v(dout0_9) AT=1980.05n

.meas tran vdout0_10ck1970 FIND v(dout0_10) AT=1980.05n

.meas tran vdout0_11ck1970 FIND v(dout0_11) AT=1980.05n

.meas tran vdout0_12ck1970 FIND v(dout0_12) AT=1980.05n

.meas tran vdout0_13ck1970 FIND v(dout0_13) AT=1980.05n

.meas tran vdout0_14ck1970 FIND v(dout0_14) AT=1980.05n

.meas tran vdout0_15ck1970 FIND v(dout0_15) AT=1980.05n

.meas tran vdout0_16ck1970 FIND v(dout0_16) AT=1980.05n

.meas tran vdout0_17ck1970 FIND v(dout0_17) AT=1980.05n

.meas tran vdout0_18ck1970 FIND v(dout0_18) AT=1980.05n

.meas tran vdout0_19ck1970 FIND v(dout0_19) AT=1980.05n

.meas tran vdout0_20ck1970 FIND v(dout0_20) AT=1980.05n

.meas tran vdout0_21ck1970 FIND v(dout0_21) AT=1980.05n

.meas tran vdout0_22ck1970 FIND v(dout0_22) AT=1980.05n

.meas tran vdout0_23ck1970 FIND v(dout0_23) AT=1980.05n

.meas tran vdout0_24ck1970 FIND v(dout0_24) AT=1980.05n

.meas tran vdout0_25ck1970 FIND v(dout0_25) AT=1980.05n

.meas tran vdout0_26ck1970 FIND v(dout0_26) AT=1980.05n

.meas tran vdout0_27ck1970 FIND v(dout0_27) AT=1980.05n

.meas tran vdout0_28ck1970 FIND v(dout0_28) AT=1980.05n

.meas tran vdout0_29ck1970 FIND v(dout0_29) AT=1980.05n

.meas tran vdout0_30ck1970 FIND v(dout0_30) AT=1980.05n

.meas tran vdout0_31ck1970 FIND v(dout0_31) AT=1980.05n

.meas tran vdout1_0ck1980 FIND v(dout1_0) AT=1990.05n

.meas tran vdout1_1ck1980 FIND v(dout1_1) AT=1990.05n

.meas tran vdout1_2ck1980 FIND v(dout1_2) AT=1990.05n

.meas tran vdout1_3ck1980 FIND v(dout1_3) AT=1990.05n

.meas tran vdout1_4ck1980 FIND v(dout1_4) AT=1990.05n

.meas tran vdout1_5ck1980 FIND v(dout1_5) AT=1990.05n

.meas tran vdout1_6ck1980 FIND v(dout1_6) AT=1990.05n

.meas tran vdout1_7ck1980 FIND v(dout1_7) AT=1990.05n

.meas tran vdout1_8ck1980 FIND v(dout1_8) AT=1990.05n

.meas tran vdout1_9ck1980 FIND v(dout1_9) AT=1990.05n

.meas tran vdout1_10ck1980 FIND v(dout1_10) AT=1990.05n

.meas tran vdout1_11ck1980 FIND v(dout1_11) AT=1990.05n

.meas tran vdout1_12ck1980 FIND v(dout1_12) AT=1990.05n

.meas tran vdout1_13ck1980 FIND v(dout1_13) AT=1990.05n

.meas tran vdout1_14ck1980 FIND v(dout1_14) AT=1990.05n

.meas tran vdout1_15ck1980 FIND v(dout1_15) AT=1990.05n

.meas tran vdout1_16ck1980 FIND v(dout1_16) AT=1990.05n

.meas tran vdout1_17ck1980 FIND v(dout1_17) AT=1990.05n

.meas tran vdout1_18ck1980 FIND v(dout1_18) AT=1990.05n

.meas tran vdout1_19ck1980 FIND v(dout1_19) AT=1990.05n

.meas tran vdout1_20ck1980 FIND v(dout1_20) AT=1990.05n

.meas tran vdout1_21ck1980 FIND v(dout1_21) AT=1990.05n

.meas tran vdout1_22ck1980 FIND v(dout1_22) AT=1990.05n

.meas tran vdout1_23ck1980 FIND v(dout1_23) AT=1990.05n

.meas tran vdout1_24ck1980 FIND v(dout1_24) AT=1990.05n

.meas tran vdout1_25ck1980 FIND v(dout1_25) AT=1990.05n

.meas tran vdout1_26ck1980 FIND v(dout1_26) AT=1990.05n

.meas tran vdout1_27ck1980 FIND v(dout1_27) AT=1990.05n

.meas tran vdout1_28ck1980 FIND v(dout1_28) AT=1990.05n

.meas tran vdout1_29ck1980 FIND v(dout1_29) AT=1990.05n

.meas tran vdout1_30ck1980 FIND v(dout1_30) AT=1990.05n

.meas tran vdout1_31ck1980 FIND v(dout1_31) AT=1990.05n

.meas tran vdout0_0ck1990 FIND v(dout0_0) AT=2000.05n

.meas tran vdout0_1ck1990 FIND v(dout0_1) AT=2000.05n

.meas tran vdout0_2ck1990 FIND v(dout0_2) AT=2000.05n

.meas tran vdout0_3ck1990 FIND v(dout0_3) AT=2000.05n

.meas tran vdout0_4ck1990 FIND v(dout0_4) AT=2000.05n

.meas tran vdout0_5ck1990 FIND v(dout0_5) AT=2000.05n

.meas tran vdout0_6ck1990 FIND v(dout0_6) AT=2000.05n

.meas tran vdout0_7ck1990 FIND v(dout0_7) AT=2000.05n

.meas tran vdout0_8ck1990 FIND v(dout0_8) AT=2000.05n

.meas tran vdout0_9ck1990 FIND v(dout0_9) AT=2000.05n

.meas tran vdout0_10ck1990 FIND v(dout0_10) AT=2000.05n

.meas tran vdout0_11ck1990 FIND v(dout0_11) AT=2000.05n

.meas tran vdout0_12ck1990 FIND v(dout0_12) AT=2000.05n

.meas tran vdout0_13ck1990 FIND v(dout0_13) AT=2000.05n

.meas tran vdout0_14ck1990 FIND v(dout0_14) AT=2000.05n

.meas tran vdout0_15ck1990 FIND v(dout0_15) AT=2000.05n

.meas tran vdout0_16ck1990 FIND v(dout0_16) AT=2000.05n

.meas tran vdout0_17ck1990 FIND v(dout0_17) AT=2000.05n

.meas tran vdout0_18ck1990 FIND v(dout0_18) AT=2000.05n

.meas tran vdout0_19ck1990 FIND v(dout0_19) AT=2000.05n

.meas tran vdout0_20ck1990 FIND v(dout0_20) AT=2000.05n

.meas tran vdout0_21ck1990 FIND v(dout0_21) AT=2000.05n

.meas tran vdout0_22ck1990 FIND v(dout0_22) AT=2000.05n

.meas tran vdout0_23ck1990 FIND v(dout0_23) AT=2000.05n

.meas tran vdout0_24ck1990 FIND v(dout0_24) AT=2000.05n

.meas tran vdout0_25ck1990 FIND v(dout0_25) AT=2000.05n

.meas tran vdout0_26ck1990 FIND v(dout0_26) AT=2000.05n

.meas tran vdout0_27ck1990 FIND v(dout0_27) AT=2000.05n

.meas tran vdout0_28ck1990 FIND v(dout0_28) AT=2000.05n

.meas tran vdout0_29ck1990 FIND v(dout0_29) AT=2000.05n

.meas tran vdout0_30ck1990 FIND v(dout0_30) AT=2000.05n

.meas tran vdout0_31ck1990 FIND v(dout0_31) AT=2000.05n

.meas tran vdout1_0ck1990 FIND v(dout1_0) AT=2000.05n

.meas tran vdout1_1ck1990 FIND v(dout1_1) AT=2000.05n

.meas tran vdout1_2ck1990 FIND v(dout1_2) AT=2000.05n

.meas tran vdout1_3ck1990 FIND v(dout1_3) AT=2000.05n

.meas tran vdout1_4ck1990 FIND v(dout1_4) AT=2000.05n

.meas tran vdout1_5ck1990 FIND v(dout1_5) AT=2000.05n

.meas tran vdout1_6ck1990 FIND v(dout1_6) AT=2000.05n

.meas tran vdout1_7ck1990 FIND v(dout1_7) AT=2000.05n

.meas tran vdout1_8ck1990 FIND v(dout1_8) AT=2000.05n

.meas tran vdout1_9ck1990 FIND v(dout1_9) AT=2000.05n

.meas tran vdout1_10ck1990 FIND v(dout1_10) AT=2000.05n

.meas tran vdout1_11ck1990 FIND v(dout1_11) AT=2000.05n

.meas tran vdout1_12ck1990 FIND v(dout1_12) AT=2000.05n

.meas tran vdout1_13ck1990 FIND v(dout1_13) AT=2000.05n

.meas tran vdout1_14ck1990 FIND v(dout1_14) AT=2000.05n

.meas tran vdout1_15ck1990 FIND v(dout1_15) AT=2000.05n

.meas tran vdout1_16ck1990 FIND v(dout1_16) AT=2000.05n

.meas tran vdout1_17ck1990 FIND v(dout1_17) AT=2000.05n

.meas tran vdout1_18ck1990 FIND v(dout1_18) AT=2000.05n

.meas tran vdout1_19ck1990 FIND v(dout1_19) AT=2000.05n

.meas tran vdout1_20ck1990 FIND v(dout1_20) AT=2000.05n

.meas tran vdout1_21ck1990 FIND v(dout1_21) AT=2000.05n

.meas tran vdout1_22ck1990 FIND v(dout1_22) AT=2000.05n

.meas tran vdout1_23ck1990 FIND v(dout1_23) AT=2000.05n

.meas tran vdout1_24ck1990 FIND v(dout1_24) AT=2000.05n

.meas tran vdout1_25ck1990 FIND v(dout1_25) AT=2000.05n

.meas tran vdout1_26ck1990 FIND v(dout1_26) AT=2000.05n

.meas tran vdout1_27ck1990 FIND v(dout1_27) AT=2000.05n

.meas tran vdout1_28ck1990 FIND v(dout1_28) AT=2000.05n

.meas tran vdout1_29ck1990 FIND v(dout1_29) AT=2000.05n

.meas tran vdout1_30ck1990 FIND v(dout1_30) AT=2000.05n

.meas tran vdout1_31ck1990 FIND v(dout1_31) AT=2000.05n

.meas tran vdout0_0ck2000 FIND v(dout0_0) AT=2010.05n

.meas tran vdout0_1ck2000 FIND v(dout0_1) AT=2010.05n

.meas tran vdout0_2ck2000 FIND v(dout0_2) AT=2010.05n

.meas tran vdout0_3ck2000 FIND v(dout0_3) AT=2010.05n

.meas tran vdout0_4ck2000 FIND v(dout0_4) AT=2010.05n

.meas tran vdout0_5ck2000 FIND v(dout0_5) AT=2010.05n

.meas tran vdout0_6ck2000 FIND v(dout0_6) AT=2010.05n

.meas tran vdout0_7ck2000 FIND v(dout0_7) AT=2010.05n

.meas tran vdout0_8ck2000 FIND v(dout0_8) AT=2010.05n

.meas tran vdout0_9ck2000 FIND v(dout0_9) AT=2010.05n

.meas tran vdout0_10ck2000 FIND v(dout0_10) AT=2010.05n

.meas tran vdout0_11ck2000 FIND v(dout0_11) AT=2010.05n

.meas tran vdout0_12ck2000 FIND v(dout0_12) AT=2010.05n

.meas tran vdout0_13ck2000 FIND v(dout0_13) AT=2010.05n

.meas tran vdout0_14ck2000 FIND v(dout0_14) AT=2010.05n

.meas tran vdout0_15ck2000 FIND v(dout0_15) AT=2010.05n

.meas tran vdout0_16ck2000 FIND v(dout0_16) AT=2010.05n

.meas tran vdout0_17ck2000 FIND v(dout0_17) AT=2010.05n

.meas tran vdout0_18ck2000 FIND v(dout0_18) AT=2010.05n

.meas tran vdout0_19ck2000 FIND v(dout0_19) AT=2010.05n

.meas tran vdout0_20ck2000 FIND v(dout0_20) AT=2010.05n

.meas tran vdout0_21ck2000 FIND v(dout0_21) AT=2010.05n

.meas tran vdout0_22ck2000 FIND v(dout0_22) AT=2010.05n

.meas tran vdout0_23ck2000 FIND v(dout0_23) AT=2010.05n

.meas tran vdout0_24ck2000 FIND v(dout0_24) AT=2010.05n

.meas tran vdout0_25ck2000 FIND v(dout0_25) AT=2010.05n

.meas tran vdout0_26ck2000 FIND v(dout0_26) AT=2010.05n

.meas tran vdout0_27ck2000 FIND v(dout0_27) AT=2010.05n

.meas tran vdout0_28ck2000 FIND v(dout0_28) AT=2010.05n

.meas tran vdout0_29ck2000 FIND v(dout0_29) AT=2010.05n

.meas tran vdout0_30ck2000 FIND v(dout0_30) AT=2010.05n

.meas tran vdout0_31ck2000 FIND v(dout0_31) AT=2010.05n

.meas tran vdout1_0ck2000 FIND v(dout1_0) AT=2010.05n

.meas tran vdout1_1ck2000 FIND v(dout1_1) AT=2010.05n

.meas tran vdout1_2ck2000 FIND v(dout1_2) AT=2010.05n

.meas tran vdout1_3ck2000 FIND v(dout1_3) AT=2010.05n

.meas tran vdout1_4ck2000 FIND v(dout1_4) AT=2010.05n

.meas tran vdout1_5ck2000 FIND v(dout1_5) AT=2010.05n

.meas tran vdout1_6ck2000 FIND v(dout1_6) AT=2010.05n

.meas tran vdout1_7ck2000 FIND v(dout1_7) AT=2010.05n

.meas tran vdout1_8ck2000 FIND v(dout1_8) AT=2010.05n

.meas tran vdout1_9ck2000 FIND v(dout1_9) AT=2010.05n

.meas tran vdout1_10ck2000 FIND v(dout1_10) AT=2010.05n

.meas tran vdout1_11ck2000 FIND v(dout1_11) AT=2010.05n

.meas tran vdout1_12ck2000 FIND v(dout1_12) AT=2010.05n

.meas tran vdout1_13ck2000 FIND v(dout1_13) AT=2010.05n

.meas tran vdout1_14ck2000 FIND v(dout1_14) AT=2010.05n

.meas tran vdout1_15ck2000 FIND v(dout1_15) AT=2010.05n

.meas tran vdout1_16ck2000 FIND v(dout1_16) AT=2010.05n

.meas tran vdout1_17ck2000 FIND v(dout1_17) AT=2010.05n

.meas tran vdout1_18ck2000 FIND v(dout1_18) AT=2010.05n

.meas tran vdout1_19ck2000 FIND v(dout1_19) AT=2010.05n

.meas tran vdout1_20ck2000 FIND v(dout1_20) AT=2010.05n

.meas tran vdout1_21ck2000 FIND v(dout1_21) AT=2010.05n

.meas tran vdout1_22ck2000 FIND v(dout1_22) AT=2010.05n

.meas tran vdout1_23ck2000 FIND v(dout1_23) AT=2010.05n

.meas tran vdout1_24ck2000 FIND v(dout1_24) AT=2010.05n

.meas tran vdout1_25ck2000 FIND v(dout1_25) AT=2010.05n

.meas tran vdout1_26ck2000 FIND v(dout1_26) AT=2010.05n

.meas tran vdout1_27ck2000 FIND v(dout1_27) AT=2010.05n

.meas tran vdout1_28ck2000 FIND v(dout1_28) AT=2010.05n

.meas tran vdout1_29ck2000 FIND v(dout1_29) AT=2010.05n

.meas tran vdout1_30ck2000 FIND v(dout1_30) AT=2010.05n

.meas tran vdout1_31ck2000 FIND v(dout1_31) AT=2010.05n

.meas tran vdout1_0ck2010 FIND v(dout1_0) AT=2020.05n

.meas tran vdout1_1ck2010 FIND v(dout1_1) AT=2020.05n

.meas tran vdout1_2ck2010 FIND v(dout1_2) AT=2020.05n

.meas tran vdout1_3ck2010 FIND v(dout1_3) AT=2020.05n

.meas tran vdout1_4ck2010 FIND v(dout1_4) AT=2020.05n

.meas tran vdout1_5ck2010 FIND v(dout1_5) AT=2020.05n

.meas tran vdout1_6ck2010 FIND v(dout1_6) AT=2020.05n

.meas tran vdout1_7ck2010 FIND v(dout1_7) AT=2020.05n

.meas tran vdout1_8ck2010 FIND v(dout1_8) AT=2020.05n

.meas tran vdout1_9ck2010 FIND v(dout1_9) AT=2020.05n

.meas tran vdout1_10ck2010 FIND v(dout1_10) AT=2020.05n

.meas tran vdout1_11ck2010 FIND v(dout1_11) AT=2020.05n

.meas tran vdout1_12ck2010 FIND v(dout1_12) AT=2020.05n

.meas tran vdout1_13ck2010 FIND v(dout1_13) AT=2020.05n

.meas tran vdout1_14ck2010 FIND v(dout1_14) AT=2020.05n

.meas tran vdout1_15ck2010 FIND v(dout1_15) AT=2020.05n

.meas tran vdout1_16ck2010 FIND v(dout1_16) AT=2020.05n

.meas tran vdout1_17ck2010 FIND v(dout1_17) AT=2020.05n

.meas tran vdout1_18ck2010 FIND v(dout1_18) AT=2020.05n

.meas tran vdout1_19ck2010 FIND v(dout1_19) AT=2020.05n

.meas tran vdout1_20ck2010 FIND v(dout1_20) AT=2020.05n

.meas tran vdout1_21ck2010 FIND v(dout1_21) AT=2020.05n

.meas tran vdout1_22ck2010 FIND v(dout1_22) AT=2020.05n

.meas tran vdout1_23ck2010 FIND v(dout1_23) AT=2020.05n

.meas tran vdout1_24ck2010 FIND v(dout1_24) AT=2020.05n

.meas tran vdout1_25ck2010 FIND v(dout1_25) AT=2020.05n

.meas tran vdout1_26ck2010 FIND v(dout1_26) AT=2020.05n

.meas tran vdout1_27ck2010 FIND v(dout1_27) AT=2020.05n

.meas tran vdout1_28ck2010 FIND v(dout1_28) AT=2020.05n

.meas tran vdout1_29ck2010 FIND v(dout1_29) AT=2020.05n

.meas tran vdout1_30ck2010 FIND v(dout1_30) AT=2020.05n

.meas tran vdout1_31ck2010 FIND v(dout1_31) AT=2020.05n

.meas tran vdout0_0ck2040 FIND v(dout0_0) AT=2050.05n

.meas tran vdout0_1ck2040 FIND v(dout0_1) AT=2050.05n

.meas tran vdout0_2ck2040 FIND v(dout0_2) AT=2050.05n

.meas tran vdout0_3ck2040 FIND v(dout0_3) AT=2050.05n

.meas tran vdout0_4ck2040 FIND v(dout0_4) AT=2050.05n

.meas tran vdout0_5ck2040 FIND v(dout0_5) AT=2050.05n

.meas tran vdout0_6ck2040 FIND v(dout0_6) AT=2050.05n

.meas tran vdout0_7ck2040 FIND v(dout0_7) AT=2050.05n

.meas tran vdout0_8ck2040 FIND v(dout0_8) AT=2050.05n

.meas tran vdout0_9ck2040 FIND v(dout0_9) AT=2050.05n

.meas tran vdout0_10ck2040 FIND v(dout0_10) AT=2050.05n

.meas tran vdout0_11ck2040 FIND v(dout0_11) AT=2050.05n

.meas tran vdout0_12ck2040 FIND v(dout0_12) AT=2050.05n

.meas tran vdout0_13ck2040 FIND v(dout0_13) AT=2050.05n

.meas tran vdout0_14ck2040 FIND v(dout0_14) AT=2050.05n

.meas tran vdout0_15ck2040 FIND v(dout0_15) AT=2050.05n

.meas tran vdout0_16ck2040 FIND v(dout0_16) AT=2050.05n

.meas tran vdout0_17ck2040 FIND v(dout0_17) AT=2050.05n

.meas tran vdout0_18ck2040 FIND v(dout0_18) AT=2050.05n

.meas tran vdout0_19ck2040 FIND v(dout0_19) AT=2050.05n

.meas tran vdout0_20ck2040 FIND v(dout0_20) AT=2050.05n

.meas tran vdout0_21ck2040 FIND v(dout0_21) AT=2050.05n

.meas tran vdout0_22ck2040 FIND v(dout0_22) AT=2050.05n

.meas tran vdout0_23ck2040 FIND v(dout0_23) AT=2050.05n

.meas tran vdout0_24ck2040 FIND v(dout0_24) AT=2050.05n

.meas tran vdout0_25ck2040 FIND v(dout0_25) AT=2050.05n

.meas tran vdout0_26ck2040 FIND v(dout0_26) AT=2050.05n

.meas tran vdout0_27ck2040 FIND v(dout0_27) AT=2050.05n

.meas tran vdout0_28ck2040 FIND v(dout0_28) AT=2050.05n

.meas tran vdout0_29ck2040 FIND v(dout0_29) AT=2050.05n

.meas tran vdout0_30ck2040 FIND v(dout0_30) AT=2050.05n

.meas tran vdout0_31ck2040 FIND v(dout0_31) AT=2050.05n

.meas tran vdout1_0ck2040 FIND v(dout1_0) AT=2050.05n

.meas tran vdout1_1ck2040 FIND v(dout1_1) AT=2050.05n

.meas tran vdout1_2ck2040 FIND v(dout1_2) AT=2050.05n

.meas tran vdout1_3ck2040 FIND v(dout1_3) AT=2050.05n

.meas tran vdout1_4ck2040 FIND v(dout1_4) AT=2050.05n

.meas tran vdout1_5ck2040 FIND v(dout1_5) AT=2050.05n

.meas tran vdout1_6ck2040 FIND v(dout1_6) AT=2050.05n

.meas tran vdout1_7ck2040 FIND v(dout1_7) AT=2050.05n

.meas tran vdout1_8ck2040 FIND v(dout1_8) AT=2050.05n

.meas tran vdout1_9ck2040 FIND v(dout1_9) AT=2050.05n

.meas tran vdout1_10ck2040 FIND v(dout1_10) AT=2050.05n

.meas tran vdout1_11ck2040 FIND v(dout1_11) AT=2050.05n

.meas tran vdout1_12ck2040 FIND v(dout1_12) AT=2050.05n

.meas tran vdout1_13ck2040 FIND v(dout1_13) AT=2050.05n

.meas tran vdout1_14ck2040 FIND v(dout1_14) AT=2050.05n

.meas tran vdout1_15ck2040 FIND v(dout1_15) AT=2050.05n

.meas tran vdout1_16ck2040 FIND v(dout1_16) AT=2050.05n

.meas tran vdout1_17ck2040 FIND v(dout1_17) AT=2050.05n

.meas tran vdout1_18ck2040 FIND v(dout1_18) AT=2050.05n

.meas tran vdout1_19ck2040 FIND v(dout1_19) AT=2050.05n

.meas tran vdout1_20ck2040 FIND v(dout1_20) AT=2050.05n

.meas tran vdout1_21ck2040 FIND v(dout1_21) AT=2050.05n

.meas tran vdout1_22ck2040 FIND v(dout1_22) AT=2050.05n

.meas tran vdout1_23ck2040 FIND v(dout1_23) AT=2050.05n

.meas tran vdout1_24ck2040 FIND v(dout1_24) AT=2050.05n

.meas tran vdout1_25ck2040 FIND v(dout1_25) AT=2050.05n

.meas tran vdout1_26ck2040 FIND v(dout1_26) AT=2050.05n

.meas tran vdout1_27ck2040 FIND v(dout1_27) AT=2050.05n

.meas tran vdout1_28ck2040 FIND v(dout1_28) AT=2050.05n

.meas tran vdout1_29ck2040 FIND v(dout1_29) AT=2050.05n

.meas tran vdout1_30ck2040 FIND v(dout1_30) AT=2050.05n

.meas tran vdout1_31ck2040 FIND v(dout1_31) AT=2050.05n
