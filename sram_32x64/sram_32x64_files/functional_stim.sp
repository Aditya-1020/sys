* Functional test stimulus file for 10ns period

* FF process corner
.lib "/home/link/eda/.volare/sky130A/libs.tech/ngspice/sky130.lib.spice" ff
.include "/tmp/openram_link_680848_temp/sram.sp"

* Global Power Supplies
Vvdd vdd 0 1.95

*Nodes gnd and 0 are the same global ground node in ngspice/hspice/xa. Otherwise, this source may be needed.
*Vgnd gnd 0 0.0

* Instantiation of the SRAM
Xsky130_sram_256byte_1rw1r_32x64_8 din0_0 din0_1 din0_2 din0_3 din0_4 din0_5 din0_6 din0_7 din0_8 din0_9 din0_10 din0_11 din0_12 din0_13 din0_14 din0_15 din0_16 din0_17 din0_18 din0_19 din0_20 din0_21 din0_22 din0_23 din0_24 din0_25 din0_26 din0_27 din0_28 din0_29 din0_30 din0_31 a0_0 a0_1 a0_2 a0_3 a0_4 a0_5 a1_0 a1_1 a1_2 a1_3 a1_4 a1_5 CSB0 CSB1 WEB0 clk0 clk1 WMASK0_0 WMASK0_1 WMASK0_2 WMASK0_3 dout0_0 dout0_1 dout0_2 dout0_3 dout0_4 dout0_5 dout0_6 dout0_7 dout0_8 dout0_9 dout0_10 dout0_11 dout0_12 dout0_13 dout0_14 dout0_15 dout0_16 dout0_17 dout0_18 dout0_19 dout0_20 dout0_21 dout0_22 dout0_23 dout0_24 dout0_25 dout0_26 dout0_27 dout0_28 dout0_29 dout0_30 dout0_31 dout1_0 dout1_1 dout1_2 dout1_3 dout1_4 dout1_5 dout1_6 dout1_7 dout1_8 dout1_9 dout1_10 dout1_11 dout1_12 dout1_13 dout1_14 dout1_15 dout1_16 dout1_17 dout1_18 dout1_19 dout1_20 dout1_21 dout1_22 dout1_23 dout1_24 dout1_25 dout1_26 dout1_27 dout1_28 dout1_29 dout1_30 dout1_31 vdd gnd sky130_sram_256byte_1rw1r_32x64_8

* SRAM output loads
CD00 dout0_0  0 27.56f
CD01 dout0_1  0 27.56f
CD02 dout0_2  0 27.56f
CD03 dout0_3  0 27.56f
CD04 dout0_4  0 27.56f
CD05 dout0_5  0 27.56f
CD06 dout0_6  0 27.56f
CD07 dout0_7  0 27.56f
CD08 dout0_8  0 27.56f
CD09 dout0_9  0 27.56f
CD010 dout0_10  0 27.56f
CD011 dout0_11  0 27.56f
CD012 dout0_12  0 27.56f
CD013 dout0_13  0 27.56f
CD014 dout0_14  0 27.56f
CD015 dout0_15  0 27.56f
CD016 dout0_16  0 27.56f
CD017 dout0_17  0 27.56f
CD018 dout0_18  0 27.56f
CD019 dout0_19  0 27.56f
CD020 dout0_20  0 27.56f
CD021 dout0_21  0 27.56f
CD022 dout0_22  0 27.56f
CD023 dout0_23  0 27.56f
CD024 dout0_24  0 27.56f
CD025 dout0_25  0 27.56f
CD026 dout0_26  0 27.56f
CD027 dout0_27  0 27.56f
CD028 dout0_28  0 27.56f
CD029 dout0_29  0 27.56f
CD030 dout0_30  0 27.56f
CD031 dout0_31  0 27.56f
CD10 dout1_0  0 27.56f
CD11 dout1_1  0 27.56f
CD12 dout1_2  0 27.56f
CD13 dout1_3  0 27.56f
CD14 dout1_4  0 27.56f
CD15 dout1_5  0 27.56f
CD16 dout1_6  0 27.56f
CD17 dout1_7  0 27.56f
CD18 dout1_8  0 27.56f
CD19 dout1_9  0 27.56f
CD110 dout1_10  0 27.56f
CD111 dout1_11  0 27.56f
CD112 dout1_12  0 27.56f
CD113 dout1_13  0 27.56f
CD114 dout1_14  0 27.56f
CD115 dout1_15  0 27.56f
CD116 dout1_16  0 27.56f
CD117 dout1_17  0 27.56f
CD118 dout1_18  0 27.56f
CD119 dout1_19  0 27.56f
CD120 dout1_20  0 27.56f
CD121 dout1_21  0 27.56f
CD122 dout1_22  0 27.56f
CD123 dout1_23  0 27.56f
CD124 dout1_24  0 27.56f
CD125 dout1_25  0 27.56f
CD126 dout1_26  0 27.56f
CD127 dout1_27  0 27.56f
CD128 dout1_28  0 27.56f
CD129 dout1_29  0 27.56f
CD130 dout1_30  0 27.56f
CD131 dout1_31  0 27.56f

* Important signals for debug
* bl:	xsram:xbank0:bl_0_1
* br:	xsram:xbank0:br_0_1
* s_en:	xsram:s_en
* q:	xsram:xbank0:xbitcell_array:xbitcell_array:xbit_r0_c0.Q
* qbar:	xsram:xbank0:xbitcell_array:xbitcell_array:xbit_r0_c0.Q_bar

* Sequence of operations
*	Idle during cycle 0 (0ns - 10ns)
*	Writing 11010011100110011011001110100111  to  address 000001 (from port 0) during cycle 1 (10ns - 20ns)
*	Writing 01100101110111000100110001110010  to  address 000000 (from port 0) during cycle 2 (20ns - 30ns)
*	Writing 11010111101011110101011000001000  to  address 000000 (from port 0) during cycle 3 (30ns - 40ns)
*	Reading 11010011100110011011001110100111 from address 000001 (from port 0) during cycle 4 (40ns - 50ns)
*	Reading 11010011100110011011001110100111 from address 000001 (from port 1) during cycle 4 (40ns - 50ns)
*	Reading 11010111101011110101011000001000 from address 000000 (from port 0) during cycle 5 (50ns - 60ns)
*	Reading 11010011100110011011001110100111 from address 000001 (from port 1) during cycle 5 (50ns - 60ns)
*	Writing (partial) 00001100001101010011001000011101  to  address 000001 with mask bit 0011 (from port 0) during cycle 6 (60ns - 70ns)
*	Writing 00010111011111010010000011111100  to  address 000001 (from port 0) during cycle 7 (70ns - 80ns)
*	Writing 01110101001001110010111101011010  to  address 000001 (from port 0) during cycle 8 (80ns - 90ns)
*	Reading 01110101001001110010111101011010 from address 000001 (from port 0) during cycle 9 (90ns - 100ns)
*	Reading 01110101001001110010111101011010 from address 000001 (from port 1) during cycle 9 (90ns - 100ns)
*	Writing 01011000000011111011000110001101  to  address 000000 (from port 0) during cycle 11 (110ns - 120ns)
*	Reading 01110101001001110010111101011010 from address 000001 (from port 0) during cycle 12 (120ns - 130ns)
*	Reading 01110101001001110010111101011010 from address 000001 (from port 1) during cycle 12 (120ns - 130ns)
*	Reading 01011000000011111011000110001101 from address 000000 (from port 1) during cycle 13 (130ns - 140ns)
*	Reading 01011000000011111011000110001101 from address 000000 (from port 0) during cycle 14 (140ns - 150ns)
*	Reading 01110101001001110010111101011010 from address 000001 (from port 1) during cycle 14 (140ns - 150ns)
*	Reading 01110101001001110010111101011010 from address 000001 (from port 1) during cycle 15 (150ns - 160ns)
*	Writing (partial) 11111001010101001100110111110000  to  address 000000 with mask bit 0010 (from port 0) during cycle 16 (160ns - 170ns)
*	Reading 01011000000011111100110110001101 from address 000000 (from port 0) during cycle 17 (170ns - 180ns)
*	Reading 01011000000011111100110110001101 from address 000000 (from port 1) during cycle 17 (170ns - 180ns)
*	Reading 01011000000011111100110110001101 from address 000000 (from port 0) during cycle 18 (180ns - 190ns)
*	Reading 01110101001001110010111101011010 from address 000001 (from port 1) during cycle 18 (180ns - 190ns)
*	Reading 01110101001001110010111101011010 from address 000001 (from port 0) during cycle 19 (190ns - 200ns)
*	Reading 01011000000011111100110110001101 from address 000000 (from port 0) during cycle 20 (200ns - 210ns)
*	Reading 01110101001001110010111101011010 from address 000001 (from port 1) during cycle 20 (200ns - 210ns)
*	Reading 01110101001001110010111101011010 from address 000001 (from port 0) during cycle 21 (210ns - 220ns)
*	Reading 01011000000011111100110110001101 from address 000000 (from port 1) during cycle 21 (210ns - 220ns)
*	Writing (partial) 11010011010101101111100101100111  to  address 000000 with mask bit 1000 (from port 0) during cycle 24 (240ns - 250ns)
*	Reading 11010011000011111100110110001101 from address 000000 (from port 1) during cycle 25 (250ns - 260ns)
*	Writing (partial) 10111011110110000000001101111101  to  address 000000 with mask bit 0100 (from port 0) during cycle 27 (270ns - 280ns)
*	Reading 01110101001001110010111101011010 from address 000001 (from port 0) during cycle 28 (280ns - 290ns)
*	Reading 11010011110110001100110110001101 from address 000000 (from port 0) during cycle 29 (290ns - 300ns)
*	Reading 11010011110110001100110110001101 from address 000000 (from port 1) during cycle 29 (290ns - 300ns)
*	Writing 01100111011000101110100110110111  to  address 000001 (from port 0) during cycle 30 (300ns - 310ns)
*	Reading 11010011110110001100110110001101 from address 000000 (from port 1) during cycle 31 (310ns - 320ns)
*	Reading 11010011110110001100110110001101 from address 000000 (from port 1) during cycle 32 (320ns - 330ns)
*	Writing 01101100010011101111100110011111  to  address 000001 (from port 0) during cycle 34 (340ns - 350ns)
*	Reading 11010011110110001100110110001101 from address 000000 (from port 0) during cycle 35 (350ns - 360ns)
*	Reading 11010011110110001100110110001101 from address 000000 (from port 0) during cycle 36 (360ns - 370ns)
*	Writing (partial) 10110110111111011000000001001000  to  address 000000 with mask bit 1110 (from port 0) during cycle 37 (370ns - 380ns)
*	Reading 01101100010011101111100110011111 from address 000001 (from port 1) during cycle 37 (370ns - 380ns)
*	Reading 10110110111111011000000010001101 from address 000000 (from port 1) during cycle 38 (380ns - 390ns)
*	Writing 11110110000010011111110101011000  to  address 111101 (from port 0) during cycle 40 (400ns - 410ns)
*	Writing 10011011011001100010011011100000  to  address 111110 (from port 0) during cycle 42 (420ns - 430ns)
*	Reading 11110110000010011111110101011000 from address 111101 (from port 1) during cycle 42 (420ns - 430ns)
*	Reading 10011011011001100010011011100000 from address 111110 (from port 0) during cycle 43 (430ns - 440ns)
*	Reading 01101100010011101111100110011111 from address 000001 (from port 1) during cycle 43 (430ns - 440ns)
*	Reading 11110110000010011111110101011000 from address 111101 (from port 0) during cycle 44 (440ns - 450ns)
*	Reading 01101100010011101111100110011111 from address 000001 (from port 1) during cycle 44 (440ns - 450ns)
*	Reading 10110110111111011000000010001101 from address 000000 (from port 0) during cycle 46 (460ns - 470ns)
*	Reading 11110110000010011111110101011000 from address 111101 (from port 1) during cycle 46 (460ns - 470ns)
*	Reading 10011011011001100010011011100000 from address 111110 (from port 0) during cycle 47 (470ns - 480ns)
*	Reading 10110110111111011000000010001101 from address 000000 (from port 0) during cycle 49 (490ns - 500ns)
*	Writing 01110111010010111001110000011101  to  address 000001 (from port 0) during cycle 50 (500ns - 510ns)
*	Writing 10001101101111010010100000110010  to  address 000000 (from port 0) during cycle 51 (510ns - 520ns)
*	Reading 11110110000010011111110101011000 from address 111101 (from port 1) during cycle 51 (510ns - 520ns)
*	Reading 01110111010010111001110000011101 from address 000001 (from port 0) during cycle 52 (520ns - 530ns)
*	Writing 10110111111001111111110110100100  to  address 111110 (from port 0) during cycle 54 (540ns - 550ns)
*	Writing 11000001100001100111111111010011  to  address 111101 (from port 0) during cycle 55 (550ns - 560ns)
*	Reading 10110111111001111111110110100100 from address 111110 (from port 0) during cycle 56 (560ns - 570ns)
*	Reading 10110111111001111111110110100100 from address 111110 (from port 0) during cycle 58 (580ns - 590ns)
*	Reading 10110111111001111111110110100100 from address 111110 (from port 1) during cycle 58 (580ns - 590ns)
*	Writing 00110111011101000111101011110000  to  address 000001 (from port 0) during cycle 59 (590ns - 600ns)
*	Reading 11000001100001100111111111010011 from address 111101 (from port 0) during cycle 60 (600ns - 610ns)
*	Reading 11000001100001100111111111010011 from address 111101 (from port 1) during cycle 60 (600ns - 610ns)
*	Reading 10110111111001111111110110100100 from address 111110 (from port 0) during cycle 61 (610ns - 620ns)
*	Reading 10110111111001111111110110100100 from address 111110 (from port 0) during cycle 62 (620ns - 630ns)
*	Reading 00110111011101000111101011110000 from address 000001 (from port 1) during cycle 62 (620ns - 630ns)
*	Reading 00110111011101000111101011110000 from address 000001 (from port 1) during cycle 63 (630ns - 640ns)
*	Writing (partial) 00001111010010000011101001111110  to  address 111101 with mask bit 1110 (from port 0) during cycle 64 (640ns - 650ns)
*	Writing (partial) 11100101110010010001011000110110  to  address 000000 with mask bit 1001 (from port 0) during cycle 65 (650ns - 660ns)
*	Reading 00001111010010000011101011010011 from address 111101 (from port 1) during cycle 65 (650ns - 660ns)
*	Reading 00001111010010000011101011010011 from address 111101 (from port 0) during cycle 66 (660ns - 670ns)
*	Reading 00110111011101000111101011110000 from address 000001 (from port 1) during cycle 66 (660ns - 670ns)
*	Writing 00010011101100000110101000101010  to  address 000001 (from port 0) during cycle 67 (670ns - 680ns)
*	Reading 00010011101100000110101000101010 from address 000001 (from port 0) during cycle 68 (680ns - 690ns)
*	Reading 10110111111001111111110110100100 from address 111110 (from port 0) during cycle 69 (690ns - 700ns)
*	Reading 00001111010010000011101011010011 from address 111101 (from port 1) during cycle 69 (690ns - 700ns)
*	Writing (partial) 01011110011110000101110010010100  to  address 000001 with mask bit 0101 (from port 0) during cycle 70 (700ns - 710ns)
*	Reading 10110111111001111111110110100100 from address 111110 (from port 1) during cycle 70 (700ns - 710ns)
*	Writing (partial) 00010001001000110000011000000010  to  address 111101 with mask bit 1100 (from port 0) during cycle 73 (730ns - 740ns)
*	Reading 11100101101111010010100000110110 from address 000000 (from port 0) during cycle 74 (740ns - 750ns)
*	Reading 00010011011110000110101010010100 from address 000001 (from port 1) during cycle 74 (740ns - 750ns)
*	Writing (partial) 10110101011110010011101000000010  to  address 111101 with mask bit 1101 (from port 0) during cycle 75 (750ns - 760ns)
*	Reading 11100101101111010010100000110110 from address 000000 (from port 0) during cycle 76 (760ns - 770ns)
*	Writing 10011011101011111011110101011001  to  address 000000 (from port 0) during cycle 77 (770ns - 780ns)
*	Writing (partial) 00010100000011111011110110001000  to  address 111110 with mask bit 0101 (from port 0) during cycle 78 (780ns - 790ns)
*	Reading 10110101011110010011101000000010 from address 111101 (from port 1) during cycle 78 (780ns - 790ns)
*	Writing (partial) 01100010101101011001110001010110  to  address 000000 with mask bit 0110 (from port 0) during cycle 79 (790ns - 800ns)
*	Writing (partial) 01100010111111111100110111001111  to  address 111101 with mask bit 1010 (from port 0) during cycle 81 (810ns - 820ns)
*	Reading 10110111000011111111110110001000 from address 111110 (from port 0) during cycle 82 (820ns - 830ns)
*	Reading 10110111000011111111110110001000 from address 111110 (from port 1) during cycle 82 (820ns - 830ns)
*	Writing (partial) 01110110111000111010101111010010  to  address 000000 with mask bit 1000 (from port 0) during cycle 83 (830ns - 840ns)
*	Reading 10110111000011111111110110001000 from address 111110 (from port 1) during cycle 83 (830ns - 840ns)
*	Writing 11010110000000101100111011011000  to  address 000000 (from port 0) during cycle 85 (850ns - 860ns)
*	Reading 00010011011110000110101010010100 from address 000001 (from port 1) during cycle 85 (850ns - 860ns)
*	Reading 00010011011110000110101010010100 from address 000001 (from port 0) during cycle 86 (860ns - 870ns)
*	Reading 00010011011110000110101010010100 from address 000001 (from port 1) during cycle 86 (860ns - 870ns)
*	Reading 11010110000000101100111011011000 from address 000000 (from port 1) during cycle 87 (870ns - 880ns)
*	Reading 01100010011110011100110100000010 from address 111101 (from port 0) during cycle 88 (880ns - 890ns)
*	Reading 01100010011110011100110100000010 from address 111101 (from port 1) during cycle 88 (880ns - 890ns)
*	Reading 00010011011110000110101010010100 from address 000001 (from port 0) during cycle 89 (890ns - 900ns)
*	Reading 01100010011110011100110100000010 from address 111101 (from port 1) during cycle 89 (890ns - 900ns)
*	Reading 00010011011110000110101010010100 from address 000001 (from port 0) during cycle 90 (900ns - 910ns)
*	Reading 00010011011110000110101010010100 from address 000001 (from port 1) during cycle 90 (900ns - 910ns)
*	Reading 00010011011110000110101010010100 from address 000001 (from port 0) during cycle 91 (910ns - 920ns)
*	Reading 00010011011110000110101010010100 from address 000001 (from port 0) during cycle 92 (920ns - 930ns)
*	Reading 00010011011110000110101010010100 from address 000001 (from port 1) during cycle 92 (920ns - 930ns)
*	Reading 11010110000000101100111011011000 from address 000000 (from port 0) during cycle 93 (930ns - 940ns)
*	Reading 11010110000000101100111011011000 from address 000000 (from port 1) during cycle 93 (930ns - 940ns)
*	Writing 01100010000101001001000101110100  to  address 000001 (from port 0) during cycle 94 (940ns - 950ns)
*	Writing 11011011101100000000101100101101  to  address 111110 (from port 0) during cycle 95 (950ns - 960ns)
*	Reading 11011011101100000000101100101101 from address 111110 (from port 0) during cycle 96 (960ns - 970ns)
*	Reading 01100010011110011100110100000010 from address 111101 (from port 1) during cycle 96 (960ns - 970ns)
*	Writing 01111001110001010101001010011111  to  address 111110 (from port 0) during cycle 97 (970ns - 980ns)
*	Writing (partial) 10110010111011100010010001101110  to  address 000001 with mask bit 1001 (from port 0) during cycle 98 (980ns - 990ns)
*	Writing (partial) 01110011001001011111000000101111  to  address 111110 with mask bit 0010 (from port 0) during cycle 99 (990ns - 1000ns)
*	Reading 01100010011110011100110100000010 from address 111101 (from port 0) during cycle 100 (1000ns - 1010ns)
*	Writing (partial) 10001001110001011010101010000011  to  address 111110 with mask bit 0110 (from port 0) during cycle 101 (1010ns - 1020ns)
*	Reading 10110010000101001001000101101110 from address 000001 (from port 1) during cycle 101 (1010ns - 1020ns)
*	Reading 01100010011110011100110100000010 from address 111101 (from port 0) during cycle 102 (1020ns - 1030ns)
*	Reading 10110010000101001001000101101110 from address 000001 (from port 1) during cycle 102 (1020ns - 1030ns)
*	Writing 01110111011010010010001111111010  to  address 111110 (from port 0) during cycle 103 (1030ns - 1040ns)
*	Reading 10110010000101001001000101101110 from address 000001 (from port 1) during cycle 104 (1040ns - 1050ns)
*	Writing (partial) 01000010001000000011101101010100  to  address 111101 with mask bit 1011 (from port 0) during cycle 105 (1050ns - 1060ns)
*	Reading 01110111011010010010001111111010 from address 111110 (from port 1) during cycle 105 (1050ns - 1060ns)
*	Reading 10110010000101001001000101101110 from address 000001 (from port 0) during cycle 107 (1070ns - 1080ns)
*	Reading 10110010000101001001000101101110 from address 000001 (from port 1) during cycle 107 (1070ns - 1080ns)
*	Reading 11010110000000101100111011011000 from address 000000 (from port 0) during cycle 109 (1090ns - 1100ns)
*	Reading 01000010011110010011101101010100 from address 111101 (from port 1) during cycle 109 (1090ns - 1100ns)
*	Writing (partial) 11110011011101100011101100010011  to  address 000000 with mask bit 1000 (from port 0) during cycle 111 (1110ns - 1120ns)
*	Reading 01110111011010010010001111111010 from address 111110 (from port 1) during cycle 111 (1110ns - 1120ns)
*	Reading 11110011000000101100111011011000 from address 000000 (from port 0) during cycle 112 (1120ns - 1130ns)
*	Reading 01000010011110010011101101010100 from address 111101 (from port 1) during cycle 112 (1120ns - 1130ns)
*	Reading 01000010011110010011101101010100 from address 111101 (from port 0) during cycle 113 (1130ns - 1140ns)
*	Reading 01000010011110010011101101010100 from address 111101 (from port 1) during cycle 113 (1130ns - 1140ns)
*	Reading 11110011000000101100111011011000 from address 000000 (from port 0) during cycle 114 (1140ns - 1150ns)
*	Writing 00110101101010001000011011101010  to  address 000000 (from port 0) during cycle 115 (1150ns - 1160ns)
*	Reading 01110111011010010010001111111010 from address 111110 (from port 1) during cycle 115 (1150ns - 1160ns)
*	Reading 01000010011110010011101101010100 from address 111101 (from port 0) during cycle 116 (1160ns - 1170ns)
*	Reading 01110111011010010010001111111010 from address 111110 (from port 1) during cycle 116 (1160ns - 1170ns)
*	Reading 01110111011010010010001111111010 from address 111110 (from port 0) during cycle 117 (1170ns - 1180ns)
*	Reading 00110101101010001000011011101010 from address 000000 (from port 1) during cycle 117 (1170ns - 1180ns)
*	Reading 01110111011010010010001111111010 from address 111110 (from port 1) during cycle 118 (1180ns - 1190ns)
*	Reading 01000010011110010011101101010100 from address 111101 (from port 0) during cycle 119 (1190ns - 1200ns)
*	Reading 01000010011110010011101101010100 from address 111101 (from port 0) during cycle 120 (1200ns - 1210ns)
*	Reading 10110010000101001001000101101110 from address 000001 (from port 1) during cycle 120 (1200ns - 1210ns)
*	Writing (partial) 11101011001101100011111000100110  to  address 111101 with mask bit 0001 (from port 0) during cycle 121 (1210ns - 1220ns)
*	Reading 10110010000101001001000101101110 from address 000001 (from port 1) during cycle 121 (1210ns - 1220ns)
*	Reading 01000010011110010011101100100110 from address 111101 (from port 1) during cycle 122 (1220ns - 1230ns)
*	Writing 01001011010101111100111111010110  to  address 111101 (from port 0) during cycle 123 (1230ns - 1240ns)
*	Reading 01110111011010010010001111111010 from address 111110 (from port 1) during cycle 123 (1230ns - 1240ns)
*	Writing (partial) 00000001010010001011101011100110  to  address 000001 with mask bit 0100 (from port 0) during cycle 124 (1240ns - 1250ns)
*	Reading 01001011010101111100111111010110 from address 111101 (from port 1) during cycle 124 (1240ns - 1250ns)
*	Writing (partial) 00110001010011011111110011010010  to  address 111101 with mask bit 1011 (from port 0) during cycle 125 (1250ns - 1260ns)
*	Reading 10110010010010001001000101101110 from address 000001 (from port 1) during cycle 125 (1250ns - 1260ns)
*	Reading 00110001010101111111110011010010 from address 111101 (from port 1) during cycle 126 (1260ns - 1270ns)
*	Reading 01110111011010010010001111111010 from address 111110 (from port 0) during cycle 127 (1270ns - 1280ns)
*	Reading 00110001010101111111110011010010 from address 111101 (from port 1) during cycle 127 (1270ns - 1280ns)
*	Reading 01110111011010010010001111111010 from address 111110 (from port 0) during cycle 128 (1280ns - 1290ns)
*	Reading 10110010010010001001000101101110 from address 000001 (from port 1) during cycle 128 (1280ns - 1290ns)
*	Writing 11001001010000000101100010110110  to  address 111101 (from port 0) during cycle 129 (1290ns - 1300ns)
*	Reading 11001001010000000101100010110110 from address 111101 (from port 0) during cycle 130 (1300ns - 1310ns)
*	Reading 01110111011010010010001111111010 from address 111110 (from port 1) during cycle 130 (1300ns - 1310ns)
*	Reading 01110111011010010010001111111010 from address 111110 (from port 1) during cycle 131 (1310ns - 1320ns)
*	Writing (partial) 01001101100000111011000001001101  to  address 111110 with mask bit 0100 (from port 0) during cycle 132 (1320ns - 1330ns)
*	Reading 10110010010010001001000101101110 from address 000001 (from port 1) during cycle 132 (1320ns - 1330ns)
*	Writing (partial) 01010000111101001101000111110010  to  address 000000 with mask bit 1000 (from port 0) during cycle 133 (1330ns - 1340ns)
*	Writing 10111010101110011110110111100000  to  address 000001 (from port 0) during cycle 134 (1340ns - 1350ns)
*	Reading 11001001010000000101100010110110 from address 111101 (from port 0) during cycle 135 (1350ns - 1360ns)
*	Reading 11001001010000000101100010110110 from address 111101 (from port 1) during cycle 136 (1360ns - 1370ns)
*	Reading 01110111100000110010001111111010 from address 111110 (from port 0) during cycle 137 (1370ns - 1380ns)
*	Reading 11001001010000000101100010110110 from address 111101 (from port 1) during cycle 137 (1370ns - 1380ns)
*	Writing 00001111000100110101010101110100  to  address 000000 (from port 0) during cycle 138 (1380ns - 1390ns)
*	Writing (partial) 01000111001011110011100010000000  to  address 111110 with mask bit 0100 (from port 0) during cycle 139 (1390ns - 1400ns)
*	Reading 00001111000100110101010101110100 from address 000000 (from port 0) during cycle 140 (1400ns - 1410ns)
*	Reading 11001001010000000101100010110110 from address 111101 (from port 0) during cycle 141 (1410ns - 1420ns)
*	Reading 01110111001011110010001111111010 from address 111110 (from port 1) during cycle 141 (1410ns - 1420ns)
*	Writing 10110001001101101111001010011111  to  address 111110 (from port 0) during cycle 142 (1420ns - 1430ns)
*	Reading 10111010101110011110110111100000 from address 000001 (from port 1) during cycle 142 (1420ns - 1430ns)
*	Writing (partial) 11001101010111011001100100101001  to  address 111110 with mask bit 1101 (from port 0) during cycle 144 (1440ns - 1450ns)
*	Reading 00001111000100110101010101110100 from address 000000 (from port 0) during cycle 145 (1450ns - 1460ns)
*	Reading 11001001010000000101100010110110 from address 111101 (from port 0) during cycle 146 (1460ns - 1470ns)
*	Reading 00001111000100110101010101110100 from address 000000 (from port 1) during cycle 147 (1470ns - 1480ns)
*	Reading 11001101010111011111001000101001 from address 111110 (from port 0) during cycle 148 (1480ns - 1490ns)
*	Reading 11001001010000000101100010110110 from address 111101 (from port 0) during cycle 149 (1490ns - 1500ns)
*	Reading 11001101010111011111001000101001 from address 111110 (from port 0) during cycle 150 (1500ns - 1510ns)
*	Reading 11001001010000000101100010110110 from address 111101 (from port 0) during cycle 151 (1510ns - 1520ns)
*	Reading 00001111000100110101010101110100 from address 000000 (from port 0) during cycle 153 (1530ns - 1540ns)
*	Reading 11001001010000000101100010110110 from address 111101 (from port 1) during cycle 153 (1530ns - 1540ns)
*	Reading 10111010101110011110110111100000 from address 000001 (from port 1) during cycle 154 (1540ns - 1550ns)
*	Writing (partial) 01111100011010011000001111100100  to  address 000000 with mask bit 0011 (from port 0) during cycle 155 (1550ns - 1560ns)
*	Writing (partial) 01100101110111000011111101011100  to  address 111110 with mask bit 1001 (from port 0) during cycle 156 (1560ns - 1570ns)
*	Reading 01100101010111011111001001011100 from address 111110 (from port 0) during cycle 157 (1570ns - 1580ns)
*	Reading 11001001010000000101100010110110 from address 111101 (from port 1) during cycle 157 (1570ns - 1580ns)
*	Writing (partial) 00100101101000111001001000010111  to  address 000000 with mask bit 1010 (from port 0) during cycle 158 (1580ns - 1590ns)
*	Reading 01100101010111011111001001011100 from address 111110 (from port 0) during cycle 159 (1590ns - 1600ns)
*	Writing 10101011010100001001001011101010  to  address 000000 (from port 0) during cycle 160 (1600ns - 1610ns)
*	Writing (partial) 10111111010001010001101011010100  to  address 111110 with mask bit 1100 (from port 0) during cycle 161 (1610ns - 1620ns)
*	Reading 10111010101110011110110111100000 from address 000001 (from port 0) during cycle 162 (1620ns - 1630ns)
*	Reading 11001001010000000101100010110110 from address 111101 (from port 1) during cycle 162 (1620ns - 1630ns)
*	Reading 10101011010100001001001011101010 from address 000000 (from port 0) during cycle 163 (1630ns - 1640ns)
*	Reading 10111111010001011111001001011100 from address 111110 (from port 0) during cycle 165 (1650ns - 1660ns)
*	Reading 11001001010000000101100010110110 from address 111101 (from port 1) during cycle 165 (1650ns - 1660ns)
*	Writing (partial) 11101000000101001110100101010110  to  address 111110 with mask bit 1000 (from port 0) during cycle 166 (1660ns - 1670ns)
*	Reading 10111010101110011110110111100000 from address 000001 (from port 1) during cycle 166 (1660ns - 1670ns)
*	Reading 11101000010001011111001001011100 from address 111110 (from port 0) during cycle 167 (1670ns - 1680ns)
*	Writing 01111001101001000011001010011011  to  address 111110 (from port 0) during cycle 168 (1680ns - 1690ns)
*	Writing 00110001101100011000101100010101  to  address 111101 (from port 0) during cycle 169 (1690ns - 1700ns)
*	Reading 01111001101001000011001010011011 from address 111110 (from port 0) during cycle 170 (1700ns - 1710ns)
*	Reading 00110001101100011000101100010101 from address 111101 (from port 1) during cycle 170 (1700ns - 1710ns)
*	Writing 10100100011001111111101001101100  to  address 000000 (from port 0) during cycle 172 (1720ns - 1730ns)
*	Writing (partial) 00100100000111011001001010110010  to  address 111101 with mask bit 1001 (from port 0) during cycle 173 (1730ns - 1740ns)
*	Reading 10100100011001111111101001101100 from address 000000 (from port 1) during cycle 173 (1730ns - 1740ns)
*	Writing (partial) 10011101111011100000000111110000  to  address 000000 with mask bit 1100 (from port 0) during cycle 174 (1740ns - 1750ns)
*	Reading 10011101111011101111101001101100 from address 000000 (from port 0) during cycle 175 (1750ns - 1760ns)
*	Reading 01111001101001000011001010011011 from address 111110 (from port 1) during cycle 175 (1750ns - 1760ns)
*	Writing 01000101010100100100101111111011  to  address 111110 (from port 0) during cycle 176 (1760ns - 1770ns)
*	Reading 10111010101110011110110111100000 from address 000001 (from port 1) during cycle 177 (1770ns - 1780ns)
*	Reading 10111010101110011110110111100000 from address 000001 (from port 1) during cycle 178 (1780ns - 1790ns)
*	Reading 01000101010100100100101111111011 from address 111110 (from port 1) during cycle 179 (1790ns - 1800ns)
*	Reading 10011101111011101111101001101100 from address 000000 (from port 0) during cycle 180 (1800ns - 1810ns)
*	Reading 10111010101110011110110111100000 from address 000001 (from port 1) during cycle 180 (1800ns - 1810ns)
*	Writing (partial) 10111101010100011101011110001100  to  address 000000 with mask bit 0010 (from port 0) during cycle 181 (1810ns - 1820ns)
*	Reading 10111010101110011110110111100000 from address 000001 (from port 1) during cycle 181 (1810ns - 1820ns)
*	Reading 10111010101110011110110111100000 from address 000001 (from port 0) during cycle 182 (1820ns - 1830ns)
*	Reading 01000101010100100100101111111011 from address 111110 (from port 1) during cycle 182 (1820ns - 1830ns)
*	Reading 10111010101110011110110111100000 from address 000001 (from port 1) during cycle 183 (1830ns - 1840ns)
*	Writing (partial) 00000101000000111001111010011011  to  address 111101 with mask bit 1000 (from port 0) during cycle 184 (1840ns - 1850ns)
*	Writing (partial) 11111000011000001101100111111101  to  address 000001 with mask bit 1011 (from port 0) during cycle 185 (1850ns - 1860ns)
*	Reading 01000101010100100100101111111011 from address 111110 (from port 1) during cycle 185 (1850ns - 1860ns)
*	Writing 11010111001011000111000010010100  to  address 111110 (from port 0) during cycle 186 (1860ns - 1870ns)
*	Reading 11010111001011000111000010010100 from address 111110 (from port 1) during cycle 188 (1880ns - 1890ns)
*	Reading 11111000101110011101100111111101 from address 000001 (from port 0) during cycle 189 (1890ns - 1900ns)
*	Reading 10011101111011101101011101101100 from address 000000 (from port 1) during cycle 189 (1890ns - 1900ns)
*	Reading 11010111001011000111000010010100 from address 111110 (from port 0) during cycle 190 (1900ns - 1910ns)
*	Reading 10011101111011101101011101101100 from address 000000 (from port 1) during cycle 190 (1900ns - 1910ns)
*	Reading 10011101111011101101011101101100 from address 000000 (from port 0) during cycle 192 (1920ns - 1930ns)
*	Reading 11111000101110011101100111111101 from address 000001 (from port 1) during cycle 192 (1920ns - 1930ns)
*	Reading 00000101101100011000101110110010 from address 111101 (from port 0) during cycle 194 (1940ns - 1950ns)
*	Writing (partial) 00110000111100111101011010000000  to  address 111110 with mask bit 0100 (from port 0) during cycle 195 (1950ns - 1960ns)
*	Reading 11111000101110011101100111111101 from address 000001 (from port 1) during cycle 195 (1950ns - 1960ns)
*	Writing 11010100101111001100011010001001  to  address 000001 (from port 0) during cycle 196 (1960ns - 1970ns)
*	Writing (partial) 00001100101110000110011110011111  to  address 000000 with mask bit 0100 (from port 0) during cycle 197 (1970ns - 1980ns)
*	Reading 11010100101111001100011010001001 from address 000001 (from port 1) during cycle 198 (1980ns - 1990ns)
*	Writing (partial) 01100011010101001110110111110011  to  address 000001 with mask bit 0111 (from port 0) during cycle 199 (1990ns - 2000ns)
*	Reading 00000101101100011000101110110010 from address 111101 (from port 0) during cycle 200 (2000ns - 2010ns)
*	Reading 11010111111100110111000010010100 from address 111110 (from port 0) during cycle 201 (2010ns - 2020ns)
*	Reading 00000101101100011000101110110010 from address 111101 (from port 0) during cycle 202 (2020ns - 2030ns)
*	Reading 10011101101110001101011101101100 from address 000000 (from port 1) during cycle 202 (2020ns - 2030ns)
*	Reading 11010111111100110111000010010100 from address 111110 (from port 0) during cycle 203 (2030ns - 2040ns)
*	Reading 00000101101100011000101110110010 from address 111101 (from port 0) during cycle 204 (2040ns - 2050ns)
*	Reading 11010100010101001110110111110011 from address 000001 (from port 1) during cycle 204 (2040ns - 2050ns)
*	Idle during cycle 205 (2050ns - 2060ns)

* Generation of data and address signals
* (time, data): [(0, 0), (10, 1), (20, 0), (30, 0), (40, 0), (50, 0), (60, 1), (70, 0), (80, 0), (90, 0), (100, 0), (110, 1), (120, 1), (130, 1), (140, 1), (150, 1), (160, 0), (170, 0), (180, 0), (190, 0), (200, 0), (210, 0), (220, 0), (230, 0), (240, 1), (250, 1), (260, 1), (270, 1), (280, 1), (290, 1), (300, 1), (310, 1), (320, 1), (330, 1), (340, 1), (350, 1), (360, 1), (370, 0), (380, 0), (390, 0), (400, 0), (410, 0), (420, 0), (430, 0), (440, 0), (450, 0), (460, 0), (470, 0), (480, 0), (490, 0), (500, 1), (510, 0), (520, 0), (530, 0), (540, 0), (550, 1), (560, 1), (570, 1), (580, 1), (590, 0), (600, 0), (610, 0), (620, 0), (630, 0), (640, 0), (650, 0), (660, 0), (670, 0), (680, 0), (690, 0), (700, 0), (710, 0), (720, 0), (730, 0), (740, 0), (750, 0), (760, 0), (770, 1), (780, 0), (790, 0), (800, 0), (810, 1), (820, 1), (830, 0), (840, 0), (850, 0), (860, 0), (870, 0), (880, 0), (890, 0), (900, 0), (910, 0), (920, 0), (930, 0), (940, 0), (950, 1), (960, 1), (970, 1), (980, 0), (990, 1), (1000, 1), (1010, 1), (1020, 1), (1030, 0), (1040, 0), (1050, 0), (1060, 0), (1070, 0), (1080, 0), (1090, 0), (1100, 0), (1110, 1), (1120, 1), (1130, 1), (1140, 1), (1150, 0), (1160, 0), (1170, 0), (1180, 0), (1190, 0), (1200, 0), (1210, 0), (1220, 0), (1230, 0), (1240, 0), (1250, 0), (1260, 0), (1270, 0), (1280, 0), (1290, 0), (1300, 0), (1310, 0), (1320, 1), (1330, 0), (1340, 0), (1350, 0), (1360, 0), (1370, 0), (1380, 0), (1390, 0), (1400, 0), (1410, 0), (1420, 1), (1430, 1), (1440, 1), (1450, 1), (1460, 1), (1470, 1), (1480, 1), (1490, 1), (1500, 1), (1510, 1), (1520, 1), (1530, 1), (1540, 1), (1550, 0), (1560, 0), (1570, 0), (1580, 1), (1590, 1), (1600, 0), (1610, 0), (1620, 0), (1630, 0), (1640, 0), (1650, 0), (1660, 0), (1670, 0), (1680, 1), (1690, 1), (1700, 1), (1710, 1), (1720, 0), (1730, 0), (1740, 0), (1750, 0), (1760, 1), (1770, 1), (1780, 1), (1790, 1), (1800, 1), (1810, 0), (1820, 0), (1830, 0), (1840, 1), (1850, 1), (1860, 0), (1870, 0), (1880, 0), (1890, 0), (1900, 0), (1910, 0), (1920, 0), (1930, 0), (1940, 0), (1950, 0), (1960, 1), (1970, 1), (1980, 1), (1990, 1), (2000, 1), (2010, 1), (2020, 1), (2030, 1), (2040, 1), (2050, 1)]
Vdin0_0  din0_0  0 PWL (0n 0.0v 9.495n 0.0v 9.505n 1.95v 19.495n 1.95v 19.505n 0.0v 29.495n 0.0v 29.505n 0.0v 39.495n 0.0v 39.505n 0.0v 49.495n 0.0v 49.505n 0.0v 59.495n 0.0v 59.505n 1.95v 69.495n 1.95v 69.505n 0.0v 79.495n 0.0v 79.505n 0.0v 89.495n 0.0v 89.505n 0.0v 99.495n 0.0v 99.505n 0.0v 109.495n 0.0v 109.505n 1.95v 119.495n 1.95v 119.505n 1.95v 129.495n 1.95v 129.505n 1.95v 139.495n 1.95v 139.505n 1.95v 149.495n 1.95v 149.505n 1.95v 159.495n 1.95v 159.505n 0.0v 169.495n 0.0v 169.505n 0.0v 179.495n 0.0v 179.505n 0.0v 189.495n 0.0v 189.505n 0.0v 199.495n 0.0v 199.505n 0.0v 209.495n 0.0v 209.505n 0.0v 219.495n 0.0v 219.505n 0.0v 229.495n 0.0v 229.505n 0.0v 239.495n 0.0v 239.505n 1.95v 249.495n 1.95v 249.505n 1.95v 259.495n 1.95v 259.505n 1.95v 269.495n 1.95v 269.505n 1.95v 279.495n 1.95v 279.505n 1.95v 289.495n 1.95v 289.505n 1.95v 299.495n 1.95v 299.505n 1.95v 309.495n 1.95v 309.505n 1.95v 319.495n 1.95v 319.505n 1.95v 329.495n 1.95v 329.505n 1.95v 339.495n 1.95v 339.505n 1.95v 349.495n 1.95v 349.505n 1.95v 359.495n 1.95v 359.505n 1.95v 369.495n 1.95v 369.505n 0.0v 379.495n 0.0v 379.505n 0.0v 389.495n 0.0v 389.505n 0.0v 399.495n 0.0v 399.505n 0.0v 409.495n 0.0v 409.505n 0.0v 419.495n 0.0v 419.505n 0.0v 429.495n 0.0v 429.505n 0.0v 439.495n 0.0v 439.505n 0.0v 449.495n 0.0v 449.505n 0.0v 459.495n 0.0v 459.505n 0.0v 469.495n 0.0v 469.505n 0.0v 479.495n 0.0v 479.505n 0.0v 489.495n 0.0v 489.505n 0.0v 499.495n 0.0v 499.505n 1.95v 509.495n 1.95v 509.505n 0.0v 519.495n 0.0v 519.505n 0.0v 529.495n 0.0v 529.505n 0.0v 539.495n 0.0v 539.505n 0.0v 549.495n 0.0v 549.505n 1.95v 559.495n 1.95v 559.505n 1.95v 569.495n 1.95v 569.505n 1.95v 579.495n 1.95v 579.505n 1.95v 589.495n 1.95v 589.505n 0.0v 599.495n 0.0v 599.505n 0.0v 609.495n 0.0v 609.505n 0.0v 619.495n 0.0v 619.505n 0.0v 629.495n 0.0v 629.505n 0.0v 639.495n 0.0v 639.505n 0.0v 649.495n 0.0v 649.505n 0.0v 659.495n 0.0v 659.505n 0.0v 669.495n 0.0v 669.505n 0.0v 679.495n 0.0v 679.505n 0.0v 689.495n 0.0v 689.505n 0.0v 699.495n 0.0v 699.505n 0.0v 709.495n 0.0v 709.505n 0.0v 719.495n 0.0v 719.505n 0.0v 729.495n 0.0v 729.505n 0.0v 739.495n 0.0v 739.505n 0.0v 749.495n 0.0v 749.505n 0.0v 759.495n 0.0v 759.505n 0.0v 769.495n 0.0v 769.505n 1.95v 779.495n 1.95v 779.505n 0.0v 789.495n 0.0v 789.505n 0.0v 799.495n 0.0v 799.505n 0.0v 809.495n 0.0v 809.505n 1.95v 819.495n 1.95v 819.505n 1.95v 829.495n 1.95v 829.505n 0.0v 839.495n 0.0v 839.505n 0.0v 849.495n 0.0v 849.505n 0.0v 859.495n 0.0v 859.505n 0.0v 869.495n 0.0v 869.505n 0.0v 879.495n 0.0v 879.505n 0.0v 889.495n 0.0v 889.505n 0.0v 899.495n 0.0v 899.505n 0.0v 909.495n 0.0v 909.505n 0.0v 919.495n 0.0v 919.505n 0.0v 929.495n 0.0v 929.505n 0.0v 939.495n 0.0v 939.505n 0.0v 949.495n 0.0v 949.505n 1.95v 959.495n 1.95v 959.505n 1.95v 969.495n 1.95v 969.505n 1.95v 979.495n 1.95v 979.505n 0.0v 989.495n 0.0v 989.505n 1.95v 999.495n 1.95v 999.505n 1.95v 1009.495n 1.95v 1009.505n 1.95v 1019.495n 1.95v 1019.505n 1.95v 1029.495n 1.95v 1029.505n 0.0v 1039.495n 0.0v 1039.505n 0.0v 1049.495n 0.0v 1049.505n 0.0v 1059.495n 0.0v 1059.505n 0.0v 1069.495n 0.0v 1069.505n 0.0v 1079.495n 0.0v 1079.505n 0.0v 1089.495n 0.0v 1089.505n 0.0v 1099.495n 0.0v 1099.505n 0.0v 1109.495n 0.0v 1109.505n 1.95v 1119.495n 1.95v 1119.505n 1.95v 1129.495n 1.95v 1129.505n 1.95v 1139.495n 1.95v 1139.505n 1.95v 1149.495n 1.95v 1149.505n 0.0v 1159.495n 0.0v 1159.505n 0.0v 1169.495n 0.0v 1169.505n 0.0v 1179.495n 0.0v 1179.505n 0.0v 1189.495n 0.0v 1189.505n 0.0v 1199.495n 0.0v 1199.505n 0.0v 1209.495n 0.0v 1209.505n 0.0v 1219.495n 0.0v 1219.505n 0.0v 1229.495n 0.0v 1229.505n 0.0v 1239.495n 0.0v 1239.505n 0.0v 1249.495n 0.0v 1249.505n 0.0v 1259.495n 0.0v 1259.505n 0.0v 1269.495n 0.0v 1269.505n 0.0v 1279.495n 0.0v 1279.505n 0.0v 1289.495n 0.0v 1289.505n 0.0v 1299.495n 0.0v 1299.505n 0.0v 1309.495n 0.0v 1309.505n 0.0v 1319.495n 0.0v 1319.505n 1.95v 1329.495n 1.95v 1329.505n 0.0v 1339.495n 0.0v 1339.505n 0.0v 1349.495n 0.0v 1349.505n 0.0v 1359.495n 0.0v 1359.505n 0.0v 1369.495n 0.0v 1369.505n 0.0v 1379.495n 0.0v 1379.505n 0.0v 1389.495n 0.0v 1389.505n 0.0v 1399.495n 0.0v 1399.505n 0.0v 1409.495n 0.0v 1409.505n 0.0v 1419.495n 0.0v 1419.505n 1.95v 1429.495n 1.95v 1429.505n 1.95v 1439.495n 1.95v 1439.505n 1.95v 1449.495n 1.95v 1449.505n 1.95v 1459.495n 1.95v 1459.505n 1.95v 1469.495n 1.95v 1469.505n 1.95v 1479.495n 1.95v 1479.505n 1.95v 1489.495n 1.95v 1489.505n 1.95v 1499.495n 1.95v 1499.505n 1.95v 1509.495n 1.95v 1509.505n 1.95v 1519.495n 1.95v 1519.505n 1.95v 1529.495n 1.95v 1529.505n 1.95v 1539.495n 1.95v 1539.505n 1.95v 1549.495n 1.95v 1549.505n 0.0v 1559.495n 0.0v 1559.505n 0.0v 1569.495n 0.0v 1569.505n 0.0v 1579.495n 0.0v 1579.505n 1.95v 1589.495n 1.95v 1589.505n 1.95v 1599.495n 1.95v 1599.505n 0.0v 1609.495n 0.0v 1609.505n 0.0v 1619.495n 0.0v 1619.505n 0.0v 1629.495n 0.0v 1629.505n 0.0v 1639.495n 0.0v 1639.505n 0.0v 1649.495n 0.0v 1649.505n 0.0v 1659.495n 0.0v 1659.505n 0.0v 1669.495n 0.0v 1669.505n 0.0v 1679.495n 0.0v 1679.505n 1.95v 1689.495n 1.95v 1689.505n 1.95v 1699.495n 1.95v 1699.505n 1.95v 1709.495n 1.95v 1709.505n 1.95v 1719.495n 1.95v 1719.505n 0.0v 1729.495n 0.0v 1729.505n 0.0v 1739.495n 0.0v 1739.505n 0.0v 1749.495n 0.0v 1749.505n 0.0v 1759.495n 0.0v 1759.505n 1.95v 1769.495n 1.95v 1769.505n 1.95v 1779.495n 1.95v 1779.505n 1.95v 1789.495n 1.95v 1789.505n 1.95v 1799.495n 1.95v 1799.505n 1.95v 1809.495n 1.95v 1809.505n 0.0v 1819.495n 0.0v 1819.505n 0.0v 1829.495n 0.0v 1829.505n 0.0v 1839.495n 0.0v 1839.505n 1.95v 1849.495n 1.95v 1849.505n 1.95v 1859.495n 1.95v 1859.505n 0.0v 1869.495n 0.0v 1869.505n 0.0v 1879.495n 0.0v 1879.505n 0.0v 1889.495n 0.0v 1889.505n 0.0v 1899.495n 0.0v 1899.505n 0.0v 1909.495n 0.0v 1909.505n 0.0v 1919.495n 0.0v 1919.505n 0.0v 1929.495n 0.0v 1929.505n 0.0v 1939.495n 0.0v 1939.505n 0.0v 1949.495n 0.0v 1949.505n 0.0v 1959.495n 0.0v 1959.505n 1.95v 1969.495n 1.95v 1969.505n 1.95v 1979.495n 1.95v 1979.505n 1.95v 1989.495n 1.95v 1989.505n 1.95v 1999.495n 1.95v 1999.505n 1.95v 2009.495n 1.95v 2009.505n 1.95v 2019.495n 1.95v 2019.505n 1.95v 2029.495n 1.95v 2029.505n 1.95v 2039.495n 1.95v 2039.505n 1.95v 2049.495n 1.95v 2049.505n 1.95v )
* (time, data): [(0, 0), (10, 1), (20, 1), (30, 0), (40, 0), (50, 0), (60, 0), (70, 0), (80, 1), (90, 1), (100, 1), (110, 0), (120, 0), (130, 0), (140, 0), (150, 0), (160, 0), (170, 0), (180, 0), (190, 0), (200, 0), (210, 0), (220, 0), (230, 0), (240, 1), (250, 1), (260, 1), (270, 0), (280, 0), (290, 0), (300, 1), (310, 1), (320, 1), (330, 1), (340, 1), (350, 1), (360, 1), (370, 0), (380, 0), (390, 0), (400, 0), (410, 0), (420, 0), (430, 0), (440, 0), (450, 0), (460, 0), (470, 0), (480, 0), (490, 0), (500, 0), (510, 1), (520, 1), (530, 1), (540, 0), (550, 1), (560, 1), (570, 1), (580, 1), (590, 0), (600, 0), (610, 0), (620, 0), (630, 0), (640, 1), (650, 1), (660, 1), (670, 1), (680, 1), (690, 1), (700, 0), (710, 0), (720, 0), (730, 1), (740, 1), (750, 1), (760, 1), (770, 0), (780, 0), (790, 1), (800, 1), (810, 1), (820, 1), (830, 1), (840, 1), (850, 0), (860, 0), (870, 0), (880, 0), (890, 0), (900, 0), (910, 0), (920, 0), (930, 0), (940, 0), (950, 0), (960, 0), (970, 1), (980, 1), (990, 1), (1000, 1), (1010, 1), (1020, 1), (1030, 1), (1040, 1), (1050, 0), (1060, 0), (1070, 0), (1080, 0), (1090, 0), (1100, 0), (1110, 1), (1120, 1), (1130, 1), (1140, 1), (1150, 1), (1160, 1), (1170, 1), (1180, 1), (1190, 1), (1200, 1), (1210, 1), (1220, 1), (1230, 1), (1240, 1), (1250, 1), (1260, 1), (1270, 1), (1280, 1), (1290, 1), (1300, 1), (1310, 1), (1320, 0), (1330, 1), (1340, 0), (1350, 0), (1360, 0), (1370, 0), (1380, 0), (1390, 0), (1400, 0), (1410, 0), (1420, 1), (1430, 1), (1440, 0), (1450, 0), (1460, 0), (1470, 0), (1480, 0), (1490, 0), (1500, 0), (1510, 0), (1520, 0), (1530, 0), (1540, 0), (1550, 0), (1560, 0), (1570, 0), (1580, 1), (1590, 1), (1600, 1), (1610, 0), (1620, 0), (1630, 0), (1640, 0), (1650, 0), (1660, 1), (1670, 1), (1680, 1), (1690, 0), (1700, 0), (1710, 0), (1720, 0), (1730, 1), (1740, 0), (1750, 0), (1760, 1), (1770, 1), (1780, 1), (1790, 1), (1800, 1), (1810, 0), (1820, 0), (1830, 0), (1840, 1), (1850, 0), (1860, 0), (1870, 0), (1880, 0), (1890, 0), (1900, 0), (1910, 0), (1920, 0), (1930, 0), (1940, 0), (1950, 0), (1960, 0), (1970, 1), (1980, 1), (1990, 1), (2000, 1), (2010, 1), (2020, 1), (2030, 1), (2040, 1), (2050, 1)]
Vdin0_1  din0_1  0 PWL (0n 0.0v 9.495n 0.0v 9.505n 1.95v 19.495n 1.95v 19.505n 1.95v 29.495n 1.95v 29.505n 0.0v 39.495n 0.0v 39.505n 0.0v 49.495n 0.0v 49.505n 0.0v 59.495n 0.0v 59.505n 0.0v 69.495n 0.0v 69.505n 0.0v 79.495n 0.0v 79.505n 1.95v 89.495n 1.95v 89.505n 1.95v 99.495n 1.95v 99.505n 1.95v 109.495n 1.95v 109.505n 0.0v 119.495n 0.0v 119.505n 0.0v 129.495n 0.0v 129.505n 0.0v 139.495n 0.0v 139.505n 0.0v 149.495n 0.0v 149.505n 0.0v 159.495n 0.0v 159.505n 0.0v 169.495n 0.0v 169.505n 0.0v 179.495n 0.0v 179.505n 0.0v 189.495n 0.0v 189.505n 0.0v 199.495n 0.0v 199.505n 0.0v 209.495n 0.0v 209.505n 0.0v 219.495n 0.0v 219.505n 0.0v 229.495n 0.0v 229.505n 0.0v 239.495n 0.0v 239.505n 1.95v 249.495n 1.95v 249.505n 1.95v 259.495n 1.95v 259.505n 1.95v 269.495n 1.95v 269.505n 0.0v 279.495n 0.0v 279.505n 0.0v 289.495n 0.0v 289.505n 0.0v 299.495n 0.0v 299.505n 1.95v 309.495n 1.95v 309.505n 1.95v 319.495n 1.95v 319.505n 1.95v 329.495n 1.95v 329.505n 1.95v 339.495n 1.95v 339.505n 1.95v 349.495n 1.95v 349.505n 1.95v 359.495n 1.95v 359.505n 1.95v 369.495n 1.95v 369.505n 0.0v 379.495n 0.0v 379.505n 0.0v 389.495n 0.0v 389.505n 0.0v 399.495n 0.0v 399.505n 0.0v 409.495n 0.0v 409.505n 0.0v 419.495n 0.0v 419.505n 0.0v 429.495n 0.0v 429.505n 0.0v 439.495n 0.0v 439.505n 0.0v 449.495n 0.0v 449.505n 0.0v 459.495n 0.0v 459.505n 0.0v 469.495n 0.0v 469.505n 0.0v 479.495n 0.0v 479.505n 0.0v 489.495n 0.0v 489.505n 0.0v 499.495n 0.0v 499.505n 0.0v 509.495n 0.0v 509.505n 1.95v 519.495n 1.95v 519.505n 1.95v 529.495n 1.95v 529.505n 1.95v 539.495n 1.95v 539.505n 0.0v 549.495n 0.0v 549.505n 1.95v 559.495n 1.95v 559.505n 1.95v 569.495n 1.95v 569.505n 1.95v 579.495n 1.95v 579.505n 1.95v 589.495n 1.95v 589.505n 0.0v 599.495n 0.0v 599.505n 0.0v 609.495n 0.0v 609.505n 0.0v 619.495n 0.0v 619.505n 0.0v 629.495n 0.0v 629.505n 0.0v 639.495n 0.0v 639.505n 1.95v 649.495n 1.95v 649.505n 1.95v 659.495n 1.95v 659.505n 1.95v 669.495n 1.95v 669.505n 1.95v 679.495n 1.95v 679.505n 1.95v 689.495n 1.95v 689.505n 1.95v 699.495n 1.95v 699.505n 0.0v 709.495n 0.0v 709.505n 0.0v 719.495n 0.0v 719.505n 0.0v 729.495n 0.0v 729.505n 1.95v 739.495n 1.95v 739.505n 1.95v 749.495n 1.95v 749.505n 1.95v 759.495n 1.95v 759.505n 1.95v 769.495n 1.95v 769.505n 0.0v 779.495n 0.0v 779.505n 0.0v 789.495n 0.0v 789.505n 1.95v 799.495n 1.95v 799.505n 1.95v 809.495n 1.95v 809.505n 1.95v 819.495n 1.95v 819.505n 1.95v 829.495n 1.95v 829.505n 1.95v 839.495n 1.95v 839.505n 1.95v 849.495n 1.95v 849.505n 0.0v 859.495n 0.0v 859.505n 0.0v 869.495n 0.0v 869.505n 0.0v 879.495n 0.0v 879.505n 0.0v 889.495n 0.0v 889.505n 0.0v 899.495n 0.0v 899.505n 0.0v 909.495n 0.0v 909.505n 0.0v 919.495n 0.0v 919.505n 0.0v 929.495n 0.0v 929.505n 0.0v 939.495n 0.0v 939.505n 0.0v 949.495n 0.0v 949.505n 0.0v 959.495n 0.0v 959.505n 0.0v 969.495n 0.0v 969.505n 1.95v 979.495n 1.95v 979.505n 1.95v 989.495n 1.95v 989.505n 1.95v 999.495n 1.95v 999.505n 1.95v 1009.495n 1.95v 1009.505n 1.95v 1019.495n 1.95v 1019.505n 1.95v 1029.495n 1.95v 1029.505n 1.95v 1039.495n 1.95v 1039.505n 1.95v 1049.495n 1.95v 1049.505n 0.0v 1059.495n 0.0v 1059.505n 0.0v 1069.495n 0.0v 1069.505n 0.0v 1079.495n 0.0v 1079.505n 0.0v 1089.495n 0.0v 1089.505n 0.0v 1099.495n 0.0v 1099.505n 0.0v 1109.495n 0.0v 1109.505n 1.95v 1119.495n 1.95v 1119.505n 1.95v 1129.495n 1.95v 1129.505n 1.95v 1139.495n 1.95v 1139.505n 1.95v 1149.495n 1.95v 1149.505n 1.95v 1159.495n 1.95v 1159.505n 1.95v 1169.495n 1.95v 1169.505n 1.95v 1179.495n 1.95v 1179.505n 1.95v 1189.495n 1.95v 1189.505n 1.95v 1199.495n 1.95v 1199.505n 1.95v 1209.495n 1.95v 1209.505n 1.95v 1219.495n 1.95v 1219.505n 1.95v 1229.495n 1.95v 1229.505n 1.95v 1239.495n 1.95v 1239.505n 1.95v 1249.495n 1.95v 1249.505n 1.95v 1259.495n 1.95v 1259.505n 1.95v 1269.495n 1.95v 1269.505n 1.95v 1279.495n 1.95v 1279.505n 1.95v 1289.495n 1.95v 1289.505n 1.95v 1299.495n 1.95v 1299.505n 1.95v 1309.495n 1.95v 1309.505n 1.95v 1319.495n 1.95v 1319.505n 0.0v 1329.495n 0.0v 1329.505n 1.95v 1339.495n 1.95v 1339.505n 0.0v 1349.495n 0.0v 1349.505n 0.0v 1359.495n 0.0v 1359.505n 0.0v 1369.495n 0.0v 1369.505n 0.0v 1379.495n 0.0v 1379.505n 0.0v 1389.495n 0.0v 1389.505n 0.0v 1399.495n 0.0v 1399.505n 0.0v 1409.495n 0.0v 1409.505n 0.0v 1419.495n 0.0v 1419.505n 1.95v 1429.495n 1.95v 1429.505n 1.95v 1439.495n 1.95v 1439.505n 0.0v 1449.495n 0.0v 1449.505n 0.0v 1459.495n 0.0v 1459.505n 0.0v 1469.495n 0.0v 1469.505n 0.0v 1479.495n 0.0v 1479.505n 0.0v 1489.495n 0.0v 1489.505n 0.0v 1499.495n 0.0v 1499.505n 0.0v 1509.495n 0.0v 1509.505n 0.0v 1519.495n 0.0v 1519.505n 0.0v 1529.495n 0.0v 1529.505n 0.0v 1539.495n 0.0v 1539.505n 0.0v 1549.495n 0.0v 1549.505n 0.0v 1559.495n 0.0v 1559.505n 0.0v 1569.495n 0.0v 1569.505n 0.0v 1579.495n 0.0v 1579.505n 1.95v 1589.495n 1.95v 1589.505n 1.95v 1599.495n 1.95v 1599.505n 1.95v 1609.495n 1.95v 1609.505n 0.0v 1619.495n 0.0v 1619.505n 0.0v 1629.495n 0.0v 1629.505n 0.0v 1639.495n 0.0v 1639.505n 0.0v 1649.495n 0.0v 1649.505n 0.0v 1659.495n 0.0v 1659.505n 1.95v 1669.495n 1.95v 1669.505n 1.95v 1679.495n 1.95v 1679.505n 1.95v 1689.495n 1.95v 1689.505n 0.0v 1699.495n 0.0v 1699.505n 0.0v 1709.495n 0.0v 1709.505n 0.0v 1719.495n 0.0v 1719.505n 0.0v 1729.495n 0.0v 1729.505n 1.95v 1739.495n 1.95v 1739.505n 0.0v 1749.495n 0.0v 1749.505n 0.0v 1759.495n 0.0v 1759.505n 1.95v 1769.495n 1.95v 1769.505n 1.95v 1779.495n 1.95v 1779.505n 1.95v 1789.495n 1.95v 1789.505n 1.95v 1799.495n 1.95v 1799.505n 1.95v 1809.495n 1.95v 1809.505n 0.0v 1819.495n 0.0v 1819.505n 0.0v 1829.495n 0.0v 1829.505n 0.0v 1839.495n 0.0v 1839.505n 1.95v 1849.495n 1.95v 1849.505n 0.0v 1859.495n 0.0v 1859.505n 0.0v 1869.495n 0.0v 1869.505n 0.0v 1879.495n 0.0v 1879.505n 0.0v 1889.495n 0.0v 1889.505n 0.0v 1899.495n 0.0v 1899.505n 0.0v 1909.495n 0.0v 1909.505n 0.0v 1919.495n 0.0v 1919.505n 0.0v 1929.495n 0.0v 1929.505n 0.0v 1939.495n 0.0v 1939.505n 0.0v 1949.495n 0.0v 1949.505n 0.0v 1959.495n 0.0v 1959.505n 0.0v 1969.495n 0.0v 1969.505n 1.95v 1979.495n 1.95v 1979.505n 1.95v 1989.495n 1.95v 1989.505n 1.95v 1999.495n 1.95v 1999.505n 1.95v 2009.495n 1.95v 2009.505n 1.95v 2019.495n 1.95v 2019.505n 1.95v 2029.495n 1.95v 2029.505n 1.95v 2039.495n 1.95v 2039.505n 1.95v 2049.495n 1.95v 2049.505n 1.95v )
* (time, data): [(0, 0), (10, 1), (20, 0), (30, 0), (40, 0), (50, 0), (60, 1), (70, 1), (80, 0), (90, 0), (100, 0), (110, 1), (120, 1), (130, 1), (140, 1), (150, 1), (160, 0), (170, 0), (180, 0), (190, 0), (200, 0), (210, 0), (220, 0), (230, 0), (240, 1), (250, 1), (260, 1), (270, 1), (280, 1), (290, 1), (300, 1), (310, 1), (320, 1), (330, 1), (340, 1), (350, 1), (360, 1), (370, 0), (380, 0), (390, 0), (400, 0), (410, 0), (420, 0), (430, 0), (440, 0), (450, 0), (460, 0), (470, 0), (480, 0), (490, 0), (500, 1), (510, 0), (520, 0), (530, 0), (540, 1), (550, 0), (560, 0), (570, 0), (580, 0), (590, 0), (600, 0), (610, 0), (620, 0), (630, 0), (640, 1), (650, 1), (660, 1), (670, 0), (680, 0), (690, 0), (700, 1), (710, 1), (720, 1), (730, 0), (740, 0), (750, 0), (760, 0), (770, 0), (780, 0), (790, 1), (800, 1), (810, 1), (820, 1), (830, 0), (840, 0), (850, 0), (860, 0), (870, 0), (880, 0), (890, 0), (900, 0), (910, 0), (920, 0), (930, 0), (940, 1), (950, 1), (960, 1), (970, 1), (980, 1), (990, 1), (1000, 1), (1010, 0), (1020, 0), (1030, 0), (1040, 0), (1050, 1), (1060, 1), (1070, 1), (1080, 1), (1090, 1), (1100, 1), (1110, 0), (1120, 0), (1130, 0), (1140, 0), (1150, 0), (1160, 0), (1170, 0), (1180, 0), (1190, 0), (1200, 0), (1210, 1), (1220, 1), (1230, 1), (1240, 1), (1250, 0), (1260, 0), (1270, 0), (1280, 0), (1290, 1), (1300, 1), (1310, 1), (1320, 1), (1330, 0), (1340, 0), (1350, 0), (1360, 0), (1370, 0), (1380, 1), (1390, 0), (1400, 0), (1410, 0), (1420, 1), (1430, 1), (1440, 0), (1450, 0), (1460, 0), (1470, 0), (1480, 0), (1490, 0), (1500, 0), (1510, 0), (1520, 0), (1530, 0), (1540, 0), (1550, 1), (1560, 1), (1570, 1), (1580, 1), (1590, 1), (1600, 0), (1610, 1), (1620, 1), (1630, 1), (1640, 1), (1650, 1), (1660, 1), (1670, 1), (1680, 0), (1690, 1), (1700, 1), (1710, 1), (1720, 1), (1730, 0), (1740, 0), (1750, 0), (1760, 0), (1770, 0), (1780, 0), (1790, 0), (1800, 0), (1810, 1), (1820, 1), (1830, 1), (1840, 0), (1850, 1), (1860, 1), (1870, 1), (1880, 1), (1890, 1), (1900, 1), (1910, 1), (1920, 1), (1930, 1), (1940, 1), (1950, 0), (1960, 0), (1970, 1), (1980, 1), (1990, 0), (2000, 0), (2010, 0), (2020, 0), (2030, 0), (2040, 0), (2050, 0)]
Vdin0_2  din0_2  0 PWL (0n 0.0v 9.495n 0.0v 9.505n 1.95v 19.495n 1.95v 19.505n 0.0v 29.495n 0.0v 29.505n 0.0v 39.495n 0.0v 39.505n 0.0v 49.495n 0.0v 49.505n 0.0v 59.495n 0.0v 59.505n 1.95v 69.495n 1.95v 69.505n 1.95v 79.495n 1.95v 79.505n 0.0v 89.495n 0.0v 89.505n 0.0v 99.495n 0.0v 99.505n 0.0v 109.495n 0.0v 109.505n 1.95v 119.495n 1.95v 119.505n 1.95v 129.495n 1.95v 129.505n 1.95v 139.495n 1.95v 139.505n 1.95v 149.495n 1.95v 149.505n 1.95v 159.495n 1.95v 159.505n 0.0v 169.495n 0.0v 169.505n 0.0v 179.495n 0.0v 179.505n 0.0v 189.495n 0.0v 189.505n 0.0v 199.495n 0.0v 199.505n 0.0v 209.495n 0.0v 209.505n 0.0v 219.495n 0.0v 219.505n 0.0v 229.495n 0.0v 229.505n 0.0v 239.495n 0.0v 239.505n 1.95v 249.495n 1.95v 249.505n 1.95v 259.495n 1.95v 259.505n 1.95v 269.495n 1.95v 269.505n 1.95v 279.495n 1.95v 279.505n 1.95v 289.495n 1.95v 289.505n 1.95v 299.495n 1.95v 299.505n 1.95v 309.495n 1.95v 309.505n 1.95v 319.495n 1.95v 319.505n 1.95v 329.495n 1.95v 329.505n 1.95v 339.495n 1.95v 339.505n 1.95v 349.495n 1.95v 349.505n 1.95v 359.495n 1.95v 359.505n 1.95v 369.495n 1.95v 369.505n 0.0v 379.495n 0.0v 379.505n 0.0v 389.495n 0.0v 389.505n 0.0v 399.495n 0.0v 399.505n 0.0v 409.495n 0.0v 409.505n 0.0v 419.495n 0.0v 419.505n 0.0v 429.495n 0.0v 429.505n 0.0v 439.495n 0.0v 439.505n 0.0v 449.495n 0.0v 449.505n 0.0v 459.495n 0.0v 459.505n 0.0v 469.495n 0.0v 469.505n 0.0v 479.495n 0.0v 479.505n 0.0v 489.495n 0.0v 489.505n 0.0v 499.495n 0.0v 499.505n 1.95v 509.495n 1.95v 509.505n 0.0v 519.495n 0.0v 519.505n 0.0v 529.495n 0.0v 529.505n 0.0v 539.495n 0.0v 539.505n 1.95v 549.495n 1.95v 549.505n 0.0v 559.495n 0.0v 559.505n 0.0v 569.495n 0.0v 569.505n 0.0v 579.495n 0.0v 579.505n 0.0v 589.495n 0.0v 589.505n 0.0v 599.495n 0.0v 599.505n 0.0v 609.495n 0.0v 609.505n 0.0v 619.495n 0.0v 619.505n 0.0v 629.495n 0.0v 629.505n 0.0v 639.495n 0.0v 639.505n 1.95v 649.495n 1.95v 649.505n 1.95v 659.495n 1.95v 659.505n 1.95v 669.495n 1.95v 669.505n 0.0v 679.495n 0.0v 679.505n 0.0v 689.495n 0.0v 689.505n 0.0v 699.495n 0.0v 699.505n 1.95v 709.495n 1.95v 709.505n 1.95v 719.495n 1.95v 719.505n 1.95v 729.495n 1.95v 729.505n 0.0v 739.495n 0.0v 739.505n 0.0v 749.495n 0.0v 749.505n 0.0v 759.495n 0.0v 759.505n 0.0v 769.495n 0.0v 769.505n 0.0v 779.495n 0.0v 779.505n 0.0v 789.495n 0.0v 789.505n 1.95v 799.495n 1.95v 799.505n 1.95v 809.495n 1.95v 809.505n 1.95v 819.495n 1.95v 819.505n 1.95v 829.495n 1.95v 829.505n 0.0v 839.495n 0.0v 839.505n 0.0v 849.495n 0.0v 849.505n 0.0v 859.495n 0.0v 859.505n 0.0v 869.495n 0.0v 869.505n 0.0v 879.495n 0.0v 879.505n 0.0v 889.495n 0.0v 889.505n 0.0v 899.495n 0.0v 899.505n 0.0v 909.495n 0.0v 909.505n 0.0v 919.495n 0.0v 919.505n 0.0v 929.495n 0.0v 929.505n 0.0v 939.495n 0.0v 939.505n 1.95v 949.495n 1.95v 949.505n 1.95v 959.495n 1.95v 959.505n 1.95v 969.495n 1.95v 969.505n 1.95v 979.495n 1.95v 979.505n 1.95v 989.495n 1.95v 989.505n 1.95v 999.495n 1.95v 999.505n 1.95v 1009.495n 1.95v 1009.505n 0.0v 1019.495n 0.0v 1019.505n 0.0v 1029.495n 0.0v 1029.505n 0.0v 1039.495n 0.0v 1039.505n 0.0v 1049.495n 0.0v 1049.505n 1.95v 1059.495n 1.95v 1059.505n 1.95v 1069.495n 1.95v 1069.505n 1.95v 1079.495n 1.95v 1079.505n 1.95v 1089.495n 1.95v 1089.505n 1.95v 1099.495n 1.95v 1099.505n 1.95v 1109.495n 1.95v 1109.505n 0.0v 1119.495n 0.0v 1119.505n 0.0v 1129.495n 0.0v 1129.505n 0.0v 1139.495n 0.0v 1139.505n 0.0v 1149.495n 0.0v 1149.505n 0.0v 1159.495n 0.0v 1159.505n 0.0v 1169.495n 0.0v 1169.505n 0.0v 1179.495n 0.0v 1179.505n 0.0v 1189.495n 0.0v 1189.505n 0.0v 1199.495n 0.0v 1199.505n 0.0v 1209.495n 0.0v 1209.505n 1.95v 1219.495n 1.95v 1219.505n 1.95v 1229.495n 1.95v 1229.505n 1.95v 1239.495n 1.95v 1239.505n 1.95v 1249.495n 1.95v 1249.505n 0.0v 1259.495n 0.0v 1259.505n 0.0v 1269.495n 0.0v 1269.505n 0.0v 1279.495n 0.0v 1279.505n 0.0v 1289.495n 0.0v 1289.505n 1.95v 1299.495n 1.95v 1299.505n 1.95v 1309.495n 1.95v 1309.505n 1.95v 1319.495n 1.95v 1319.505n 1.95v 1329.495n 1.95v 1329.505n 0.0v 1339.495n 0.0v 1339.505n 0.0v 1349.495n 0.0v 1349.505n 0.0v 1359.495n 0.0v 1359.505n 0.0v 1369.495n 0.0v 1369.505n 0.0v 1379.495n 0.0v 1379.505n 1.95v 1389.495n 1.95v 1389.505n 0.0v 1399.495n 0.0v 1399.505n 0.0v 1409.495n 0.0v 1409.505n 0.0v 1419.495n 0.0v 1419.505n 1.95v 1429.495n 1.95v 1429.505n 1.95v 1439.495n 1.95v 1439.505n 0.0v 1449.495n 0.0v 1449.505n 0.0v 1459.495n 0.0v 1459.505n 0.0v 1469.495n 0.0v 1469.505n 0.0v 1479.495n 0.0v 1479.505n 0.0v 1489.495n 0.0v 1489.505n 0.0v 1499.495n 0.0v 1499.505n 0.0v 1509.495n 0.0v 1509.505n 0.0v 1519.495n 0.0v 1519.505n 0.0v 1529.495n 0.0v 1529.505n 0.0v 1539.495n 0.0v 1539.505n 0.0v 1549.495n 0.0v 1549.505n 1.95v 1559.495n 1.95v 1559.505n 1.95v 1569.495n 1.95v 1569.505n 1.95v 1579.495n 1.95v 1579.505n 1.95v 1589.495n 1.95v 1589.505n 1.95v 1599.495n 1.95v 1599.505n 0.0v 1609.495n 0.0v 1609.505n 1.95v 1619.495n 1.95v 1619.505n 1.95v 1629.495n 1.95v 1629.505n 1.95v 1639.495n 1.95v 1639.505n 1.95v 1649.495n 1.95v 1649.505n 1.95v 1659.495n 1.95v 1659.505n 1.95v 1669.495n 1.95v 1669.505n 1.95v 1679.495n 1.95v 1679.505n 0.0v 1689.495n 0.0v 1689.505n 1.95v 1699.495n 1.95v 1699.505n 1.95v 1709.495n 1.95v 1709.505n 1.95v 1719.495n 1.95v 1719.505n 1.95v 1729.495n 1.95v 1729.505n 0.0v 1739.495n 0.0v 1739.505n 0.0v 1749.495n 0.0v 1749.505n 0.0v 1759.495n 0.0v 1759.505n 0.0v 1769.495n 0.0v 1769.505n 0.0v 1779.495n 0.0v 1779.505n 0.0v 1789.495n 0.0v 1789.505n 0.0v 1799.495n 0.0v 1799.505n 0.0v 1809.495n 0.0v 1809.505n 1.95v 1819.495n 1.95v 1819.505n 1.95v 1829.495n 1.95v 1829.505n 1.95v 1839.495n 1.95v 1839.505n 0.0v 1849.495n 0.0v 1849.505n 1.95v 1859.495n 1.95v 1859.505n 1.95v 1869.495n 1.95v 1869.505n 1.95v 1879.495n 1.95v 1879.505n 1.95v 1889.495n 1.95v 1889.505n 1.95v 1899.495n 1.95v 1899.505n 1.95v 1909.495n 1.95v 1909.505n 1.95v 1919.495n 1.95v 1919.505n 1.95v 1929.495n 1.95v 1929.505n 1.95v 1939.495n 1.95v 1939.505n 1.95v 1949.495n 1.95v 1949.505n 0.0v 1959.495n 0.0v 1959.505n 0.0v 1969.495n 0.0v 1969.505n 1.95v 1979.495n 1.95v 1979.505n 1.95v 1989.495n 1.95v 1989.505n 0.0v 1999.495n 0.0v 1999.505n 0.0v 2009.495n 0.0v 2009.505n 0.0v 2019.495n 0.0v 2019.505n 0.0v 2029.495n 0.0v 2029.505n 0.0v 2039.495n 0.0v 2039.505n 0.0v 2049.495n 0.0v 2049.505n 0.0v )
* (time, data): [(0, 0), (10, 0), (20, 0), (30, 1), (40, 1), (50, 1), (60, 1), (70, 1), (80, 1), (90, 1), (100, 1), (110, 1), (120, 1), (130, 1), (140, 1), (150, 1), (160, 0), (170, 0), (180, 0), (190, 0), (200, 0), (210, 0), (220, 0), (230, 0), (240, 0), (250, 0), (260, 0), (270, 1), (280, 1), (290, 1), (300, 0), (310, 0), (320, 0), (330, 0), (340, 1), (350, 1), (360, 1), (370, 1), (380, 1), (390, 1), (400, 1), (410, 1), (420, 0), (430, 0), (440, 0), (450, 0), (460, 0), (470, 0), (480, 0), (490, 0), (500, 1), (510, 0), (520, 0), (530, 0), (540, 0), (550, 0), (560, 0), (570, 0), (580, 0), (590, 0), (600, 0), (610, 0), (620, 0), (630, 0), (640, 1), (650, 0), (660, 0), (670, 1), (680, 1), (690, 1), (700, 0), (710, 0), (720, 0), (730, 0), (740, 0), (750, 0), (760, 0), (770, 1), (780, 1), (790, 0), (800, 0), (810, 1), (820, 1), (830, 0), (840, 0), (850, 1), (860, 1), (870, 1), (880, 1), (890, 1), (900, 1), (910, 1), (920, 1), (930, 1), (940, 0), (950, 1), (960, 1), (970, 1), (980, 1), (990, 1), (1000, 1), (1010, 0), (1020, 0), (1030, 1), (1040, 1), (1050, 0), (1060, 0), (1070, 0), (1080, 0), (1090, 0), (1100, 0), (1110, 0), (1120, 0), (1130, 0), (1140, 0), (1150, 1), (1160, 1), (1170, 1), (1180, 1), (1190, 1), (1200, 1), (1210, 0), (1220, 0), (1230, 0), (1240, 0), (1250, 0), (1260, 0), (1270, 0), (1280, 0), (1290, 0), (1300, 0), (1310, 0), (1320, 1), (1330, 0), (1340, 0), (1350, 0), (1360, 0), (1370, 0), (1380, 0), (1390, 0), (1400, 0), (1410, 0), (1420, 1), (1430, 1), (1440, 1), (1450, 1), (1460, 1), (1470, 1), (1480, 1), (1490, 1), (1500, 1), (1510, 1), (1520, 1), (1530, 1), (1540, 1), (1550, 0), (1560, 1), (1570, 1), (1580, 0), (1590, 0), (1600, 1), (1610, 0), (1620, 0), (1630, 0), (1640, 0), (1650, 0), (1660, 0), (1670, 0), (1680, 1), (1690, 0), (1700, 0), (1710, 0), (1720, 1), (1730, 0), (1740, 0), (1750, 0), (1760, 1), (1770, 1), (1780, 1), (1790, 1), (1800, 1), (1810, 1), (1820, 1), (1830, 1), (1840, 1), (1850, 1), (1860, 0), (1870, 0), (1880, 0), (1890, 0), (1900, 0), (1910, 0), (1920, 0), (1930, 0), (1940, 0), (1950, 0), (1960, 1), (1970, 1), (1980, 1), (1990, 0), (2000, 0), (2010, 0), (2020, 0), (2030, 0), (2040, 0), (2050, 0)]
Vdin0_3  din0_3  0 PWL (0n 0.0v 9.495n 0.0v 9.505n 0.0v 19.495n 0.0v 19.505n 0.0v 29.495n 0.0v 29.505n 1.95v 39.495n 1.95v 39.505n 1.95v 49.495n 1.95v 49.505n 1.95v 59.495n 1.95v 59.505n 1.95v 69.495n 1.95v 69.505n 1.95v 79.495n 1.95v 79.505n 1.95v 89.495n 1.95v 89.505n 1.95v 99.495n 1.95v 99.505n 1.95v 109.495n 1.95v 109.505n 1.95v 119.495n 1.95v 119.505n 1.95v 129.495n 1.95v 129.505n 1.95v 139.495n 1.95v 139.505n 1.95v 149.495n 1.95v 149.505n 1.95v 159.495n 1.95v 159.505n 0.0v 169.495n 0.0v 169.505n 0.0v 179.495n 0.0v 179.505n 0.0v 189.495n 0.0v 189.505n 0.0v 199.495n 0.0v 199.505n 0.0v 209.495n 0.0v 209.505n 0.0v 219.495n 0.0v 219.505n 0.0v 229.495n 0.0v 229.505n 0.0v 239.495n 0.0v 239.505n 0.0v 249.495n 0.0v 249.505n 0.0v 259.495n 0.0v 259.505n 0.0v 269.495n 0.0v 269.505n 1.95v 279.495n 1.95v 279.505n 1.95v 289.495n 1.95v 289.505n 1.95v 299.495n 1.95v 299.505n 0.0v 309.495n 0.0v 309.505n 0.0v 319.495n 0.0v 319.505n 0.0v 329.495n 0.0v 329.505n 0.0v 339.495n 0.0v 339.505n 1.95v 349.495n 1.95v 349.505n 1.95v 359.495n 1.95v 359.505n 1.95v 369.495n 1.95v 369.505n 1.95v 379.495n 1.95v 379.505n 1.95v 389.495n 1.95v 389.505n 1.95v 399.495n 1.95v 399.505n 1.95v 409.495n 1.95v 409.505n 1.95v 419.495n 1.95v 419.505n 0.0v 429.495n 0.0v 429.505n 0.0v 439.495n 0.0v 439.505n 0.0v 449.495n 0.0v 449.505n 0.0v 459.495n 0.0v 459.505n 0.0v 469.495n 0.0v 469.505n 0.0v 479.495n 0.0v 479.505n 0.0v 489.495n 0.0v 489.505n 0.0v 499.495n 0.0v 499.505n 1.95v 509.495n 1.95v 509.505n 0.0v 519.495n 0.0v 519.505n 0.0v 529.495n 0.0v 529.505n 0.0v 539.495n 0.0v 539.505n 0.0v 549.495n 0.0v 549.505n 0.0v 559.495n 0.0v 559.505n 0.0v 569.495n 0.0v 569.505n 0.0v 579.495n 0.0v 579.505n 0.0v 589.495n 0.0v 589.505n 0.0v 599.495n 0.0v 599.505n 0.0v 609.495n 0.0v 609.505n 0.0v 619.495n 0.0v 619.505n 0.0v 629.495n 0.0v 629.505n 0.0v 639.495n 0.0v 639.505n 1.95v 649.495n 1.95v 649.505n 0.0v 659.495n 0.0v 659.505n 0.0v 669.495n 0.0v 669.505n 1.95v 679.495n 1.95v 679.505n 1.95v 689.495n 1.95v 689.505n 1.95v 699.495n 1.95v 699.505n 0.0v 709.495n 0.0v 709.505n 0.0v 719.495n 0.0v 719.505n 0.0v 729.495n 0.0v 729.505n 0.0v 739.495n 0.0v 739.505n 0.0v 749.495n 0.0v 749.505n 0.0v 759.495n 0.0v 759.505n 0.0v 769.495n 0.0v 769.505n 1.95v 779.495n 1.95v 779.505n 1.95v 789.495n 1.95v 789.505n 0.0v 799.495n 0.0v 799.505n 0.0v 809.495n 0.0v 809.505n 1.95v 819.495n 1.95v 819.505n 1.95v 829.495n 1.95v 829.505n 0.0v 839.495n 0.0v 839.505n 0.0v 849.495n 0.0v 849.505n 1.95v 859.495n 1.95v 859.505n 1.95v 869.495n 1.95v 869.505n 1.95v 879.495n 1.95v 879.505n 1.95v 889.495n 1.95v 889.505n 1.95v 899.495n 1.95v 899.505n 1.95v 909.495n 1.95v 909.505n 1.95v 919.495n 1.95v 919.505n 1.95v 929.495n 1.95v 929.505n 1.95v 939.495n 1.95v 939.505n 0.0v 949.495n 0.0v 949.505n 1.95v 959.495n 1.95v 959.505n 1.95v 969.495n 1.95v 969.505n 1.95v 979.495n 1.95v 979.505n 1.95v 989.495n 1.95v 989.505n 1.95v 999.495n 1.95v 999.505n 1.95v 1009.495n 1.95v 1009.505n 0.0v 1019.495n 0.0v 1019.505n 0.0v 1029.495n 0.0v 1029.505n 1.95v 1039.495n 1.95v 1039.505n 1.95v 1049.495n 1.95v 1049.505n 0.0v 1059.495n 0.0v 1059.505n 0.0v 1069.495n 0.0v 1069.505n 0.0v 1079.495n 0.0v 1079.505n 0.0v 1089.495n 0.0v 1089.505n 0.0v 1099.495n 0.0v 1099.505n 0.0v 1109.495n 0.0v 1109.505n 0.0v 1119.495n 0.0v 1119.505n 0.0v 1129.495n 0.0v 1129.505n 0.0v 1139.495n 0.0v 1139.505n 0.0v 1149.495n 0.0v 1149.505n 1.95v 1159.495n 1.95v 1159.505n 1.95v 1169.495n 1.95v 1169.505n 1.95v 1179.495n 1.95v 1179.505n 1.95v 1189.495n 1.95v 1189.505n 1.95v 1199.495n 1.95v 1199.505n 1.95v 1209.495n 1.95v 1209.505n 0.0v 1219.495n 0.0v 1219.505n 0.0v 1229.495n 0.0v 1229.505n 0.0v 1239.495n 0.0v 1239.505n 0.0v 1249.495n 0.0v 1249.505n 0.0v 1259.495n 0.0v 1259.505n 0.0v 1269.495n 0.0v 1269.505n 0.0v 1279.495n 0.0v 1279.505n 0.0v 1289.495n 0.0v 1289.505n 0.0v 1299.495n 0.0v 1299.505n 0.0v 1309.495n 0.0v 1309.505n 0.0v 1319.495n 0.0v 1319.505n 1.95v 1329.495n 1.95v 1329.505n 0.0v 1339.495n 0.0v 1339.505n 0.0v 1349.495n 0.0v 1349.505n 0.0v 1359.495n 0.0v 1359.505n 0.0v 1369.495n 0.0v 1369.505n 0.0v 1379.495n 0.0v 1379.505n 0.0v 1389.495n 0.0v 1389.505n 0.0v 1399.495n 0.0v 1399.505n 0.0v 1409.495n 0.0v 1409.505n 0.0v 1419.495n 0.0v 1419.505n 1.95v 1429.495n 1.95v 1429.505n 1.95v 1439.495n 1.95v 1439.505n 1.95v 1449.495n 1.95v 1449.505n 1.95v 1459.495n 1.95v 1459.505n 1.95v 1469.495n 1.95v 1469.505n 1.95v 1479.495n 1.95v 1479.505n 1.95v 1489.495n 1.95v 1489.505n 1.95v 1499.495n 1.95v 1499.505n 1.95v 1509.495n 1.95v 1509.505n 1.95v 1519.495n 1.95v 1519.505n 1.95v 1529.495n 1.95v 1529.505n 1.95v 1539.495n 1.95v 1539.505n 1.95v 1549.495n 1.95v 1549.505n 0.0v 1559.495n 0.0v 1559.505n 1.95v 1569.495n 1.95v 1569.505n 1.95v 1579.495n 1.95v 1579.505n 0.0v 1589.495n 0.0v 1589.505n 0.0v 1599.495n 0.0v 1599.505n 1.95v 1609.495n 1.95v 1609.505n 0.0v 1619.495n 0.0v 1619.505n 0.0v 1629.495n 0.0v 1629.505n 0.0v 1639.495n 0.0v 1639.505n 0.0v 1649.495n 0.0v 1649.505n 0.0v 1659.495n 0.0v 1659.505n 0.0v 1669.495n 0.0v 1669.505n 0.0v 1679.495n 0.0v 1679.505n 1.95v 1689.495n 1.95v 1689.505n 0.0v 1699.495n 0.0v 1699.505n 0.0v 1709.495n 0.0v 1709.505n 0.0v 1719.495n 0.0v 1719.505n 1.95v 1729.495n 1.95v 1729.505n 0.0v 1739.495n 0.0v 1739.505n 0.0v 1749.495n 0.0v 1749.505n 0.0v 1759.495n 0.0v 1759.505n 1.95v 1769.495n 1.95v 1769.505n 1.95v 1779.495n 1.95v 1779.505n 1.95v 1789.495n 1.95v 1789.505n 1.95v 1799.495n 1.95v 1799.505n 1.95v 1809.495n 1.95v 1809.505n 1.95v 1819.495n 1.95v 1819.505n 1.95v 1829.495n 1.95v 1829.505n 1.95v 1839.495n 1.95v 1839.505n 1.95v 1849.495n 1.95v 1849.505n 1.95v 1859.495n 1.95v 1859.505n 0.0v 1869.495n 0.0v 1869.505n 0.0v 1879.495n 0.0v 1879.505n 0.0v 1889.495n 0.0v 1889.505n 0.0v 1899.495n 0.0v 1899.505n 0.0v 1909.495n 0.0v 1909.505n 0.0v 1919.495n 0.0v 1919.505n 0.0v 1929.495n 0.0v 1929.505n 0.0v 1939.495n 0.0v 1939.505n 0.0v 1949.495n 0.0v 1949.505n 0.0v 1959.495n 0.0v 1959.505n 1.95v 1969.495n 1.95v 1969.505n 1.95v 1979.495n 1.95v 1979.505n 1.95v 1989.495n 1.95v 1989.505n 0.0v 1999.495n 0.0v 1999.505n 0.0v 2009.495n 0.0v 2009.505n 0.0v 2019.495n 0.0v 2019.505n 0.0v 2029.495n 0.0v 2029.505n 0.0v 2039.495n 0.0v 2039.505n 0.0v 2049.495n 0.0v 2049.505n 0.0v )
* (time, data): [(0, 0), (10, 0), (20, 1), (30, 0), (40, 0), (50, 0), (60, 1), (70, 1), (80, 1), (90, 1), (100, 1), (110, 0), (120, 0), (130, 0), (140, 0), (150, 0), (160, 1), (170, 1), (180, 1), (190, 1), (200, 1), (210, 1), (220, 1), (230, 1), (240, 0), (250, 0), (260, 0), (270, 1), (280, 1), (290, 1), (300, 1), (310, 1), (320, 1), (330, 1), (340, 1), (350, 1), (360, 1), (370, 0), (380, 0), (390, 0), (400, 1), (410, 1), (420, 0), (430, 0), (440, 0), (450, 0), (460, 0), (470, 0), (480, 0), (490, 0), (500, 1), (510, 1), (520, 1), (530, 1), (540, 0), (550, 1), (560, 1), (570, 1), (580, 1), (590, 1), (600, 1), (610, 1), (620, 1), (630, 1), (640, 1), (650, 1), (660, 1), (670, 0), (680, 0), (690, 0), (700, 1), (710, 1), (720, 1), (730, 0), (740, 0), (750, 0), (760, 0), (770, 1), (780, 0), (790, 1), (800, 1), (810, 0), (820, 0), (830, 1), (840, 1), (850, 1), (860, 1), (870, 1), (880, 1), (890, 1), (900, 1), (910, 1), (920, 1), (930, 1), (940, 1), (950, 0), (960, 0), (970, 1), (980, 0), (990, 0), (1000, 0), (1010, 0), (1020, 0), (1030, 1), (1040, 1), (1050, 1), (1060, 1), (1070, 1), (1080, 1), (1090, 1), (1100, 1), (1110, 1), (1120, 1), (1130, 1), (1140, 1), (1150, 0), (1160, 0), (1170, 0), (1180, 0), (1190, 0), (1200, 0), (1210, 0), (1220, 0), (1230, 1), (1240, 0), (1250, 1), (1260, 1), (1270, 1), (1280, 1), (1290, 1), (1300, 1), (1310, 1), (1320, 0), (1330, 1), (1340, 0), (1350, 0), (1360, 0), (1370, 0), (1380, 1), (1390, 0), (1400, 0), (1410, 0), (1420, 1), (1430, 1), (1440, 0), (1450, 0), (1460, 0), (1470, 0), (1480, 0), (1490, 0), (1500, 0), (1510, 0), (1520, 0), (1530, 0), (1540, 0), (1550, 0), (1560, 1), (1570, 1), (1580, 1), (1590, 1), (1600, 0), (1610, 1), (1620, 1), (1630, 1), (1640, 1), (1650, 1), (1660, 1), (1670, 1), (1680, 1), (1690, 1), (1700, 1), (1710, 1), (1720, 0), (1730, 1), (1740, 1), (1750, 1), (1760, 1), (1770, 1), (1780, 1), (1790, 1), (1800, 1), (1810, 0), (1820, 0), (1830, 0), (1840, 1), (1850, 1), (1860, 1), (1870, 1), (1880, 1), (1890, 1), (1900, 1), (1910, 1), (1920, 1), (1930, 1), (1940, 1), (1950, 0), (1960, 0), (1970, 1), (1980, 1), (1990, 1), (2000, 1), (2010, 1), (2020, 1), (2030, 1), (2040, 1), (2050, 1)]
Vdin0_4  din0_4  0 PWL (0n 0.0v 9.495n 0.0v 9.505n 0.0v 19.495n 0.0v 19.505n 1.95v 29.495n 1.95v 29.505n 0.0v 39.495n 0.0v 39.505n 0.0v 49.495n 0.0v 49.505n 0.0v 59.495n 0.0v 59.505n 1.95v 69.495n 1.95v 69.505n 1.95v 79.495n 1.95v 79.505n 1.95v 89.495n 1.95v 89.505n 1.95v 99.495n 1.95v 99.505n 1.95v 109.495n 1.95v 109.505n 0.0v 119.495n 0.0v 119.505n 0.0v 129.495n 0.0v 129.505n 0.0v 139.495n 0.0v 139.505n 0.0v 149.495n 0.0v 149.505n 0.0v 159.495n 0.0v 159.505n 1.95v 169.495n 1.95v 169.505n 1.95v 179.495n 1.95v 179.505n 1.95v 189.495n 1.95v 189.505n 1.95v 199.495n 1.95v 199.505n 1.95v 209.495n 1.95v 209.505n 1.95v 219.495n 1.95v 219.505n 1.95v 229.495n 1.95v 229.505n 1.95v 239.495n 1.95v 239.505n 0.0v 249.495n 0.0v 249.505n 0.0v 259.495n 0.0v 259.505n 0.0v 269.495n 0.0v 269.505n 1.95v 279.495n 1.95v 279.505n 1.95v 289.495n 1.95v 289.505n 1.95v 299.495n 1.95v 299.505n 1.95v 309.495n 1.95v 309.505n 1.95v 319.495n 1.95v 319.505n 1.95v 329.495n 1.95v 329.505n 1.95v 339.495n 1.95v 339.505n 1.95v 349.495n 1.95v 349.505n 1.95v 359.495n 1.95v 359.505n 1.95v 369.495n 1.95v 369.505n 0.0v 379.495n 0.0v 379.505n 0.0v 389.495n 0.0v 389.505n 0.0v 399.495n 0.0v 399.505n 1.95v 409.495n 1.95v 409.505n 1.95v 419.495n 1.95v 419.505n 0.0v 429.495n 0.0v 429.505n 0.0v 439.495n 0.0v 439.505n 0.0v 449.495n 0.0v 449.505n 0.0v 459.495n 0.0v 459.505n 0.0v 469.495n 0.0v 469.505n 0.0v 479.495n 0.0v 479.505n 0.0v 489.495n 0.0v 489.505n 0.0v 499.495n 0.0v 499.505n 1.95v 509.495n 1.95v 509.505n 1.95v 519.495n 1.95v 519.505n 1.95v 529.495n 1.95v 529.505n 1.95v 539.495n 1.95v 539.505n 0.0v 549.495n 0.0v 549.505n 1.95v 559.495n 1.95v 559.505n 1.95v 569.495n 1.95v 569.505n 1.95v 579.495n 1.95v 579.505n 1.95v 589.495n 1.95v 589.505n 1.95v 599.495n 1.95v 599.505n 1.95v 609.495n 1.95v 609.505n 1.95v 619.495n 1.95v 619.505n 1.95v 629.495n 1.95v 629.505n 1.95v 639.495n 1.95v 639.505n 1.95v 649.495n 1.95v 649.505n 1.95v 659.495n 1.95v 659.505n 1.95v 669.495n 1.95v 669.505n 0.0v 679.495n 0.0v 679.505n 0.0v 689.495n 0.0v 689.505n 0.0v 699.495n 0.0v 699.505n 1.95v 709.495n 1.95v 709.505n 1.95v 719.495n 1.95v 719.505n 1.95v 729.495n 1.95v 729.505n 0.0v 739.495n 0.0v 739.505n 0.0v 749.495n 0.0v 749.505n 0.0v 759.495n 0.0v 759.505n 0.0v 769.495n 0.0v 769.505n 1.95v 779.495n 1.95v 779.505n 0.0v 789.495n 0.0v 789.505n 1.95v 799.495n 1.95v 799.505n 1.95v 809.495n 1.95v 809.505n 0.0v 819.495n 0.0v 819.505n 0.0v 829.495n 0.0v 829.505n 1.95v 839.495n 1.95v 839.505n 1.95v 849.495n 1.95v 849.505n 1.95v 859.495n 1.95v 859.505n 1.95v 869.495n 1.95v 869.505n 1.95v 879.495n 1.95v 879.505n 1.95v 889.495n 1.95v 889.505n 1.95v 899.495n 1.95v 899.505n 1.95v 909.495n 1.95v 909.505n 1.95v 919.495n 1.95v 919.505n 1.95v 929.495n 1.95v 929.505n 1.95v 939.495n 1.95v 939.505n 1.95v 949.495n 1.95v 949.505n 0.0v 959.495n 0.0v 959.505n 0.0v 969.495n 0.0v 969.505n 1.95v 979.495n 1.95v 979.505n 0.0v 989.495n 0.0v 989.505n 0.0v 999.495n 0.0v 999.505n 0.0v 1009.495n 0.0v 1009.505n 0.0v 1019.495n 0.0v 1019.505n 0.0v 1029.495n 0.0v 1029.505n 1.95v 1039.495n 1.95v 1039.505n 1.95v 1049.495n 1.95v 1049.505n 1.95v 1059.495n 1.95v 1059.505n 1.95v 1069.495n 1.95v 1069.505n 1.95v 1079.495n 1.95v 1079.505n 1.95v 1089.495n 1.95v 1089.505n 1.95v 1099.495n 1.95v 1099.505n 1.95v 1109.495n 1.95v 1109.505n 1.95v 1119.495n 1.95v 1119.505n 1.95v 1129.495n 1.95v 1129.505n 1.95v 1139.495n 1.95v 1139.505n 1.95v 1149.495n 1.95v 1149.505n 0.0v 1159.495n 0.0v 1159.505n 0.0v 1169.495n 0.0v 1169.505n 0.0v 1179.495n 0.0v 1179.505n 0.0v 1189.495n 0.0v 1189.505n 0.0v 1199.495n 0.0v 1199.505n 0.0v 1209.495n 0.0v 1209.505n 0.0v 1219.495n 0.0v 1219.505n 0.0v 1229.495n 0.0v 1229.505n 1.95v 1239.495n 1.95v 1239.505n 0.0v 1249.495n 0.0v 1249.505n 1.95v 1259.495n 1.95v 1259.505n 1.95v 1269.495n 1.95v 1269.505n 1.95v 1279.495n 1.95v 1279.505n 1.95v 1289.495n 1.95v 1289.505n 1.95v 1299.495n 1.95v 1299.505n 1.95v 1309.495n 1.95v 1309.505n 1.95v 1319.495n 1.95v 1319.505n 0.0v 1329.495n 0.0v 1329.505n 1.95v 1339.495n 1.95v 1339.505n 0.0v 1349.495n 0.0v 1349.505n 0.0v 1359.495n 0.0v 1359.505n 0.0v 1369.495n 0.0v 1369.505n 0.0v 1379.495n 0.0v 1379.505n 1.95v 1389.495n 1.95v 1389.505n 0.0v 1399.495n 0.0v 1399.505n 0.0v 1409.495n 0.0v 1409.505n 0.0v 1419.495n 0.0v 1419.505n 1.95v 1429.495n 1.95v 1429.505n 1.95v 1439.495n 1.95v 1439.505n 0.0v 1449.495n 0.0v 1449.505n 0.0v 1459.495n 0.0v 1459.505n 0.0v 1469.495n 0.0v 1469.505n 0.0v 1479.495n 0.0v 1479.505n 0.0v 1489.495n 0.0v 1489.505n 0.0v 1499.495n 0.0v 1499.505n 0.0v 1509.495n 0.0v 1509.505n 0.0v 1519.495n 0.0v 1519.505n 0.0v 1529.495n 0.0v 1529.505n 0.0v 1539.495n 0.0v 1539.505n 0.0v 1549.495n 0.0v 1549.505n 0.0v 1559.495n 0.0v 1559.505n 1.95v 1569.495n 1.95v 1569.505n 1.95v 1579.495n 1.95v 1579.505n 1.95v 1589.495n 1.95v 1589.505n 1.95v 1599.495n 1.95v 1599.505n 0.0v 1609.495n 0.0v 1609.505n 1.95v 1619.495n 1.95v 1619.505n 1.95v 1629.495n 1.95v 1629.505n 1.95v 1639.495n 1.95v 1639.505n 1.95v 1649.495n 1.95v 1649.505n 1.95v 1659.495n 1.95v 1659.505n 1.95v 1669.495n 1.95v 1669.505n 1.95v 1679.495n 1.95v 1679.505n 1.95v 1689.495n 1.95v 1689.505n 1.95v 1699.495n 1.95v 1699.505n 1.95v 1709.495n 1.95v 1709.505n 1.95v 1719.495n 1.95v 1719.505n 0.0v 1729.495n 0.0v 1729.505n 1.95v 1739.495n 1.95v 1739.505n 1.95v 1749.495n 1.95v 1749.505n 1.95v 1759.495n 1.95v 1759.505n 1.95v 1769.495n 1.95v 1769.505n 1.95v 1779.495n 1.95v 1779.505n 1.95v 1789.495n 1.95v 1789.505n 1.95v 1799.495n 1.95v 1799.505n 1.95v 1809.495n 1.95v 1809.505n 0.0v 1819.495n 0.0v 1819.505n 0.0v 1829.495n 0.0v 1829.505n 0.0v 1839.495n 0.0v 1839.505n 1.95v 1849.495n 1.95v 1849.505n 1.95v 1859.495n 1.95v 1859.505n 1.95v 1869.495n 1.95v 1869.505n 1.95v 1879.495n 1.95v 1879.505n 1.95v 1889.495n 1.95v 1889.505n 1.95v 1899.495n 1.95v 1899.505n 1.95v 1909.495n 1.95v 1909.505n 1.95v 1919.495n 1.95v 1919.505n 1.95v 1929.495n 1.95v 1929.505n 1.95v 1939.495n 1.95v 1939.505n 1.95v 1949.495n 1.95v 1949.505n 0.0v 1959.495n 0.0v 1959.505n 0.0v 1969.495n 0.0v 1969.505n 1.95v 1979.495n 1.95v 1979.505n 1.95v 1989.495n 1.95v 1989.505n 1.95v 1999.495n 1.95v 1999.505n 1.95v 2009.495n 1.95v 2009.505n 1.95v 2019.495n 1.95v 2019.505n 1.95v 2029.495n 1.95v 2029.505n 1.95v 2039.495n 1.95v 2039.505n 1.95v 2049.495n 1.95v 2049.505n 1.95v )
* (time, data): [(0, 0), (10, 1), (20, 1), (30, 0), (40, 0), (50, 0), (60, 0), (70, 1), (80, 0), (90, 0), (100, 0), (110, 0), (120, 0), (130, 0), (140, 0), (150, 0), (160, 1), (170, 1), (180, 1), (190, 1), (200, 1), (210, 1), (220, 1), (230, 1), (240, 1), (250, 1), (260, 1), (270, 1), (280, 1), (290, 1), (300, 1), (310, 1), (320, 1), (330, 1), (340, 0), (350, 0), (360, 0), (370, 0), (380, 0), (390, 0), (400, 0), (410, 0), (420, 1), (430, 1), (440, 1), (450, 1), (460, 1), (470, 1), (480, 1), (490, 1), (500, 0), (510, 1), (520, 1), (530, 1), (540, 1), (550, 0), (560, 0), (570, 0), (580, 0), (590, 1), (600, 1), (610, 1), (620, 1), (630, 1), (640, 1), (650, 1), (660, 1), (670, 1), (680, 1), (690, 1), (700, 0), (710, 0), (720, 0), (730, 0), (740, 0), (750, 0), (760, 0), (770, 0), (780, 0), (790, 0), (800, 0), (810, 0), (820, 0), (830, 0), (840, 0), (850, 0), (860, 0), (870, 0), (880, 0), (890, 0), (900, 0), (910, 0), (920, 0), (930, 0), (940, 1), (950, 1), (960, 1), (970, 0), (980, 1), (990, 1), (1000, 1), (1010, 0), (1020, 0), (1030, 1), (1040, 1), (1050, 0), (1060, 0), (1070, 0), (1080, 0), (1090, 0), (1100, 0), (1110, 0), (1120, 0), (1130, 0), (1140, 0), (1150, 1), (1160, 1), (1170, 1), (1180, 1), (1190, 1), (1200, 1), (1210, 1), (1220, 1), (1230, 0), (1240, 1), (1250, 0), (1260, 0), (1270, 0), (1280, 0), (1290, 1), (1300, 1), (1310, 1), (1320, 0), (1330, 1), (1340, 1), (1350, 1), (1360, 1), (1370, 1), (1380, 1), (1390, 0), (1400, 0), (1410, 0), (1420, 0), (1430, 0), (1440, 1), (1450, 1), (1460, 1), (1470, 1), (1480, 1), (1490, 1), (1500, 1), (1510, 1), (1520, 1), (1530, 1), (1540, 1), (1550, 1), (1560, 0), (1570, 0), (1580, 0), (1590, 0), (1600, 1), (1610, 0), (1620, 0), (1630, 0), (1640, 0), (1650, 0), (1660, 0), (1670, 0), (1680, 0), (1690, 0), (1700, 0), (1710, 0), (1720, 1), (1730, 1), (1740, 1), (1750, 1), (1760, 1), (1770, 1), (1780, 1), (1790, 1), (1800, 1), (1810, 0), (1820, 0), (1830, 0), (1840, 0), (1850, 1), (1860, 0), (1870, 0), (1880, 0), (1890, 0), (1900, 0), (1910, 0), (1920, 0), (1930, 0), (1940, 0), (1950, 0), (1960, 0), (1970, 0), (1980, 0), (1990, 1), (2000, 1), (2010, 1), (2020, 1), (2030, 1), (2040, 1), (2050, 1)]
Vdin0_5  din0_5  0 PWL (0n 0.0v 9.495n 0.0v 9.505n 1.95v 19.495n 1.95v 19.505n 1.95v 29.495n 1.95v 29.505n 0.0v 39.495n 0.0v 39.505n 0.0v 49.495n 0.0v 49.505n 0.0v 59.495n 0.0v 59.505n 0.0v 69.495n 0.0v 69.505n 1.95v 79.495n 1.95v 79.505n 0.0v 89.495n 0.0v 89.505n 0.0v 99.495n 0.0v 99.505n 0.0v 109.495n 0.0v 109.505n 0.0v 119.495n 0.0v 119.505n 0.0v 129.495n 0.0v 129.505n 0.0v 139.495n 0.0v 139.505n 0.0v 149.495n 0.0v 149.505n 0.0v 159.495n 0.0v 159.505n 1.95v 169.495n 1.95v 169.505n 1.95v 179.495n 1.95v 179.505n 1.95v 189.495n 1.95v 189.505n 1.95v 199.495n 1.95v 199.505n 1.95v 209.495n 1.95v 209.505n 1.95v 219.495n 1.95v 219.505n 1.95v 229.495n 1.95v 229.505n 1.95v 239.495n 1.95v 239.505n 1.95v 249.495n 1.95v 249.505n 1.95v 259.495n 1.95v 259.505n 1.95v 269.495n 1.95v 269.505n 1.95v 279.495n 1.95v 279.505n 1.95v 289.495n 1.95v 289.505n 1.95v 299.495n 1.95v 299.505n 1.95v 309.495n 1.95v 309.505n 1.95v 319.495n 1.95v 319.505n 1.95v 329.495n 1.95v 329.505n 1.95v 339.495n 1.95v 339.505n 0.0v 349.495n 0.0v 349.505n 0.0v 359.495n 0.0v 359.505n 0.0v 369.495n 0.0v 369.505n 0.0v 379.495n 0.0v 379.505n 0.0v 389.495n 0.0v 389.505n 0.0v 399.495n 0.0v 399.505n 0.0v 409.495n 0.0v 409.505n 0.0v 419.495n 0.0v 419.505n 1.95v 429.495n 1.95v 429.505n 1.95v 439.495n 1.95v 439.505n 1.95v 449.495n 1.95v 449.505n 1.95v 459.495n 1.95v 459.505n 1.95v 469.495n 1.95v 469.505n 1.95v 479.495n 1.95v 479.505n 1.95v 489.495n 1.95v 489.505n 1.95v 499.495n 1.95v 499.505n 0.0v 509.495n 0.0v 509.505n 1.95v 519.495n 1.95v 519.505n 1.95v 529.495n 1.95v 529.505n 1.95v 539.495n 1.95v 539.505n 1.95v 549.495n 1.95v 549.505n 0.0v 559.495n 0.0v 559.505n 0.0v 569.495n 0.0v 569.505n 0.0v 579.495n 0.0v 579.505n 0.0v 589.495n 0.0v 589.505n 1.95v 599.495n 1.95v 599.505n 1.95v 609.495n 1.95v 609.505n 1.95v 619.495n 1.95v 619.505n 1.95v 629.495n 1.95v 629.505n 1.95v 639.495n 1.95v 639.505n 1.95v 649.495n 1.95v 649.505n 1.95v 659.495n 1.95v 659.505n 1.95v 669.495n 1.95v 669.505n 1.95v 679.495n 1.95v 679.505n 1.95v 689.495n 1.95v 689.505n 1.95v 699.495n 1.95v 699.505n 0.0v 709.495n 0.0v 709.505n 0.0v 719.495n 0.0v 719.505n 0.0v 729.495n 0.0v 729.505n 0.0v 739.495n 0.0v 739.505n 0.0v 749.495n 0.0v 749.505n 0.0v 759.495n 0.0v 759.505n 0.0v 769.495n 0.0v 769.505n 0.0v 779.495n 0.0v 779.505n 0.0v 789.495n 0.0v 789.505n 0.0v 799.495n 0.0v 799.505n 0.0v 809.495n 0.0v 809.505n 0.0v 819.495n 0.0v 819.505n 0.0v 829.495n 0.0v 829.505n 0.0v 839.495n 0.0v 839.505n 0.0v 849.495n 0.0v 849.505n 0.0v 859.495n 0.0v 859.505n 0.0v 869.495n 0.0v 869.505n 0.0v 879.495n 0.0v 879.505n 0.0v 889.495n 0.0v 889.505n 0.0v 899.495n 0.0v 899.505n 0.0v 909.495n 0.0v 909.505n 0.0v 919.495n 0.0v 919.505n 0.0v 929.495n 0.0v 929.505n 0.0v 939.495n 0.0v 939.505n 1.95v 949.495n 1.95v 949.505n 1.95v 959.495n 1.95v 959.505n 1.95v 969.495n 1.95v 969.505n 0.0v 979.495n 0.0v 979.505n 1.95v 989.495n 1.95v 989.505n 1.95v 999.495n 1.95v 999.505n 1.95v 1009.495n 1.95v 1009.505n 0.0v 1019.495n 0.0v 1019.505n 0.0v 1029.495n 0.0v 1029.505n 1.95v 1039.495n 1.95v 1039.505n 1.95v 1049.495n 1.95v 1049.505n 0.0v 1059.495n 0.0v 1059.505n 0.0v 1069.495n 0.0v 1069.505n 0.0v 1079.495n 0.0v 1079.505n 0.0v 1089.495n 0.0v 1089.505n 0.0v 1099.495n 0.0v 1099.505n 0.0v 1109.495n 0.0v 1109.505n 0.0v 1119.495n 0.0v 1119.505n 0.0v 1129.495n 0.0v 1129.505n 0.0v 1139.495n 0.0v 1139.505n 0.0v 1149.495n 0.0v 1149.505n 1.95v 1159.495n 1.95v 1159.505n 1.95v 1169.495n 1.95v 1169.505n 1.95v 1179.495n 1.95v 1179.505n 1.95v 1189.495n 1.95v 1189.505n 1.95v 1199.495n 1.95v 1199.505n 1.95v 1209.495n 1.95v 1209.505n 1.95v 1219.495n 1.95v 1219.505n 1.95v 1229.495n 1.95v 1229.505n 0.0v 1239.495n 0.0v 1239.505n 1.95v 1249.495n 1.95v 1249.505n 0.0v 1259.495n 0.0v 1259.505n 0.0v 1269.495n 0.0v 1269.505n 0.0v 1279.495n 0.0v 1279.505n 0.0v 1289.495n 0.0v 1289.505n 1.95v 1299.495n 1.95v 1299.505n 1.95v 1309.495n 1.95v 1309.505n 1.95v 1319.495n 1.95v 1319.505n 0.0v 1329.495n 0.0v 1329.505n 1.95v 1339.495n 1.95v 1339.505n 1.95v 1349.495n 1.95v 1349.505n 1.95v 1359.495n 1.95v 1359.505n 1.95v 1369.495n 1.95v 1369.505n 1.95v 1379.495n 1.95v 1379.505n 1.95v 1389.495n 1.95v 1389.505n 0.0v 1399.495n 0.0v 1399.505n 0.0v 1409.495n 0.0v 1409.505n 0.0v 1419.495n 0.0v 1419.505n 0.0v 1429.495n 0.0v 1429.505n 0.0v 1439.495n 0.0v 1439.505n 1.95v 1449.495n 1.95v 1449.505n 1.95v 1459.495n 1.95v 1459.505n 1.95v 1469.495n 1.95v 1469.505n 1.95v 1479.495n 1.95v 1479.505n 1.95v 1489.495n 1.95v 1489.505n 1.95v 1499.495n 1.95v 1499.505n 1.95v 1509.495n 1.95v 1509.505n 1.95v 1519.495n 1.95v 1519.505n 1.95v 1529.495n 1.95v 1529.505n 1.95v 1539.495n 1.95v 1539.505n 1.95v 1549.495n 1.95v 1549.505n 1.95v 1559.495n 1.95v 1559.505n 0.0v 1569.495n 0.0v 1569.505n 0.0v 1579.495n 0.0v 1579.505n 0.0v 1589.495n 0.0v 1589.505n 0.0v 1599.495n 0.0v 1599.505n 1.95v 1609.495n 1.95v 1609.505n 0.0v 1619.495n 0.0v 1619.505n 0.0v 1629.495n 0.0v 1629.505n 0.0v 1639.495n 0.0v 1639.505n 0.0v 1649.495n 0.0v 1649.505n 0.0v 1659.495n 0.0v 1659.505n 0.0v 1669.495n 0.0v 1669.505n 0.0v 1679.495n 0.0v 1679.505n 0.0v 1689.495n 0.0v 1689.505n 0.0v 1699.495n 0.0v 1699.505n 0.0v 1709.495n 0.0v 1709.505n 0.0v 1719.495n 0.0v 1719.505n 1.95v 1729.495n 1.95v 1729.505n 1.95v 1739.495n 1.95v 1739.505n 1.95v 1749.495n 1.95v 1749.505n 1.95v 1759.495n 1.95v 1759.505n 1.95v 1769.495n 1.95v 1769.505n 1.95v 1779.495n 1.95v 1779.505n 1.95v 1789.495n 1.95v 1789.505n 1.95v 1799.495n 1.95v 1799.505n 1.95v 1809.495n 1.95v 1809.505n 0.0v 1819.495n 0.0v 1819.505n 0.0v 1829.495n 0.0v 1829.505n 0.0v 1839.495n 0.0v 1839.505n 0.0v 1849.495n 0.0v 1849.505n 1.95v 1859.495n 1.95v 1859.505n 0.0v 1869.495n 0.0v 1869.505n 0.0v 1879.495n 0.0v 1879.505n 0.0v 1889.495n 0.0v 1889.505n 0.0v 1899.495n 0.0v 1899.505n 0.0v 1909.495n 0.0v 1909.505n 0.0v 1919.495n 0.0v 1919.505n 0.0v 1929.495n 0.0v 1929.505n 0.0v 1939.495n 0.0v 1939.505n 0.0v 1949.495n 0.0v 1949.505n 0.0v 1959.495n 0.0v 1959.505n 0.0v 1969.495n 0.0v 1969.505n 0.0v 1979.495n 0.0v 1979.505n 0.0v 1989.495n 0.0v 1989.505n 1.95v 1999.495n 1.95v 1999.505n 1.95v 2009.495n 1.95v 2009.505n 1.95v 2019.495n 1.95v 2019.505n 1.95v 2029.495n 1.95v 2029.505n 1.95v 2039.495n 1.95v 2039.505n 1.95v 2049.495n 1.95v 2049.505n 1.95v )
* (time, data): [(0, 0), (10, 0), (20, 1), (30, 0), (40, 0), (50, 0), (60, 0), (70, 1), (80, 1), (90, 1), (100, 1), (110, 0), (120, 0), (130, 0), (140, 0), (150, 0), (160, 1), (170, 1), (180, 1), (190, 1), (200, 1), (210, 1), (220, 1), (230, 1), (240, 1), (250, 1), (260, 1), (270, 1), (280, 1), (290, 1), (300, 0), (310, 0), (320, 0), (330, 0), (340, 0), (350, 0), (360, 0), (370, 1), (380, 1), (390, 1), (400, 1), (410, 1), (420, 1), (430, 1), (440, 1), (450, 1), (460, 1), (470, 1), (480, 1), (490, 1), (500, 0), (510, 0), (520, 0), (530, 0), (540, 0), (550, 1), (560, 1), (570, 1), (580, 1), (590, 1), (600, 1), (610, 1), (620, 1), (630, 1), (640, 1), (650, 0), (660, 0), (670, 0), (680, 0), (690, 0), (700, 0), (710, 0), (720, 0), (730, 0), (740, 0), (750, 0), (760, 0), (770, 1), (780, 0), (790, 1), (800, 1), (810, 1), (820, 1), (830, 1), (840, 1), (850, 1), (860, 1), (870, 1), (880, 1), (890, 1), (900, 1), (910, 1), (920, 1), (930, 1), (940, 1), (950, 0), (960, 0), (970, 0), (980, 1), (990, 0), (1000, 0), (1010, 0), (1020, 0), (1030, 1), (1040, 1), (1050, 1), (1060, 1), (1070, 1), (1080, 1), (1090, 1), (1100, 1), (1110, 0), (1120, 0), (1130, 0), (1140, 0), (1150, 1), (1160, 1), (1170, 1), (1180, 1), (1190, 1), (1200, 1), (1210, 0), (1220, 0), (1230, 1), (1240, 1), (1250, 1), (1260, 1), (1270, 1), (1280, 1), (1290, 0), (1300, 0), (1310, 0), (1320, 1), (1330, 1), (1340, 1), (1350, 1), (1360, 1), (1370, 1), (1380, 1), (1390, 0), (1400, 0), (1410, 0), (1420, 0), (1430, 0), (1440, 0), (1450, 0), (1460, 0), (1470, 0), (1480, 0), (1490, 0), (1500, 0), (1510, 0), (1520, 0), (1530, 0), (1540, 0), (1550, 1), (1560, 1), (1570, 1), (1580, 0), (1590, 0), (1600, 1), (1610, 1), (1620, 1), (1630, 1), (1640, 1), (1650, 1), (1660, 1), (1670, 1), (1680, 0), (1690, 0), (1700, 0), (1710, 0), (1720, 1), (1730, 0), (1740, 1), (1750, 1), (1760, 1), (1770, 1), (1780, 1), (1790, 1), (1800, 1), (1810, 0), (1820, 0), (1830, 0), (1840, 0), (1850, 1), (1860, 0), (1870, 0), (1880, 0), (1890, 0), (1900, 0), (1910, 0), (1920, 0), (1930, 0), (1940, 0), (1950, 0), (1960, 0), (1970, 0), (1980, 0), (1990, 1), (2000, 1), (2010, 1), (2020, 1), (2030, 1), (2040, 1), (2050, 1)]
Vdin0_6  din0_6  0 PWL (0n 0.0v 9.495n 0.0v 9.505n 0.0v 19.495n 0.0v 19.505n 1.95v 29.495n 1.95v 29.505n 0.0v 39.495n 0.0v 39.505n 0.0v 49.495n 0.0v 49.505n 0.0v 59.495n 0.0v 59.505n 0.0v 69.495n 0.0v 69.505n 1.95v 79.495n 1.95v 79.505n 1.95v 89.495n 1.95v 89.505n 1.95v 99.495n 1.95v 99.505n 1.95v 109.495n 1.95v 109.505n 0.0v 119.495n 0.0v 119.505n 0.0v 129.495n 0.0v 129.505n 0.0v 139.495n 0.0v 139.505n 0.0v 149.495n 0.0v 149.505n 0.0v 159.495n 0.0v 159.505n 1.95v 169.495n 1.95v 169.505n 1.95v 179.495n 1.95v 179.505n 1.95v 189.495n 1.95v 189.505n 1.95v 199.495n 1.95v 199.505n 1.95v 209.495n 1.95v 209.505n 1.95v 219.495n 1.95v 219.505n 1.95v 229.495n 1.95v 229.505n 1.95v 239.495n 1.95v 239.505n 1.95v 249.495n 1.95v 249.505n 1.95v 259.495n 1.95v 259.505n 1.95v 269.495n 1.95v 269.505n 1.95v 279.495n 1.95v 279.505n 1.95v 289.495n 1.95v 289.505n 1.95v 299.495n 1.95v 299.505n 0.0v 309.495n 0.0v 309.505n 0.0v 319.495n 0.0v 319.505n 0.0v 329.495n 0.0v 329.505n 0.0v 339.495n 0.0v 339.505n 0.0v 349.495n 0.0v 349.505n 0.0v 359.495n 0.0v 359.505n 0.0v 369.495n 0.0v 369.505n 1.95v 379.495n 1.95v 379.505n 1.95v 389.495n 1.95v 389.505n 1.95v 399.495n 1.95v 399.505n 1.95v 409.495n 1.95v 409.505n 1.95v 419.495n 1.95v 419.505n 1.95v 429.495n 1.95v 429.505n 1.95v 439.495n 1.95v 439.505n 1.95v 449.495n 1.95v 449.505n 1.95v 459.495n 1.95v 459.505n 1.95v 469.495n 1.95v 469.505n 1.95v 479.495n 1.95v 479.505n 1.95v 489.495n 1.95v 489.505n 1.95v 499.495n 1.95v 499.505n 0.0v 509.495n 0.0v 509.505n 0.0v 519.495n 0.0v 519.505n 0.0v 529.495n 0.0v 529.505n 0.0v 539.495n 0.0v 539.505n 0.0v 549.495n 0.0v 549.505n 1.95v 559.495n 1.95v 559.505n 1.95v 569.495n 1.95v 569.505n 1.95v 579.495n 1.95v 579.505n 1.95v 589.495n 1.95v 589.505n 1.95v 599.495n 1.95v 599.505n 1.95v 609.495n 1.95v 609.505n 1.95v 619.495n 1.95v 619.505n 1.95v 629.495n 1.95v 629.505n 1.95v 639.495n 1.95v 639.505n 1.95v 649.495n 1.95v 649.505n 0.0v 659.495n 0.0v 659.505n 0.0v 669.495n 0.0v 669.505n 0.0v 679.495n 0.0v 679.505n 0.0v 689.495n 0.0v 689.505n 0.0v 699.495n 0.0v 699.505n 0.0v 709.495n 0.0v 709.505n 0.0v 719.495n 0.0v 719.505n 0.0v 729.495n 0.0v 729.505n 0.0v 739.495n 0.0v 739.505n 0.0v 749.495n 0.0v 749.505n 0.0v 759.495n 0.0v 759.505n 0.0v 769.495n 0.0v 769.505n 1.95v 779.495n 1.95v 779.505n 0.0v 789.495n 0.0v 789.505n 1.95v 799.495n 1.95v 799.505n 1.95v 809.495n 1.95v 809.505n 1.95v 819.495n 1.95v 819.505n 1.95v 829.495n 1.95v 829.505n 1.95v 839.495n 1.95v 839.505n 1.95v 849.495n 1.95v 849.505n 1.95v 859.495n 1.95v 859.505n 1.95v 869.495n 1.95v 869.505n 1.95v 879.495n 1.95v 879.505n 1.95v 889.495n 1.95v 889.505n 1.95v 899.495n 1.95v 899.505n 1.95v 909.495n 1.95v 909.505n 1.95v 919.495n 1.95v 919.505n 1.95v 929.495n 1.95v 929.505n 1.95v 939.495n 1.95v 939.505n 1.95v 949.495n 1.95v 949.505n 0.0v 959.495n 0.0v 959.505n 0.0v 969.495n 0.0v 969.505n 0.0v 979.495n 0.0v 979.505n 1.95v 989.495n 1.95v 989.505n 0.0v 999.495n 0.0v 999.505n 0.0v 1009.495n 0.0v 1009.505n 0.0v 1019.495n 0.0v 1019.505n 0.0v 1029.495n 0.0v 1029.505n 1.95v 1039.495n 1.95v 1039.505n 1.95v 1049.495n 1.95v 1049.505n 1.95v 1059.495n 1.95v 1059.505n 1.95v 1069.495n 1.95v 1069.505n 1.95v 1079.495n 1.95v 1079.505n 1.95v 1089.495n 1.95v 1089.505n 1.95v 1099.495n 1.95v 1099.505n 1.95v 1109.495n 1.95v 1109.505n 0.0v 1119.495n 0.0v 1119.505n 0.0v 1129.495n 0.0v 1129.505n 0.0v 1139.495n 0.0v 1139.505n 0.0v 1149.495n 0.0v 1149.505n 1.95v 1159.495n 1.95v 1159.505n 1.95v 1169.495n 1.95v 1169.505n 1.95v 1179.495n 1.95v 1179.505n 1.95v 1189.495n 1.95v 1189.505n 1.95v 1199.495n 1.95v 1199.505n 1.95v 1209.495n 1.95v 1209.505n 0.0v 1219.495n 0.0v 1219.505n 0.0v 1229.495n 0.0v 1229.505n 1.95v 1239.495n 1.95v 1239.505n 1.95v 1249.495n 1.95v 1249.505n 1.95v 1259.495n 1.95v 1259.505n 1.95v 1269.495n 1.95v 1269.505n 1.95v 1279.495n 1.95v 1279.505n 1.95v 1289.495n 1.95v 1289.505n 0.0v 1299.495n 0.0v 1299.505n 0.0v 1309.495n 0.0v 1309.505n 0.0v 1319.495n 0.0v 1319.505n 1.95v 1329.495n 1.95v 1329.505n 1.95v 1339.495n 1.95v 1339.505n 1.95v 1349.495n 1.95v 1349.505n 1.95v 1359.495n 1.95v 1359.505n 1.95v 1369.495n 1.95v 1369.505n 1.95v 1379.495n 1.95v 1379.505n 1.95v 1389.495n 1.95v 1389.505n 0.0v 1399.495n 0.0v 1399.505n 0.0v 1409.495n 0.0v 1409.505n 0.0v 1419.495n 0.0v 1419.505n 0.0v 1429.495n 0.0v 1429.505n 0.0v 1439.495n 0.0v 1439.505n 0.0v 1449.495n 0.0v 1449.505n 0.0v 1459.495n 0.0v 1459.505n 0.0v 1469.495n 0.0v 1469.505n 0.0v 1479.495n 0.0v 1479.505n 0.0v 1489.495n 0.0v 1489.505n 0.0v 1499.495n 0.0v 1499.505n 0.0v 1509.495n 0.0v 1509.505n 0.0v 1519.495n 0.0v 1519.505n 0.0v 1529.495n 0.0v 1529.505n 0.0v 1539.495n 0.0v 1539.505n 0.0v 1549.495n 0.0v 1549.505n 1.95v 1559.495n 1.95v 1559.505n 1.95v 1569.495n 1.95v 1569.505n 1.95v 1579.495n 1.95v 1579.505n 0.0v 1589.495n 0.0v 1589.505n 0.0v 1599.495n 0.0v 1599.505n 1.95v 1609.495n 1.95v 1609.505n 1.95v 1619.495n 1.95v 1619.505n 1.95v 1629.495n 1.95v 1629.505n 1.95v 1639.495n 1.95v 1639.505n 1.95v 1649.495n 1.95v 1649.505n 1.95v 1659.495n 1.95v 1659.505n 1.95v 1669.495n 1.95v 1669.505n 1.95v 1679.495n 1.95v 1679.505n 0.0v 1689.495n 0.0v 1689.505n 0.0v 1699.495n 0.0v 1699.505n 0.0v 1709.495n 0.0v 1709.505n 0.0v 1719.495n 0.0v 1719.505n 1.95v 1729.495n 1.95v 1729.505n 0.0v 1739.495n 0.0v 1739.505n 1.95v 1749.495n 1.95v 1749.505n 1.95v 1759.495n 1.95v 1759.505n 1.95v 1769.495n 1.95v 1769.505n 1.95v 1779.495n 1.95v 1779.505n 1.95v 1789.495n 1.95v 1789.505n 1.95v 1799.495n 1.95v 1799.505n 1.95v 1809.495n 1.95v 1809.505n 0.0v 1819.495n 0.0v 1819.505n 0.0v 1829.495n 0.0v 1829.505n 0.0v 1839.495n 0.0v 1839.505n 0.0v 1849.495n 0.0v 1849.505n 1.95v 1859.495n 1.95v 1859.505n 0.0v 1869.495n 0.0v 1869.505n 0.0v 1879.495n 0.0v 1879.505n 0.0v 1889.495n 0.0v 1889.505n 0.0v 1899.495n 0.0v 1899.505n 0.0v 1909.495n 0.0v 1909.505n 0.0v 1919.495n 0.0v 1919.505n 0.0v 1929.495n 0.0v 1929.505n 0.0v 1939.495n 0.0v 1939.505n 0.0v 1949.495n 0.0v 1949.505n 0.0v 1959.495n 0.0v 1959.505n 0.0v 1969.495n 0.0v 1969.505n 0.0v 1979.495n 0.0v 1979.505n 0.0v 1989.495n 0.0v 1989.505n 1.95v 1999.495n 1.95v 1999.505n 1.95v 2009.495n 1.95v 2009.505n 1.95v 2019.495n 1.95v 2019.505n 1.95v 2029.495n 1.95v 2029.505n 1.95v 2039.495n 1.95v 2039.505n 1.95v 2049.495n 1.95v 2049.505n 1.95v )
* (time, data): [(0, 0), (10, 1), (20, 0), (30, 0), (40, 0), (50, 0), (60, 0), (70, 1), (80, 0), (90, 0), (100, 0), (110, 1), (120, 1), (130, 1), (140, 1), (150, 1), (160, 1), (170, 1), (180, 1), (190, 1), (200, 1), (210, 1), (220, 1), (230, 1), (240, 0), (250, 0), (260, 0), (270, 0), (280, 0), (290, 0), (300, 1), (310, 1), (320, 1), (330, 1), (340, 1), (350, 1), (360, 1), (370, 0), (380, 0), (390, 0), (400, 0), (410, 0), (420, 1), (430, 1), (440, 1), (450, 1), (460, 1), (470, 1), (480, 1), (490, 1), (500, 0), (510, 0), (520, 0), (530, 0), (540, 1), (550, 1), (560, 1), (570, 1), (580, 1), (590, 1), (600, 1), (610, 1), (620, 1), (630, 1), (640, 0), (650, 0), (660, 0), (670, 0), (680, 0), (690, 0), (700, 1), (710, 1), (720, 1), (730, 0), (740, 0), (750, 0), (760, 0), (770, 0), (780, 1), (790, 0), (800, 0), (810, 1), (820, 1), (830, 1), (840, 1), (850, 1), (860, 1), (870, 1), (880, 1), (890, 1), (900, 1), (910, 1), (920, 1), (930, 1), (940, 0), (950, 0), (960, 0), (970, 1), (980, 0), (990, 0), (1000, 0), (1010, 1), (1020, 1), (1030, 1), (1040, 1), (1050, 0), (1060, 0), (1070, 0), (1080, 0), (1090, 0), (1100, 0), (1110, 0), (1120, 0), (1130, 0), (1140, 0), (1150, 1), (1160, 1), (1170, 1), (1180, 1), (1190, 1), (1200, 1), (1210, 0), (1220, 0), (1230, 1), (1240, 1), (1250, 1), (1260, 1), (1270, 1), (1280, 1), (1290, 1), (1300, 1), (1310, 1), (1320, 0), (1330, 1), (1340, 1), (1350, 1), (1360, 1), (1370, 1), (1380, 0), (1390, 1), (1400, 1), (1410, 1), (1420, 1), (1430, 1), (1440, 0), (1450, 0), (1460, 0), (1470, 0), (1480, 0), (1490, 0), (1500, 0), (1510, 0), (1520, 0), (1530, 0), (1540, 0), (1550, 1), (1560, 0), (1570, 0), (1580, 0), (1590, 0), (1600, 1), (1610, 1), (1620, 1), (1630, 1), (1640, 1), (1650, 1), (1660, 0), (1670, 0), (1680, 1), (1690, 0), (1700, 0), (1710, 0), (1720, 0), (1730, 1), (1740, 1), (1750, 1), (1760, 1), (1770, 1), (1780, 1), (1790, 1), (1800, 1), (1810, 1), (1820, 1), (1830, 1), (1840, 1), (1850, 1), (1860, 1), (1870, 1), (1880, 1), (1890, 1), (1900, 1), (1910, 1), (1920, 1), (1930, 1), (1940, 1), (1950, 1), (1960, 1), (1970, 1), (1980, 1), (1990, 1), (2000, 1), (2010, 1), (2020, 1), (2030, 1), (2040, 1), (2050, 1)]
Vdin0_7  din0_7  0 PWL (0n 0.0v 9.495n 0.0v 9.505n 1.95v 19.495n 1.95v 19.505n 0.0v 29.495n 0.0v 29.505n 0.0v 39.495n 0.0v 39.505n 0.0v 49.495n 0.0v 49.505n 0.0v 59.495n 0.0v 59.505n 0.0v 69.495n 0.0v 69.505n 1.95v 79.495n 1.95v 79.505n 0.0v 89.495n 0.0v 89.505n 0.0v 99.495n 0.0v 99.505n 0.0v 109.495n 0.0v 109.505n 1.95v 119.495n 1.95v 119.505n 1.95v 129.495n 1.95v 129.505n 1.95v 139.495n 1.95v 139.505n 1.95v 149.495n 1.95v 149.505n 1.95v 159.495n 1.95v 159.505n 1.95v 169.495n 1.95v 169.505n 1.95v 179.495n 1.95v 179.505n 1.95v 189.495n 1.95v 189.505n 1.95v 199.495n 1.95v 199.505n 1.95v 209.495n 1.95v 209.505n 1.95v 219.495n 1.95v 219.505n 1.95v 229.495n 1.95v 229.505n 1.95v 239.495n 1.95v 239.505n 0.0v 249.495n 0.0v 249.505n 0.0v 259.495n 0.0v 259.505n 0.0v 269.495n 0.0v 269.505n 0.0v 279.495n 0.0v 279.505n 0.0v 289.495n 0.0v 289.505n 0.0v 299.495n 0.0v 299.505n 1.95v 309.495n 1.95v 309.505n 1.95v 319.495n 1.95v 319.505n 1.95v 329.495n 1.95v 329.505n 1.95v 339.495n 1.95v 339.505n 1.95v 349.495n 1.95v 349.505n 1.95v 359.495n 1.95v 359.505n 1.95v 369.495n 1.95v 369.505n 0.0v 379.495n 0.0v 379.505n 0.0v 389.495n 0.0v 389.505n 0.0v 399.495n 0.0v 399.505n 0.0v 409.495n 0.0v 409.505n 0.0v 419.495n 0.0v 419.505n 1.95v 429.495n 1.95v 429.505n 1.95v 439.495n 1.95v 439.505n 1.95v 449.495n 1.95v 449.505n 1.95v 459.495n 1.95v 459.505n 1.95v 469.495n 1.95v 469.505n 1.95v 479.495n 1.95v 479.505n 1.95v 489.495n 1.95v 489.505n 1.95v 499.495n 1.95v 499.505n 0.0v 509.495n 0.0v 509.505n 0.0v 519.495n 0.0v 519.505n 0.0v 529.495n 0.0v 529.505n 0.0v 539.495n 0.0v 539.505n 1.95v 549.495n 1.95v 549.505n 1.95v 559.495n 1.95v 559.505n 1.95v 569.495n 1.95v 569.505n 1.95v 579.495n 1.95v 579.505n 1.95v 589.495n 1.95v 589.505n 1.95v 599.495n 1.95v 599.505n 1.95v 609.495n 1.95v 609.505n 1.95v 619.495n 1.95v 619.505n 1.95v 629.495n 1.95v 629.505n 1.95v 639.495n 1.95v 639.505n 0.0v 649.495n 0.0v 649.505n 0.0v 659.495n 0.0v 659.505n 0.0v 669.495n 0.0v 669.505n 0.0v 679.495n 0.0v 679.505n 0.0v 689.495n 0.0v 689.505n 0.0v 699.495n 0.0v 699.505n 1.95v 709.495n 1.95v 709.505n 1.95v 719.495n 1.95v 719.505n 1.95v 729.495n 1.95v 729.505n 0.0v 739.495n 0.0v 739.505n 0.0v 749.495n 0.0v 749.505n 0.0v 759.495n 0.0v 759.505n 0.0v 769.495n 0.0v 769.505n 0.0v 779.495n 0.0v 779.505n 1.95v 789.495n 1.95v 789.505n 0.0v 799.495n 0.0v 799.505n 0.0v 809.495n 0.0v 809.505n 1.95v 819.495n 1.95v 819.505n 1.95v 829.495n 1.95v 829.505n 1.95v 839.495n 1.95v 839.505n 1.95v 849.495n 1.95v 849.505n 1.95v 859.495n 1.95v 859.505n 1.95v 869.495n 1.95v 869.505n 1.95v 879.495n 1.95v 879.505n 1.95v 889.495n 1.95v 889.505n 1.95v 899.495n 1.95v 899.505n 1.95v 909.495n 1.95v 909.505n 1.95v 919.495n 1.95v 919.505n 1.95v 929.495n 1.95v 929.505n 1.95v 939.495n 1.95v 939.505n 0.0v 949.495n 0.0v 949.505n 0.0v 959.495n 0.0v 959.505n 0.0v 969.495n 0.0v 969.505n 1.95v 979.495n 1.95v 979.505n 0.0v 989.495n 0.0v 989.505n 0.0v 999.495n 0.0v 999.505n 0.0v 1009.495n 0.0v 1009.505n 1.95v 1019.495n 1.95v 1019.505n 1.95v 1029.495n 1.95v 1029.505n 1.95v 1039.495n 1.95v 1039.505n 1.95v 1049.495n 1.95v 1049.505n 0.0v 1059.495n 0.0v 1059.505n 0.0v 1069.495n 0.0v 1069.505n 0.0v 1079.495n 0.0v 1079.505n 0.0v 1089.495n 0.0v 1089.505n 0.0v 1099.495n 0.0v 1099.505n 0.0v 1109.495n 0.0v 1109.505n 0.0v 1119.495n 0.0v 1119.505n 0.0v 1129.495n 0.0v 1129.505n 0.0v 1139.495n 0.0v 1139.505n 0.0v 1149.495n 0.0v 1149.505n 1.95v 1159.495n 1.95v 1159.505n 1.95v 1169.495n 1.95v 1169.505n 1.95v 1179.495n 1.95v 1179.505n 1.95v 1189.495n 1.95v 1189.505n 1.95v 1199.495n 1.95v 1199.505n 1.95v 1209.495n 1.95v 1209.505n 0.0v 1219.495n 0.0v 1219.505n 0.0v 1229.495n 0.0v 1229.505n 1.95v 1239.495n 1.95v 1239.505n 1.95v 1249.495n 1.95v 1249.505n 1.95v 1259.495n 1.95v 1259.505n 1.95v 1269.495n 1.95v 1269.505n 1.95v 1279.495n 1.95v 1279.505n 1.95v 1289.495n 1.95v 1289.505n 1.95v 1299.495n 1.95v 1299.505n 1.95v 1309.495n 1.95v 1309.505n 1.95v 1319.495n 1.95v 1319.505n 0.0v 1329.495n 0.0v 1329.505n 1.95v 1339.495n 1.95v 1339.505n 1.95v 1349.495n 1.95v 1349.505n 1.95v 1359.495n 1.95v 1359.505n 1.95v 1369.495n 1.95v 1369.505n 1.95v 1379.495n 1.95v 1379.505n 0.0v 1389.495n 0.0v 1389.505n 1.95v 1399.495n 1.95v 1399.505n 1.95v 1409.495n 1.95v 1409.505n 1.95v 1419.495n 1.95v 1419.505n 1.95v 1429.495n 1.95v 1429.505n 1.95v 1439.495n 1.95v 1439.505n 0.0v 1449.495n 0.0v 1449.505n 0.0v 1459.495n 0.0v 1459.505n 0.0v 1469.495n 0.0v 1469.505n 0.0v 1479.495n 0.0v 1479.505n 0.0v 1489.495n 0.0v 1489.505n 0.0v 1499.495n 0.0v 1499.505n 0.0v 1509.495n 0.0v 1509.505n 0.0v 1519.495n 0.0v 1519.505n 0.0v 1529.495n 0.0v 1529.505n 0.0v 1539.495n 0.0v 1539.505n 0.0v 1549.495n 0.0v 1549.505n 1.95v 1559.495n 1.95v 1559.505n 0.0v 1569.495n 0.0v 1569.505n 0.0v 1579.495n 0.0v 1579.505n 0.0v 1589.495n 0.0v 1589.505n 0.0v 1599.495n 0.0v 1599.505n 1.95v 1609.495n 1.95v 1609.505n 1.95v 1619.495n 1.95v 1619.505n 1.95v 1629.495n 1.95v 1629.505n 1.95v 1639.495n 1.95v 1639.505n 1.95v 1649.495n 1.95v 1649.505n 1.95v 1659.495n 1.95v 1659.505n 0.0v 1669.495n 0.0v 1669.505n 0.0v 1679.495n 0.0v 1679.505n 1.95v 1689.495n 1.95v 1689.505n 0.0v 1699.495n 0.0v 1699.505n 0.0v 1709.495n 0.0v 1709.505n 0.0v 1719.495n 0.0v 1719.505n 0.0v 1729.495n 0.0v 1729.505n 1.95v 1739.495n 1.95v 1739.505n 1.95v 1749.495n 1.95v 1749.505n 1.95v 1759.495n 1.95v 1759.505n 1.95v 1769.495n 1.95v 1769.505n 1.95v 1779.495n 1.95v 1779.505n 1.95v 1789.495n 1.95v 1789.505n 1.95v 1799.495n 1.95v 1799.505n 1.95v 1809.495n 1.95v 1809.505n 1.95v 1819.495n 1.95v 1819.505n 1.95v 1829.495n 1.95v 1829.505n 1.95v 1839.495n 1.95v 1839.505n 1.95v 1849.495n 1.95v 1849.505n 1.95v 1859.495n 1.95v 1859.505n 1.95v 1869.495n 1.95v 1869.505n 1.95v 1879.495n 1.95v 1879.505n 1.95v 1889.495n 1.95v 1889.505n 1.95v 1899.495n 1.95v 1899.505n 1.95v 1909.495n 1.95v 1909.505n 1.95v 1919.495n 1.95v 1919.505n 1.95v 1929.495n 1.95v 1929.505n 1.95v 1939.495n 1.95v 1939.505n 1.95v 1949.495n 1.95v 1949.505n 1.95v 1959.495n 1.95v 1959.505n 1.95v 1969.495n 1.95v 1969.505n 1.95v 1979.495n 1.95v 1979.505n 1.95v 1989.495n 1.95v 1989.505n 1.95v 1999.495n 1.95v 1999.505n 1.95v 2009.495n 1.95v 2009.505n 1.95v 2019.495n 1.95v 2019.505n 1.95v 2029.495n 1.95v 2029.505n 1.95v 2039.495n 1.95v 2039.505n 1.95v 2049.495n 1.95v 2049.505n 1.95v )
* (time, data): [(0, 0), (10, 1), (20, 0), (30, 0), (40, 0), (50, 0), (60, 0), (70, 0), (80, 1), (90, 1), (100, 1), (110, 1), (120, 1), (130, 1), (140, 1), (150, 1), (160, 1), (170, 1), (180, 1), (190, 1), (200, 1), (210, 1), (220, 1), (230, 1), (240, 1), (250, 1), (260, 1), (270, 1), (280, 1), (290, 1), (300, 1), (310, 1), (320, 1), (330, 1), (340, 1), (350, 1), (360, 1), (370, 0), (380, 0), (390, 0), (400, 1), (410, 1), (420, 0), (430, 0), (440, 0), (450, 0), (460, 0), (470, 0), (480, 0), (490, 0), (500, 0), (510, 0), (520, 0), (530, 0), (540, 1), (550, 1), (560, 1), (570, 1), (580, 1), (590, 0), (600, 0), (610, 0), (620, 0), (630, 0), (640, 0), (650, 0), (660, 0), (670, 0), (680, 0), (690, 0), (700, 0), (710, 0), (720, 0), (730, 0), (740, 0), (750, 0), (760, 0), (770, 1), (780, 1), (790, 0), (800, 0), (810, 1), (820, 1), (830, 1), (840, 1), (850, 0), (860, 0), (870, 0), (880, 0), (890, 0), (900, 0), (910, 0), (920, 0), (930, 0), (940, 1), (950, 1), (960, 1), (970, 0), (980, 0), (990, 0), (1000, 0), (1010, 0), (1020, 0), (1030, 1), (1040, 1), (1050, 1), (1060, 1), (1070, 1), (1080, 1), (1090, 1), (1100, 1), (1110, 1), (1120, 1), (1130, 1), (1140, 1), (1150, 0), (1160, 0), (1170, 0), (1180, 0), (1190, 0), (1200, 0), (1210, 0), (1220, 0), (1230, 1), (1240, 0), (1250, 0), (1260, 0), (1270, 0), (1280, 0), (1290, 0), (1300, 0), (1310, 0), (1320, 0), (1330, 1), (1340, 1), (1350, 1), (1360, 1), (1370, 1), (1380, 1), (1390, 0), (1400, 0), (1410, 0), (1420, 0), (1430, 0), (1440, 1), (1450, 1), (1460, 1), (1470, 1), (1480, 1), (1490, 1), (1500, 1), (1510, 1), (1520, 1), (1530, 1), (1540, 1), (1550, 1), (1560, 1), (1570, 1), (1580, 0), (1590, 0), (1600, 0), (1610, 0), (1620, 0), (1630, 0), (1640, 0), (1650, 0), (1660, 1), (1670, 1), (1680, 0), (1690, 1), (1700, 1), (1710, 1), (1720, 0), (1730, 0), (1740, 1), (1750, 1), (1760, 1), (1770, 1), (1780, 1), (1790, 1), (1800, 1), (1810, 1), (1820, 1), (1830, 1), (1840, 0), (1850, 1), (1860, 0), (1870, 0), (1880, 0), (1890, 0), (1900, 0), (1910, 0), (1920, 0), (1930, 0), (1940, 0), (1950, 0), (1960, 0), (1970, 1), (1980, 1), (1990, 1), (2000, 1), (2010, 1), (2020, 1), (2030, 1), (2040, 1), (2050, 1)]
Vdin0_8  din0_8  0 PWL (0n 0.0v 9.495n 0.0v 9.505n 1.95v 19.495n 1.95v 19.505n 0.0v 29.495n 0.0v 29.505n 0.0v 39.495n 0.0v 39.505n 0.0v 49.495n 0.0v 49.505n 0.0v 59.495n 0.0v 59.505n 0.0v 69.495n 0.0v 69.505n 0.0v 79.495n 0.0v 79.505n 1.95v 89.495n 1.95v 89.505n 1.95v 99.495n 1.95v 99.505n 1.95v 109.495n 1.95v 109.505n 1.95v 119.495n 1.95v 119.505n 1.95v 129.495n 1.95v 129.505n 1.95v 139.495n 1.95v 139.505n 1.95v 149.495n 1.95v 149.505n 1.95v 159.495n 1.95v 159.505n 1.95v 169.495n 1.95v 169.505n 1.95v 179.495n 1.95v 179.505n 1.95v 189.495n 1.95v 189.505n 1.95v 199.495n 1.95v 199.505n 1.95v 209.495n 1.95v 209.505n 1.95v 219.495n 1.95v 219.505n 1.95v 229.495n 1.95v 229.505n 1.95v 239.495n 1.95v 239.505n 1.95v 249.495n 1.95v 249.505n 1.95v 259.495n 1.95v 259.505n 1.95v 269.495n 1.95v 269.505n 1.95v 279.495n 1.95v 279.505n 1.95v 289.495n 1.95v 289.505n 1.95v 299.495n 1.95v 299.505n 1.95v 309.495n 1.95v 309.505n 1.95v 319.495n 1.95v 319.505n 1.95v 329.495n 1.95v 329.505n 1.95v 339.495n 1.95v 339.505n 1.95v 349.495n 1.95v 349.505n 1.95v 359.495n 1.95v 359.505n 1.95v 369.495n 1.95v 369.505n 0.0v 379.495n 0.0v 379.505n 0.0v 389.495n 0.0v 389.505n 0.0v 399.495n 0.0v 399.505n 1.95v 409.495n 1.95v 409.505n 1.95v 419.495n 1.95v 419.505n 0.0v 429.495n 0.0v 429.505n 0.0v 439.495n 0.0v 439.505n 0.0v 449.495n 0.0v 449.505n 0.0v 459.495n 0.0v 459.505n 0.0v 469.495n 0.0v 469.505n 0.0v 479.495n 0.0v 479.505n 0.0v 489.495n 0.0v 489.505n 0.0v 499.495n 0.0v 499.505n 0.0v 509.495n 0.0v 509.505n 0.0v 519.495n 0.0v 519.505n 0.0v 529.495n 0.0v 529.505n 0.0v 539.495n 0.0v 539.505n 1.95v 549.495n 1.95v 549.505n 1.95v 559.495n 1.95v 559.505n 1.95v 569.495n 1.95v 569.505n 1.95v 579.495n 1.95v 579.505n 1.95v 589.495n 1.95v 589.505n 0.0v 599.495n 0.0v 599.505n 0.0v 609.495n 0.0v 609.505n 0.0v 619.495n 0.0v 619.505n 0.0v 629.495n 0.0v 629.505n 0.0v 639.495n 0.0v 639.505n 0.0v 649.495n 0.0v 649.505n 0.0v 659.495n 0.0v 659.505n 0.0v 669.495n 0.0v 669.505n 0.0v 679.495n 0.0v 679.505n 0.0v 689.495n 0.0v 689.505n 0.0v 699.495n 0.0v 699.505n 0.0v 709.495n 0.0v 709.505n 0.0v 719.495n 0.0v 719.505n 0.0v 729.495n 0.0v 729.505n 0.0v 739.495n 0.0v 739.505n 0.0v 749.495n 0.0v 749.505n 0.0v 759.495n 0.0v 759.505n 0.0v 769.495n 0.0v 769.505n 1.95v 779.495n 1.95v 779.505n 1.95v 789.495n 1.95v 789.505n 0.0v 799.495n 0.0v 799.505n 0.0v 809.495n 0.0v 809.505n 1.95v 819.495n 1.95v 819.505n 1.95v 829.495n 1.95v 829.505n 1.95v 839.495n 1.95v 839.505n 1.95v 849.495n 1.95v 849.505n 0.0v 859.495n 0.0v 859.505n 0.0v 869.495n 0.0v 869.505n 0.0v 879.495n 0.0v 879.505n 0.0v 889.495n 0.0v 889.505n 0.0v 899.495n 0.0v 899.505n 0.0v 909.495n 0.0v 909.505n 0.0v 919.495n 0.0v 919.505n 0.0v 929.495n 0.0v 929.505n 0.0v 939.495n 0.0v 939.505n 1.95v 949.495n 1.95v 949.505n 1.95v 959.495n 1.95v 959.505n 1.95v 969.495n 1.95v 969.505n 0.0v 979.495n 0.0v 979.505n 0.0v 989.495n 0.0v 989.505n 0.0v 999.495n 0.0v 999.505n 0.0v 1009.495n 0.0v 1009.505n 0.0v 1019.495n 0.0v 1019.505n 0.0v 1029.495n 0.0v 1029.505n 1.95v 1039.495n 1.95v 1039.505n 1.95v 1049.495n 1.95v 1049.505n 1.95v 1059.495n 1.95v 1059.505n 1.95v 1069.495n 1.95v 1069.505n 1.95v 1079.495n 1.95v 1079.505n 1.95v 1089.495n 1.95v 1089.505n 1.95v 1099.495n 1.95v 1099.505n 1.95v 1109.495n 1.95v 1109.505n 1.95v 1119.495n 1.95v 1119.505n 1.95v 1129.495n 1.95v 1129.505n 1.95v 1139.495n 1.95v 1139.505n 1.95v 1149.495n 1.95v 1149.505n 0.0v 1159.495n 0.0v 1159.505n 0.0v 1169.495n 0.0v 1169.505n 0.0v 1179.495n 0.0v 1179.505n 0.0v 1189.495n 0.0v 1189.505n 0.0v 1199.495n 0.0v 1199.505n 0.0v 1209.495n 0.0v 1209.505n 0.0v 1219.495n 0.0v 1219.505n 0.0v 1229.495n 0.0v 1229.505n 1.95v 1239.495n 1.95v 1239.505n 0.0v 1249.495n 0.0v 1249.505n 0.0v 1259.495n 0.0v 1259.505n 0.0v 1269.495n 0.0v 1269.505n 0.0v 1279.495n 0.0v 1279.505n 0.0v 1289.495n 0.0v 1289.505n 0.0v 1299.495n 0.0v 1299.505n 0.0v 1309.495n 0.0v 1309.505n 0.0v 1319.495n 0.0v 1319.505n 0.0v 1329.495n 0.0v 1329.505n 1.95v 1339.495n 1.95v 1339.505n 1.95v 1349.495n 1.95v 1349.505n 1.95v 1359.495n 1.95v 1359.505n 1.95v 1369.495n 1.95v 1369.505n 1.95v 1379.495n 1.95v 1379.505n 1.95v 1389.495n 1.95v 1389.505n 0.0v 1399.495n 0.0v 1399.505n 0.0v 1409.495n 0.0v 1409.505n 0.0v 1419.495n 0.0v 1419.505n 0.0v 1429.495n 0.0v 1429.505n 0.0v 1439.495n 0.0v 1439.505n 1.95v 1449.495n 1.95v 1449.505n 1.95v 1459.495n 1.95v 1459.505n 1.95v 1469.495n 1.95v 1469.505n 1.95v 1479.495n 1.95v 1479.505n 1.95v 1489.495n 1.95v 1489.505n 1.95v 1499.495n 1.95v 1499.505n 1.95v 1509.495n 1.95v 1509.505n 1.95v 1519.495n 1.95v 1519.505n 1.95v 1529.495n 1.95v 1529.505n 1.95v 1539.495n 1.95v 1539.505n 1.95v 1549.495n 1.95v 1549.505n 1.95v 1559.495n 1.95v 1559.505n 1.95v 1569.495n 1.95v 1569.505n 1.95v 1579.495n 1.95v 1579.505n 0.0v 1589.495n 0.0v 1589.505n 0.0v 1599.495n 0.0v 1599.505n 0.0v 1609.495n 0.0v 1609.505n 0.0v 1619.495n 0.0v 1619.505n 0.0v 1629.495n 0.0v 1629.505n 0.0v 1639.495n 0.0v 1639.505n 0.0v 1649.495n 0.0v 1649.505n 0.0v 1659.495n 0.0v 1659.505n 1.95v 1669.495n 1.95v 1669.505n 1.95v 1679.495n 1.95v 1679.505n 0.0v 1689.495n 0.0v 1689.505n 1.95v 1699.495n 1.95v 1699.505n 1.95v 1709.495n 1.95v 1709.505n 1.95v 1719.495n 1.95v 1719.505n 0.0v 1729.495n 0.0v 1729.505n 0.0v 1739.495n 0.0v 1739.505n 1.95v 1749.495n 1.95v 1749.505n 1.95v 1759.495n 1.95v 1759.505n 1.95v 1769.495n 1.95v 1769.505n 1.95v 1779.495n 1.95v 1779.505n 1.95v 1789.495n 1.95v 1789.505n 1.95v 1799.495n 1.95v 1799.505n 1.95v 1809.495n 1.95v 1809.505n 1.95v 1819.495n 1.95v 1819.505n 1.95v 1829.495n 1.95v 1829.505n 1.95v 1839.495n 1.95v 1839.505n 0.0v 1849.495n 0.0v 1849.505n 1.95v 1859.495n 1.95v 1859.505n 0.0v 1869.495n 0.0v 1869.505n 0.0v 1879.495n 0.0v 1879.505n 0.0v 1889.495n 0.0v 1889.505n 0.0v 1899.495n 0.0v 1899.505n 0.0v 1909.495n 0.0v 1909.505n 0.0v 1919.495n 0.0v 1919.505n 0.0v 1929.495n 0.0v 1929.505n 0.0v 1939.495n 0.0v 1939.505n 0.0v 1949.495n 0.0v 1949.505n 0.0v 1959.495n 0.0v 1959.505n 0.0v 1969.495n 0.0v 1969.505n 1.95v 1979.495n 1.95v 1979.505n 1.95v 1989.495n 1.95v 1989.505n 1.95v 1999.495n 1.95v 1999.505n 1.95v 2009.495n 1.95v 2009.505n 1.95v 2019.495n 1.95v 2019.505n 1.95v 2029.495n 1.95v 2029.505n 1.95v 2039.495n 1.95v 2039.505n 1.95v 2049.495n 1.95v 2049.505n 1.95v )
* (time, data): [(0, 0), (10, 1), (20, 0), (30, 1), (40, 1), (50, 1), (60, 1), (70, 0), (80, 1), (90, 1), (100, 1), (110, 0), (120, 0), (130, 0), (140, 0), (150, 0), (160, 0), (170, 0), (180, 0), (190, 0), (200, 0), (210, 0), (220, 0), (230, 0), (240, 0), (250, 0), (260, 0), (270, 1), (280, 1), (290, 1), (300, 0), (310, 0), (320, 0), (330, 0), (340, 0), (350, 0), (360, 0), (370, 0), (380, 0), (390, 0), (400, 0), (410, 0), (420, 1), (430, 1), (440, 1), (450, 1), (460, 1), (470, 1), (480, 1), (490, 1), (500, 0), (510, 0), (520, 0), (530, 0), (540, 0), (550, 1), (560, 1), (570, 1), (580, 1), (590, 1), (600, 1), (610, 1), (620, 1), (630, 1), (640, 1), (650, 1), (660, 1), (670, 1), (680, 1), (690, 1), (700, 0), (710, 0), (720, 0), (730, 1), (740, 1), (750, 1), (760, 1), (770, 0), (780, 0), (790, 0), (800, 0), (810, 0), (820, 0), (830, 1), (840, 1), (850, 1), (860, 1), (870, 1), (880, 1), (890, 1), (900, 1), (910, 1), (920, 1), (930, 1), (940, 0), (950, 1), (960, 1), (970, 1), (980, 0), (990, 0), (1000, 0), (1010, 1), (1020, 1), (1030, 1), (1040, 1), (1050, 1), (1060, 1), (1070, 1), (1080, 1), (1090, 1), (1100, 1), (1110, 1), (1120, 1), (1130, 1), (1140, 1), (1150, 1), (1160, 1), (1170, 1), (1180, 1), (1190, 1), (1200, 1), (1210, 1), (1220, 1), (1230, 1), (1240, 1), (1250, 0), (1260, 0), (1270, 0), (1280, 0), (1290, 0), (1300, 0), (1310, 0), (1320, 0), (1330, 0), (1340, 0), (1350, 0), (1360, 0), (1370, 0), (1380, 0), (1390, 0), (1400, 0), (1410, 0), (1420, 1), (1430, 1), (1440, 0), (1450, 0), (1460, 0), (1470, 0), (1480, 0), (1490, 0), (1500, 0), (1510, 0), (1520, 0), (1530, 0), (1540, 0), (1550, 1), (1560, 1), (1570, 1), (1580, 1), (1590, 1), (1600, 1), (1610, 1), (1620, 1), (1630, 1), (1640, 1), (1650, 1), (1660, 0), (1670, 0), (1680, 1), (1690, 1), (1700, 1), (1710, 1), (1720, 1), (1730, 1), (1740, 0), (1750, 0), (1760, 1), (1770, 1), (1780, 1), (1790, 1), (1800, 1), (1810, 1), (1820, 1), (1830, 1), (1840, 1), (1850, 0), (1860, 0), (1870, 0), (1880, 0), (1890, 0), (1900, 0), (1910, 0), (1920, 0), (1930, 0), (1940, 0), (1950, 1), (1960, 1), (1970, 1), (1980, 1), (1990, 0), (2000, 0), (2010, 0), (2020, 0), (2030, 0), (2040, 0), (2050, 0)]
Vdin0_9  din0_9  0 PWL (0n 0.0v 9.495n 0.0v 9.505n 1.95v 19.495n 1.95v 19.505n 0.0v 29.495n 0.0v 29.505n 1.95v 39.495n 1.95v 39.505n 1.95v 49.495n 1.95v 49.505n 1.95v 59.495n 1.95v 59.505n 1.95v 69.495n 1.95v 69.505n 0.0v 79.495n 0.0v 79.505n 1.95v 89.495n 1.95v 89.505n 1.95v 99.495n 1.95v 99.505n 1.95v 109.495n 1.95v 109.505n 0.0v 119.495n 0.0v 119.505n 0.0v 129.495n 0.0v 129.505n 0.0v 139.495n 0.0v 139.505n 0.0v 149.495n 0.0v 149.505n 0.0v 159.495n 0.0v 159.505n 0.0v 169.495n 0.0v 169.505n 0.0v 179.495n 0.0v 179.505n 0.0v 189.495n 0.0v 189.505n 0.0v 199.495n 0.0v 199.505n 0.0v 209.495n 0.0v 209.505n 0.0v 219.495n 0.0v 219.505n 0.0v 229.495n 0.0v 229.505n 0.0v 239.495n 0.0v 239.505n 0.0v 249.495n 0.0v 249.505n 0.0v 259.495n 0.0v 259.505n 0.0v 269.495n 0.0v 269.505n 1.95v 279.495n 1.95v 279.505n 1.95v 289.495n 1.95v 289.505n 1.95v 299.495n 1.95v 299.505n 0.0v 309.495n 0.0v 309.505n 0.0v 319.495n 0.0v 319.505n 0.0v 329.495n 0.0v 329.505n 0.0v 339.495n 0.0v 339.505n 0.0v 349.495n 0.0v 349.505n 0.0v 359.495n 0.0v 359.505n 0.0v 369.495n 0.0v 369.505n 0.0v 379.495n 0.0v 379.505n 0.0v 389.495n 0.0v 389.505n 0.0v 399.495n 0.0v 399.505n 0.0v 409.495n 0.0v 409.505n 0.0v 419.495n 0.0v 419.505n 1.95v 429.495n 1.95v 429.505n 1.95v 439.495n 1.95v 439.505n 1.95v 449.495n 1.95v 449.505n 1.95v 459.495n 1.95v 459.505n 1.95v 469.495n 1.95v 469.505n 1.95v 479.495n 1.95v 479.505n 1.95v 489.495n 1.95v 489.505n 1.95v 499.495n 1.95v 499.505n 0.0v 509.495n 0.0v 509.505n 0.0v 519.495n 0.0v 519.505n 0.0v 529.495n 0.0v 529.505n 0.0v 539.495n 0.0v 539.505n 0.0v 549.495n 0.0v 549.505n 1.95v 559.495n 1.95v 559.505n 1.95v 569.495n 1.95v 569.505n 1.95v 579.495n 1.95v 579.505n 1.95v 589.495n 1.95v 589.505n 1.95v 599.495n 1.95v 599.505n 1.95v 609.495n 1.95v 609.505n 1.95v 619.495n 1.95v 619.505n 1.95v 629.495n 1.95v 629.505n 1.95v 639.495n 1.95v 639.505n 1.95v 649.495n 1.95v 649.505n 1.95v 659.495n 1.95v 659.505n 1.95v 669.495n 1.95v 669.505n 1.95v 679.495n 1.95v 679.505n 1.95v 689.495n 1.95v 689.505n 1.95v 699.495n 1.95v 699.505n 0.0v 709.495n 0.0v 709.505n 0.0v 719.495n 0.0v 719.505n 0.0v 729.495n 0.0v 729.505n 1.95v 739.495n 1.95v 739.505n 1.95v 749.495n 1.95v 749.505n 1.95v 759.495n 1.95v 759.505n 1.95v 769.495n 1.95v 769.505n 0.0v 779.495n 0.0v 779.505n 0.0v 789.495n 0.0v 789.505n 0.0v 799.495n 0.0v 799.505n 0.0v 809.495n 0.0v 809.505n 0.0v 819.495n 0.0v 819.505n 0.0v 829.495n 0.0v 829.505n 1.95v 839.495n 1.95v 839.505n 1.95v 849.495n 1.95v 849.505n 1.95v 859.495n 1.95v 859.505n 1.95v 869.495n 1.95v 869.505n 1.95v 879.495n 1.95v 879.505n 1.95v 889.495n 1.95v 889.505n 1.95v 899.495n 1.95v 899.505n 1.95v 909.495n 1.95v 909.505n 1.95v 919.495n 1.95v 919.505n 1.95v 929.495n 1.95v 929.505n 1.95v 939.495n 1.95v 939.505n 0.0v 949.495n 0.0v 949.505n 1.95v 959.495n 1.95v 959.505n 1.95v 969.495n 1.95v 969.505n 1.95v 979.495n 1.95v 979.505n 0.0v 989.495n 0.0v 989.505n 0.0v 999.495n 0.0v 999.505n 0.0v 1009.495n 0.0v 1009.505n 1.95v 1019.495n 1.95v 1019.505n 1.95v 1029.495n 1.95v 1029.505n 1.95v 1039.495n 1.95v 1039.505n 1.95v 1049.495n 1.95v 1049.505n 1.95v 1059.495n 1.95v 1059.505n 1.95v 1069.495n 1.95v 1069.505n 1.95v 1079.495n 1.95v 1079.505n 1.95v 1089.495n 1.95v 1089.505n 1.95v 1099.495n 1.95v 1099.505n 1.95v 1109.495n 1.95v 1109.505n 1.95v 1119.495n 1.95v 1119.505n 1.95v 1129.495n 1.95v 1129.505n 1.95v 1139.495n 1.95v 1139.505n 1.95v 1149.495n 1.95v 1149.505n 1.95v 1159.495n 1.95v 1159.505n 1.95v 1169.495n 1.95v 1169.505n 1.95v 1179.495n 1.95v 1179.505n 1.95v 1189.495n 1.95v 1189.505n 1.95v 1199.495n 1.95v 1199.505n 1.95v 1209.495n 1.95v 1209.505n 1.95v 1219.495n 1.95v 1219.505n 1.95v 1229.495n 1.95v 1229.505n 1.95v 1239.495n 1.95v 1239.505n 1.95v 1249.495n 1.95v 1249.505n 0.0v 1259.495n 0.0v 1259.505n 0.0v 1269.495n 0.0v 1269.505n 0.0v 1279.495n 0.0v 1279.505n 0.0v 1289.495n 0.0v 1289.505n 0.0v 1299.495n 0.0v 1299.505n 0.0v 1309.495n 0.0v 1309.505n 0.0v 1319.495n 0.0v 1319.505n 0.0v 1329.495n 0.0v 1329.505n 0.0v 1339.495n 0.0v 1339.505n 0.0v 1349.495n 0.0v 1349.505n 0.0v 1359.495n 0.0v 1359.505n 0.0v 1369.495n 0.0v 1369.505n 0.0v 1379.495n 0.0v 1379.505n 0.0v 1389.495n 0.0v 1389.505n 0.0v 1399.495n 0.0v 1399.505n 0.0v 1409.495n 0.0v 1409.505n 0.0v 1419.495n 0.0v 1419.505n 1.95v 1429.495n 1.95v 1429.505n 1.95v 1439.495n 1.95v 1439.505n 0.0v 1449.495n 0.0v 1449.505n 0.0v 1459.495n 0.0v 1459.505n 0.0v 1469.495n 0.0v 1469.505n 0.0v 1479.495n 0.0v 1479.505n 0.0v 1489.495n 0.0v 1489.505n 0.0v 1499.495n 0.0v 1499.505n 0.0v 1509.495n 0.0v 1509.505n 0.0v 1519.495n 0.0v 1519.505n 0.0v 1529.495n 0.0v 1529.505n 0.0v 1539.495n 0.0v 1539.505n 0.0v 1549.495n 0.0v 1549.505n 1.95v 1559.495n 1.95v 1559.505n 1.95v 1569.495n 1.95v 1569.505n 1.95v 1579.495n 1.95v 1579.505n 1.95v 1589.495n 1.95v 1589.505n 1.95v 1599.495n 1.95v 1599.505n 1.95v 1609.495n 1.95v 1609.505n 1.95v 1619.495n 1.95v 1619.505n 1.95v 1629.495n 1.95v 1629.505n 1.95v 1639.495n 1.95v 1639.505n 1.95v 1649.495n 1.95v 1649.505n 1.95v 1659.495n 1.95v 1659.505n 0.0v 1669.495n 0.0v 1669.505n 0.0v 1679.495n 0.0v 1679.505n 1.95v 1689.495n 1.95v 1689.505n 1.95v 1699.495n 1.95v 1699.505n 1.95v 1709.495n 1.95v 1709.505n 1.95v 1719.495n 1.95v 1719.505n 1.95v 1729.495n 1.95v 1729.505n 1.95v 1739.495n 1.95v 1739.505n 0.0v 1749.495n 0.0v 1749.505n 0.0v 1759.495n 0.0v 1759.505n 1.95v 1769.495n 1.95v 1769.505n 1.95v 1779.495n 1.95v 1779.505n 1.95v 1789.495n 1.95v 1789.505n 1.95v 1799.495n 1.95v 1799.505n 1.95v 1809.495n 1.95v 1809.505n 1.95v 1819.495n 1.95v 1819.505n 1.95v 1829.495n 1.95v 1829.505n 1.95v 1839.495n 1.95v 1839.505n 1.95v 1849.495n 1.95v 1849.505n 0.0v 1859.495n 0.0v 1859.505n 0.0v 1869.495n 0.0v 1869.505n 0.0v 1879.495n 0.0v 1879.505n 0.0v 1889.495n 0.0v 1889.505n 0.0v 1899.495n 0.0v 1899.505n 0.0v 1909.495n 0.0v 1909.505n 0.0v 1919.495n 0.0v 1919.505n 0.0v 1929.495n 0.0v 1929.505n 0.0v 1939.495n 0.0v 1939.505n 0.0v 1949.495n 0.0v 1949.505n 1.95v 1959.495n 1.95v 1959.505n 1.95v 1969.495n 1.95v 1969.505n 1.95v 1979.495n 1.95v 1979.505n 1.95v 1989.495n 1.95v 1989.505n 0.0v 1999.495n 0.0v 1999.505n 0.0v 2009.495n 0.0v 2009.505n 0.0v 2019.495n 0.0v 2019.505n 0.0v 2029.495n 0.0v 2029.505n 0.0v 2039.495n 0.0v 2039.505n 0.0v 2049.495n 0.0v 2049.505n 0.0v )
* (time, data): [(0, 0), (10, 0), (20, 1), (30, 1), (40, 1), (50, 1), (60, 0), (70, 0), (80, 1), (90, 1), (100, 1), (110, 0), (120, 0), (130, 0), (140, 0), (150, 0), (160, 1), (170, 1), (180, 1), (190, 1), (200, 1), (210, 1), (220, 1), (230, 1), (240, 0), (250, 0), (260, 0), (270, 0), (280, 0), (290, 0), (300, 0), (310, 0), (320, 0), (330, 0), (340, 0), (350, 0), (360, 0), (370, 0), (380, 0), (390, 0), (400, 1), (410, 1), (420, 1), (430, 1), (440, 1), (450, 1), (460, 1), (470, 1), (480, 1), (490, 1), (500, 1), (510, 0), (520, 0), (530, 0), (540, 1), (550, 1), (560, 1), (570, 1), (580, 1), (590, 0), (600, 0), (610, 0), (620, 0), (630, 0), (640, 0), (650, 1), (660, 1), (670, 0), (680, 0), (690, 0), (700, 1), (710, 1), (720, 1), (730, 1), (740, 1), (750, 0), (760, 0), (770, 1), (780, 1), (790, 1), (800, 1), (810, 1), (820, 1), (830, 0), (840, 0), (850, 1), (860, 1), (870, 1), (880, 1), (890, 1), (900, 1), (910, 1), (920, 1), (930, 1), (940, 0), (950, 0), (960, 0), (970, 0), (980, 1), (990, 0), (1000, 0), (1010, 0), (1020, 0), (1030, 0), (1040, 0), (1050, 0), (1060, 0), (1070, 0), (1080, 0), (1090, 0), (1100, 0), (1110, 0), (1120, 0), (1130, 0), (1140, 0), (1150, 1), (1160, 1), (1170, 1), (1180, 1), (1190, 1), (1200, 1), (1210, 1), (1220, 1), (1230, 1), (1240, 0), (1250, 1), (1260, 1), (1270, 1), (1280, 1), (1290, 0), (1300, 0), (1310, 0), (1320, 0), (1330, 0), (1340, 1), (1350, 1), (1360, 1), (1370, 1), (1380, 1), (1390, 0), (1400, 0), (1410, 0), (1420, 0), (1430, 0), (1440, 0), (1450, 0), (1460, 0), (1470, 0), (1480, 0), (1490, 0), (1500, 0), (1510, 0), (1520, 0), (1530, 0), (1540, 0), (1550, 0), (1560, 1), (1570, 1), (1580, 0), (1590, 0), (1600, 0), (1610, 0), (1620, 0), (1630, 0), (1640, 0), (1650, 0), (1660, 0), (1670, 0), (1680, 0), (1690, 0), (1700, 0), (1710, 0), (1720, 0), (1730, 0), (1740, 0), (1750, 0), (1760, 0), (1770, 0), (1780, 0), (1790, 0), (1800, 0), (1810, 1), (1820, 1), (1830, 1), (1840, 1), (1850, 0), (1860, 0), (1870, 0), (1880, 0), (1890, 0), (1900, 0), (1910, 0), (1920, 0), (1930, 0), (1940, 0), (1950, 1), (1960, 1), (1970, 1), (1980, 1), (1990, 1), (2000, 1), (2010, 1), (2020, 1), (2030, 1), (2040, 1), (2050, 1)]
Vdin0_10  din0_10  0 PWL (0n 0.0v 9.495n 0.0v 9.505n 0.0v 19.495n 0.0v 19.505n 1.95v 29.495n 1.95v 29.505n 1.95v 39.495n 1.95v 39.505n 1.95v 49.495n 1.95v 49.505n 1.95v 59.495n 1.95v 59.505n 0.0v 69.495n 0.0v 69.505n 0.0v 79.495n 0.0v 79.505n 1.95v 89.495n 1.95v 89.505n 1.95v 99.495n 1.95v 99.505n 1.95v 109.495n 1.95v 109.505n 0.0v 119.495n 0.0v 119.505n 0.0v 129.495n 0.0v 129.505n 0.0v 139.495n 0.0v 139.505n 0.0v 149.495n 0.0v 149.505n 0.0v 159.495n 0.0v 159.505n 1.95v 169.495n 1.95v 169.505n 1.95v 179.495n 1.95v 179.505n 1.95v 189.495n 1.95v 189.505n 1.95v 199.495n 1.95v 199.505n 1.95v 209.495n 1.95v 209.505n 1.95v 219.495n 1.95v 219.505n 1.95v 229.495n 1.95v 229.505n 1.95v 239.495n 1.95v 239.505n 0.0v 249.495n 0.0v 249.505n 0.0v 259.495n 0.0v 259.505n 0.0v 269.495n 0.0v 269.505n 0.0v 279.495n 0.0v 279.505n 0.0v 289.495n 0.0v 289.505n 0.0v 299.495n 0.0v 299.505n 0.0v 309.495n 0.0v 309.505n 0.0v 319.495n 0.0v 319.505n 0.0v 329.495n 0.0v 329.505n 0.0v 339.495n 0.0v 339.505n 0.0v 349.495n 0.0v 349.505n 0.0v 359.495n 0.0v 359.505n 0.0v 369.495n 0.0v 369.505n 0.0v 379.495n 0.0v 379.505n 0.0v 389.495n 0.0v 389.505n 0.0v 399.495n 0.0v 399.505n 1.95v 409.495n 1.95v 409.505n 1.95v 419.495n 1.95v 419.505n 1.95v 429.495n 1.95v 429.505n 1.95v 439.495n 1.95v 439.505n 1.95v 449.495n 1.95v 449.505n 1.95v 459.495n 1.95v 459.505n 1.95v 469.495n 1.95v 469.505n 1.95v 479.495n 1.95v 479.505n 1.95v 489.495n 1.95v 489.505n 1.95v 499.495n 1.95v 499.505n 1.95v 509.495n 1.95v 509.505n 0.0v 519.495n 0.0v 519.505n 0.0v 529.495n 0.0v 529.505n 0.0v 539.495n 0.0v 539.505n 1.95v 549.495n 1.95v 549.505n 1.95v 559.495n 1.95v 559.505n 1.95v 569.495n 1.95v 569.505n 1.95v 579.495n 1.95v 579.505n 1.95v 589.495n 1.95v 589.505n 0.0v 599.495n 0.0v 599.505n 0.0v 609.495n 0.0v 609.505n 0.0v 619.495n 0.0v 619.505n 0.0v 629.495n 0.0v 629.505n 0.0v 639.495n 0.0v 639.505n 0.0v 649.495n 0.0v 649.505n 1.95v 659.495n 1.95v 659.505n 1.95v 669.495n 1.95v 669.505n 0.0v 679.495n 0.0v 679.505n 0.0v 689.495n 0.0v 689.505n 0.0v 699.495n 0.0v 699.505n 1.95v 709.495n 1.95v 709.505n 1.95v 719.495n 1.95v 719.505n 1.95v 729.495n 1.95v 729.505n 1.95v 739.495n 1.95v 739.505n 1.95v 749.495n 1.95v 749.505n 0.0v 759.495n 0.0v 759.505n 0.0v 769.495n 0.0v 769.505n 1.95v 779.495n 1.95v 779.505n 1.95v 789.495n 1.95v 789.505n 1.95v 799.495n 1.95v 799.505n 1.95v 809.495n 1.95v 809.505n 1.95v 819.495n 1.95v 819.505n 1.95v 829.495n 1.95v 829.505n 0.0v 839.495n 0.0v 839.505n 0.0v 849.495n 0.0v 849.505n 1.95v 859.495n 1.95v 859.505n 1.95v 869.495n 1.95v 869.505n 1.95v 879.495n 1.95v 879.505n 1.95v 889.495n 1.95v 889.505n 1.95v 899.495n 1.95v 899.505n 1.95v 909.495n 1.95v 909.505n 1.95v 919.495n 1.95v 919.505n 1.95v 929.495n 1.95v 929.505n 1.95v 939.495n 1.95v 939.505n 0.0v 949.495n 0.0v 949.505n 0.0v 959.495n 0.0v 959.505n 0.0v 969.495n 0.0v 969.505n 0.0v 979.495n 0.0v 979.505n 1.95v 989.495n 1.95v 989.505n 0.0v 999.495n 0.0v 999.505n 0.0v 1009.495n 0.0v 1009.505n 0.0v 1019.495n 0.0v 1019.505n 0.0v 1029.495n 0.0v 1029.505n 0.0v 1039.495n 0.0v 1039.505n 0.0v 1049.495n 0.0v 1049.505n 0.0v 1059.495n 0.0v 1059.505n 0.0v 1069.495n 0.0v 1069.505n 0.0v 1079.495n 0.0v 1079.505n 0.0v 1089.495n 0.0v 1089.505n 0.0v 1099.495n 0.0v 1099.505n 0.0v 1109.495n 0.0v 1109.505n 0.0v 1119.495n 0.0v 1119.505n 0.0v 1129.495n 0.0v 1129.505n 0.0v 1139.495n 0.0v 1139.505n 0.0v 1149.495n 0.0v 1149.505n 1.95v 1159.495n 1.95v 1159.505n 1.95v 1169.495n 1.95v 1169.505n 1.95v 1179.495n 1.95v 1179.505n 1.95v 1189.495n 1.95v 1189.505n 1.95v 1199.495n 1.95v 1199.505n 1.95v 1209.495n 1.95v 1209.505n 1.95v 1219.495n 1.95v 1219.505n 1.95v 1229.495n 1.95v 1229.505n 1.95v 1239.495n 1.95v 1239.505n 0.0v 1249.495n 0.0v 1249.505n 1.95v 1259.495n 1.95v 1259.505n 1.95v 1269.495n 1.95v 1269.505n 1.95v 1279.495n 1.95v 1279.505n 1.95v 1289.495n 1.95v 1289.505n 0.0v 1299.495n 0.0v 1299.505n 0.0v 1309.495n 0.0v 1309.505n 0.0v 1319.495n 0.0v 1319.505n 0.0v 1329.495n 0.0v 1329.505n 0.0v 1339.495n 0.0v 1339.505n 1.95v 1349.495n 1.95v 1349.505n 1.95v 1359.495n 1.95v 1359.505n 1.95v 1369.495n 1.95v 1369.505n 1.95v 1379.495n 1.95v 1379.505n 1.95v 1389.495n 1.95v 1389.505n 0.0v 1399.495n 0.0v 1399.505n 0.0v 1409.495n 0.0v 1409.505n 0.0v 1419.495n 0.0v 1419.505n 0.0v 1429.495n 0.0v 1429.505n 0.0v 1439.495n 0.0v 1439.505n 0.0v 1449.495n 0.0v 1449.505n 0.0v 1459.495n 0.0v 1459.505n 0.0v 1469.495n 0.0v 1469.505n 0.0v 1479.495n 0.0v 1479.505n 0.0v 1489.495n 0.0v 1489.505n 0.0v 1499.495n 0.0v 1499.505n 0.0v 1509.495n 0.0v 1509.505n 0.0v 1519.495n 0.0v 1519.505n 0.0v 1529.495n 0.0v 1529.505n 0.0v 1539.495n 0.0v 1539.505n 0.0v 1549.495n 0.0v 1549.505n 0.0v 1559.495n 0.0v 1559.505n 1.95v 1569.495n 1.95v 1569.505n 1.95v 1579.495n 1.95v 1579.505n 0.0v 1589.495n 0.0v 1589.505n 0.0v 1599.495n 0.0v 1599.505n 0.0v 1609.495n 0.0v 1609.505n 0.0v 1619.495n 0.0v 1619.505n 0.0v 1629.495n 0.0v 1629.505n 0.0v 1639.495n 0.0v 1639.505n 0.0v 1649.495n 0.0v 1649.505n 0.0v 1659.495n 0.0v 1659.505n 0.0v 1669.495n 0.0v 1669.505n 0.0v 1679.495n 0.0v 1679.505n 0.0v 1689.495n 0.0v 1689.505n 0.0v 1699.495n 0.0v 1699.505n 0.0v 1709.495n 0.0v 1709.505n 0.0v 1719.495n 0.0v 1719.505n 0.0v 1729.495n 0.0v 1729.505n 0.0v 1739.495n 0.0v 1739.505n 0.0v 1749.495n 0.0v 1749.505n 0.0v 1759.495n 0.0v 1759.505n 0.0v 1769.495n 0.0v 1769.505n 0.0v 1779.495n 0.0v 1779.505n 0.0v 1789.495n 0.0v 1789.505n 0.0v 1799.495n 0.0v 1799.505n 0.0v 1809.495n 0.0v 1809.505n 1.95v 1819.495n 1.95v 1819.505n 1.95v 1829.495n 1.95v 1829.505n 1.95v 1839.495n 1.95v 1839.505n 1.95v 1849.495n 1.95v 1849.505n 0.0v 1859.495n 0.0v 1859.505n 0.0v 1869.495n 0.0v 1869.505n 0.0v 1879.495n 0.0v 1879.505n 0.0v 1889.495n 0.0v 1889.505n 0.0v 1899.495n 0.0v 1899.505n 0.0v 1909.495n 0.0v 1909.505n 0.0v 1919.495n 0.0v 1919.505n 0.0v 1929.495n 0.0v 1929.505n 0.0v 1939.495n 0.0v 1939.505n 0.0v 1949.495n 0.0v 1949.505n 1.95v 1959.495n 1.95v 1959.505n 1.95v 1969.495n 1.95v 1969.505n 1.95v 1979.495n 1.95v 1979.505n 1.95v 1989.495n 1.95v 1989.505n 1.95v 1999.495n 1.95v 1999.505n 1.95v 2009.495n 1.95v 2009.505n 1.95v 2019.495n 1.95v 2019.505n 1.95v 2029.495n 1.95v 2029.505n 1.95v 2039.495n 1.95v 2039.505n 1.95v 2049.495n 1.95v 2049.505n 1.95v )
* (time, data): [(0, 0), (10, 0), (20, 1), (30, 0), (40, 0), (50, 0), (60, 0), (70, 0), (80, 1), (90, 1), (100, 1), (110, 0), (120, 0), (130, 0), (140, 0), (150, 0), (160, 1), (170, 1), (180, 1), (190, 1), (200, 1), (210, 1), (220, 1), (230, 1), (240, 1), (250, 1), (260, 1), (270, 0), (280, 0), (290, 0), (300, 1), (310, 1), (320, 1), (330, 1), (340, 1), (350, 1), (360, 1), (370, 0), (380, 0), (390, 0), (400, 1), (410, 1), (420, 0), (430, 0), (440, 0), (450, 0), (460, 0), (470, 0), (480, 0), (490, 0), (500, 1), (510, 1), (520, 1), (530, 1), (540, 1), (550, 1), (560, 1), (570, 1), (580, 1), (590, 1), (600, 1), (610, 1), (620, 1), (630, 1), (640, 1), (650, 0), (660, 0), (670, 1), (680, 1), (690, 1), (700, 1), (710, 1), (720, 1), (730, 0), (740, 0), (750, 1), (760, 1), (770, 1), (780, 1), (790, 1), (800, 1), (810, 1), (820, 1), (830, 1), (840, 1), (850, 1), (860, 1), (870, 1), (880, 1), (890, 1), (900, 1), (910, 1), (920, 1), (930, 1), (940, 0), (950, 1), (960, 1), (970, 0), (980, 0), (990, 0), (1000, 0), (1010, 1), (1020, 1), (1030, 0), (1040, 0), (1050, 1), (1060, 1), (1070, 1), (1080, 1), (1090, 1), (1100, 1), (1110, 1), (1120, 1), (1130, 1), (1140, 1), (1150, 0), (1160, 0), (1170, 0), (1180, 0), (1190, 0), (1200, 0), (1210, 1), (1220, 1), (1230, 1), (1240, 1), (1250, 1), (1260, 1), (1270, 1), (1280, 1), (1290, 1), (1300, 1), (1310, 1), (1320, 0), (1330, 0), (1340, 1), (1350, 1), (1360, 1), (1370, 1), (1380, 0), (1390, 1), (1400, 1), (1410, 1), (1420, 0), (1430, 0), (1440, 1), (1450, 1), (1460, 1), (1470, 1), (1480, 1), (1490, 1), (1500, 1), (1510, 1), (1520, 1), (1530, 1), (1540, 1), (1550, 0), (1560, 1), (1570, 1), (1580, 0), (1590, 0), (1600, 0), (1610, 1), (1620, 1), (1630, 1), (1640, 1), (1650, 1), (1660, 1), (1670, 1), (1680, 0), (1690, 1), (1700, 1), (1710, 1), (1720, 1), (1730, 0), (1740, 0), (1750, 0), (1760, 1), (1770, 1), (1780, 1), (1790, 1), (1800, 1), (1810, 0), (1820, 0), (1830, 0), (1840, 1), (1850, 1), (1860, 0), (1870, 0), (1880, 0), (1890, 0), (1900, 0), (1910, 0), (1920, 0), (1930, 0), (1940, 0), (1950, 0), (1960, 0), (1970, 0), (1980, 0), (1990, 1), (2000, 1), (2010, 1), (2020, 1), (2030, 1), (2040, 1), (2050, 1)]
Vdin0_11  din0_11  0 PWL (0n 0.0v 9.495n 0.0v 9.505n 0.0v 19.495n 0.0v 19.505n 1.95v 29.495n 1.95v 29.505n 0.0v 39.495n 0.0v 39.505n 0.0v 49.495n 0.0v 49.505n 0.0v 59.495n 0.0v 59.505n 0.0v 69.495n 0.0v 69.505n 0.0v 79.495n 0.0v 79.505n 1.95v 89.495n 1.95v 89.505n 1.95v 99.495n 1.95v 99.505n 1.95v 109.495n 1.95v 109.505n 0.0v 119.495n 0.0v 119.505n 0.0v 129.495n 0.0v 129.505n 0.0v 139.495n 0.0v 139.505n 0.0v 149.495n 0.0v 149.505n 0.0v 159.495n 0.0v 159.505n 1.95v 169.495n 1.95v 169.505n 1.95v 179.495n 1.95v 179.505n 1.95v 189.495n 1.95v 189.505n 1.95v 199.495n 1.95v 199.505n 1.95v 209.495n 1.95v 209.505n 1.95v 219.495n 1.95v 219.505n 1.95v 229.495n 1.95v 229.505n 1.95v 239.495n 1.95v 239.505n 1.95v 249.495n 1.95v 249.505n 1.95v 259.495n 1.95v 259.505n 1.95v 269.495n 1.95v 269.505n 0.0v 279.495n 0.0v 279.505n 0.0v 289.495n 0.0v 289.505n 0.0v 299.495n 0.0v 299.505n 1.95v 309.495n 1.95v 309.505n 1.95v 319.495n 1.95v 319.505n 1.95v 329.495n 1.95v 329.505n 1.95v 339.495n 1.95v 339.505n 1.95v 349.495n 1.95v 349.505n 1.95v 359.495n 1.95v 359.505n 1.95v 369.495n 1.95v 369.505n 0.0v 379.495n 0.0v 379.505n 0.0v 389.495n 0.0v 389.505n 0.0v 399.495n 0.0v 399.505n 1.95v 409.495n 1.95v 409.505n 1.95v 419.495n 1.95v 419.505n 0.0v 429.495n 0.0v 429.505n 0.0v 439.495n 0.0v 439.505n 0.0v 449.495n 0.0v 449.505n 0.0v 459.495n 0.0v 459.505n 0.0v 469.495n 0.0v 469.505n 0.0v 479.495n 0.0v 479.505n 0.0v 489.495n 0.0v 489.505n 0.0v 499.495n 0.0v 499.505n 1.95v 509.495n 1.95v 509.505n 1.95v 519.495n 1.95v 519.505n 1.95v 529.495n 1.95v 529.505n 1.95v 539.495n 1.95v 539.505n 1.95v 549.495n 1.95v 549.505n 1.95v 559.495n 1.95v 559.505n 1.95v 569.495n 1.95v 569.505n 1.95v 579.495n 1.95v 579.505n 1.95v 589.495n 1.95v 589.505n 1.95v 599.495n 1.95v 599.505n 1.95v 609.495n 1.95v 609.505n 1.95v 619.495n 1.95v 619.505n 1.95v 629.495n 1.95v 629.505n 1.95v 639.495n 1.95v 639.505n 1.95v 649.495n 1.95v 649.505n 0.0v 659.495n 0.0v 659.505n 0.0v 669.495n 0.0v 669.505n 1.95v 679.495n 1.95v 679.505n 1.95v 689.495n 1.95v 689.505n 1.95v 699.495n 1.95v 699.505n 1.95v 709.495n 1.95v 709.505n 1.95v 719.495n 1.95v 719.505n 1.95v 729.495n 1.95v 729.505n 0.0v 739.495n 0.0v 739.505n 0.0v 749.495n 0.0v 749.505n 1.95v 759.495n 1.95v 759.505n 1.95v 769.495n 1.95v 769.505n 1.95v 779.495n 1.95v 779.505n 1.95v 789.495n 1.95v 789.505n 1.95v 799.495n 1.95v 799.505n 1.95v 809.495n 1.95v 809.505n 1.95v 819.495n 1.95v 819.505n 1.95v 829.495n 1.95v 829.505n 1.95v 839.495n 1.95v 839.505n 1.95v 849.495n 1.95v 849.505n 1.95v 859.495n 1.95v 859.505n 1.95v 869.495n 1.95v 869.505n 1.95v 879.495n 1.95v 879.505n 1.95v 889.495n 1.95v 889.505n 1.95v 899.495n 1.95v 899.505n 1.95v 909.495n 1.95v 909.505n 1.95v 919.495n 1.95v 919.505n 1.95v 929.495n 1.95v 929.505n 1.95v 939.495n 1.95v 939.505n 0.0v 949.495n 0.0v 949.505n 1.95v 959.495n 1.95v 959.505n 1.95v 969.495n 1.95v 969.505n 0.0v 979.495n 0.0v 979.505n 0.0v 989.495n 0.0v 989.505n 0.0v 999.495n 0.0v 999.505n 0.0v 1009.495n 0.0v 1009.505n 1.95v 1019.495n 1.95v 1019.505n 1.95v 1029.495n 1.95v 1029.505n 0.0v 1039.495n 0.0v 1039.505n 0.0v 1049.495n 0.0v 1049.505n 1.95v 1059.495n 1.95v 1059.505n 1.95v 1069.495n 1.95v 1069.505n 1.95v 1079.495n 1.95v 1079.505n 1.95v 1089.495n 1.95v 1089.505n 1.95v 1099.495n 1.95v 1099.505n 1.95v 1109.495n 1.95v 1109.505n 1.95v 1119.495n 1.95v 1119.505n 1.95v 1129.495n 1.95v 1129.505n 1.95v 1139.495n 1.95v 1139.505n 1.95v 1149.495n 1.95v 1149.505n 0.0v 1159.495n 0.0v 1159.505n 0.0v 1169.495n 0.0v 1169.505n 0.0v 1179.495n 0.0v 1179.505n 0.0v 1189.495n 0.0v 1189.505n 0.0v 1199.495n 0.0v 1199.505n 0.0v 1209.495n 0.0v 1209.505n 1.95v 1219.495n 1.95v 1219.505n 1.95v 1229.495n 1.95v 1229.505n 1.95v 1239.495n 1.95v 1239.505n 1.95v 1249.495n 1.95v 1249.505n 1.95v 1259.495n 1.95v 1259.505n 1.95v 1269.495n 1.95v 1269.505n 1.95v 1279.495n 1.95v 1279.505n 1.95v 1289.495n 1.95v 1289.505n 1.95v 1299.495n 1.95v 1299.505n 1.95v 1309.495n 1.95v 1309.505n 1.95v 1319.495n 1.95v 1319.505n 0.0v 1329.495n 0.0v 1329.505n 0.0v 1339.495n 0.0v 1339.505n 1.95v 1349.495n 1.95v 1349.505n 1.95v 1359.495n 1.95v 1359.505n 1.95v 1369.495n 1.95v 1369.505n 1.95v 1379.495n 1.95v 1379.505n 0.0v 1389.495n 0.0v 1389.505n 1.95v 1399.495n 1.95v 1399.505n 1.95v 1409.495n 1.95v 1409.505n 1.95v 1419.495n 1.95v 1419.505n 0.0v 1429.495n 0.0v 1429.505n 0.0v 1439.495n 0.0v 1439.505n 1.95v 1449.495n 1.95v 1449.505n 1.95v 1459.495n 1.95v 1459.505n 1.95v 1469.495n 1.95v 1469.505n 1.95v 1479.495n 1.95v 1479.505n 1.95v 1489.495n 1.95v 1489.505n 1.95v 1499.495n 1.95v 1499.505n 1.95v 1509.495n 1.95v 1509.505n 1.95v 1519.495n 1.95v 1519.505n 1.95v 1529.495n 1.95v 1529.505n 1.95v 1539.495n 1.95v 1539.505n 1.95v 1549.495n 1.95v 1549.505n 0.0v 1559.495n 0.0v 1559.505n 1.95v 1569.495n 1.95v 1569.505n 1.95v 1579.495n 1.95v 1579.505n 0.0v 1589.495n 0.0v 1589.505n 0.0v 1599.495n 0.0v 1599.505n 0.0v 1609.495n 0.0v 1609.505n 1.95v 1619.495n 1.95v 1619.505n 1.95v 1629.495n 1.95v 1629.505n 1.95v 1639.495n 1.95v 1639.505n 1.95v 1649.495n 1.95v 1649.505n 1.95v 1659.495n 1.95v 1659.505n 1.95v 1669.495n 1.95v 1669.505n 1.95v 1679.495n 1.95v 1679.505n 0.0v 1689.495n 0.0v 1689.505n 1.95v 1699.495n 1.95v 1699.505n 1.95v 1709.495n 1.95v 1709.505n 1.95v 1719.495n 1.95v 1719.505n 1.95v 1729.495n 1.95v 1729.505n 0.0v 1739.495n 0.0v 1739.505n 0.0v 1749.495n 0.0v 1749.505n 0.0v 1759.495n 0.0v 1759.505n 1.95v 1769.495n 1.95v 1769.505n 1.95v 1779.495n 1.95v 1779.505n 1.95v 1789.495n 1.95v 1789.505n 1.95v 1799.495n 1.95v 1799.505n 1.95v 1809.495n 1.95v 1809.505n 0.0v 1819.495n 0.0v 1819.505n 0.0v 1829.495n 0.0v 1829.505n 0.0v 1839.495n 0.0v 1839.505n 1.95v 1849.495n 1.95v 1849.505n 1.95v 1859.495n 1.95v 1859.505n 0.0v 1869.495n 0.0v 1869.505n 0.0v 1879.495n 0.0v 1879.505n 0.0v 1889.495n 0.0v 1889.505n 0.0v 1899.495n 0.0v 1899.505n 0.0v 1909.495n 0.0v 1909.505n 0.0v 1919.495n 0.0v 1919.505n 0.0v 1929.495n 0.0v 1929.505n 0.0v 1939.495n 0.0v 1939.505n 0.0v 1949.495n 0.0v 1949.505n 0.0v 1959.495n 0.0v 1959.505n 0.0v 1969.495n 0.0v 1969.505n 0.0v 1979.495n 0.0v 1979.505n 0.0v 1989.495n 0.0v 1989.505n 1.95v 1999.495n 1.95v 1999.505n 1.95v 2009.495n 1.95v 2009.505n 1.95v 2019.495n 1.95v 2019.505n 1.95v 2029.495n 1.95v 2029.505n 1.95v 2039.495n 1.95v 2039.505n 1.95v 2049.495n 1.95v 2049.505n 1.95v )
* (time, data): [(0, 0), (10, 1), (20, 0), (30, 1), (40, 1), (50, 1), (60, 1), (70, 0), (80, 0), (90, 0), (100, 0), (110, 1), (120, 1), (130, 1), (140, 1), (150, 1), (160, 0), (170, 0), (180, 0), (190, 0), (200, 0), (210, 0), (220, 0), (230, 0), (240, 1), (250, 1), (260, 1), (270, 0), (280, 0), (290, 0), (300, 0), (310, 0), (320, 0), (330, 0), (340, 1), (350, 1), (360, 1), (370, 0), (380, 0), (390, 0), (400, 1), (410, 1), (420, 0), (430, 0), (440, 0), (450, 0), (460, 0), (470, 0), (480, 0), (490, 0), (500, 1), (510, 0), (520, 0), (530, 0), (540, 1), (550, 1), (560, 1), (570, 1), (580, 1), (590, 1), (600, 1), (610, 1), (620, 1), (630, 1), (640, 1), (650, 1), (660, 1), (670, 0), (680, 0), (690, 0), (700, 1), (710, 1), (720, 1), (730, 0), (740, 0), (750, 1), (760, 1), (770, 1), (780, 1), (790, 1), (800, 1), (810, 0), (820, 0), (830, 0), (840, 0), (850, 0), (860, 0), (870, 0), (880, 0), (890, 0), (900, 0), (910, 0), (920, 0), (930, 0), (940, 1), (950, 0), (960, 0), (970, 1), (980, 0), (990, 1), (1000, 1), (1010, 0), (1020, 0), (1030, 0), (1040, 0), (1050, 1), (1060, 1), (1070, 1), (1080, 1), (1090, 1), (1100, 1), (1110, 1), (1120, 1), (1130, 1), (1140, 1), (1150, 0), (1160, 0), (1170, 0), (1180, 0), (1190, 0), (1200, 0), (1210, 1), (1220, 1), (1230, 0), (1240, 1), (1250, 1), (1260, 1), (1270, 1), (1280, 1), (1290, 1), (1300, 1), (1310, 1), (1320, 1), (1330, 1), (1340, 0), (1350, 0), (1360, 0), (1370, 0), (1380, 1), (1390, 1), (1400, 1), (1410, 1), (1420, 1), (1430, 1), (1440, 1), (1450, 1), (1460, 1), (1470, 1), (1480, 1), (1490, 1), (1500, 1), (1510, 1), (1520, 1), (1530, 1), (1540, 1), (1550, 0), (1560, 1), (1570, 1), (1580, 1), (1590, 1), (1600, 1), (1610, 1), (1620, 1), (1630, 1), (1640, 1), (1650, 1), (1660, 0), (1670, 0), (1680, 1), (1690, 0), (1700, 0), (1710, 0), (1720, 1), (1730, 1), (1740, 0), (1750, 0), (1760, 0), (1770, 0), (1780, 0), (1790, 0), (1800, 0), (1810, 1), (1820, 1), (1830, 1), (1840, 1), (1850, 1), (1860, 1), (1870, 1), (1880, 1), (1890, 1), (1900, 1), (1910, 1), (1920, 1), (1930, 1), (1940, 1), (1950, 1), (1960, 0), (1970, 0), (1980, 0), (1990, 0), (2000, 0), (2010, 0), (2020, 0), (2030, 0), (2040, 0), (2050, 0)]
Vdin0_12  din0_12  0 PWL (0n 0.0v 9.495n 0.0v 9.505n 1.95v 19.495n 1.95v 19.505n 0.0v 29.495n 0.0v 29.505n 1.95v 39.495n 1.95v 39.505n 1.95v 49.495n 1.95v 49.505n 1.95v 59.495n 1.95v 59.505n 1.95v 69.495n 1.95v 69.505n 0.0v 79.495n 0.0v 79.505n 0.0v 89.495n 0.0v 89.505n 0.0v 99.495n 0.0v 99.505n 0.0v 109.495n 0.0v 109.505n 1.95v 119.495n 1.95v 119.505n 1.95v 129.495n 1.95v 129.505n 1.95v 139.495n 1.95v 139.505n 1.95v 149.495n 1.95v 149.505n 1.95v 159.495n 1.95v 159.505n 0.0v 169.495n 0.0v 169.505n 0.0v 179.495n 0.0v 179.505n 0.0v 189.495n 0.0v 189.505n 0.0v 199.495n 0.0v 199.505n 0.0v 209.495n 0.0v 209.505n 0.0v 219.495n 0.0v 219.505n 0.0v 229.495n 0.0v 229.505n 0.0v 239.495n 0.0v 239.505n 1.95v 249.495n 1.95v 249.505n 1.95v 259.495n 1.95v 259.505n 1.95v 269.495n 1.95v 269.505n 0.0v 279.495n 0.0v 279.505n 0.0v 289.495n 0.0v 289.505n 0.0v 299.495n 0.0v 299.505n 0.0v 309.495n 0.0v 309.505n 0.0v 319.495n 0.0v 319.505n 0.0v 329.495n 0.0v 329.505n 0.0v 339.495n 0.0v 339.505n 1.95v 349.495n 1.95v 349.505n 1.95v 359.495n 1.95v 359.505n 1.95v 369.495n 1.95v 369.505n 0.0v 379.495n 0.0v 379.505n 0.0v 389.495n 0.0v 389.505n 0.0v 399.495n 0.0v 399.505n 1.95v 409.495n 1.95v 409.505n 1.95v 419.495n 1.95v 419.505n 0.0v 429.495n 0.0v 429.505n 0.0v 439.495n 0.0v 439.505n 0.0v 449.495n 0.0v 449.505n 0.0v 459.495n 0.0v 459.505n 0.0v 469.495n 0.0v 469.505n 0.0v 479.495n 0.0v 479.505n 0.0v 489.495n 0.0v 489.505n 0.0v 499.495n 0.0v 499.505n 1.95v 509.495n 1.95v 509.505n 0.0v 519.495n 0.0v 519.505n 0.0v 529.495n 0.0v 529.505n 0.0v 539.495n 0.0v 539.505n 1.95v 549.495n 1.95v 549.505n 1.95v 559.495n 1.95v 559.505n 1.95v 569.495n 1.95v 569.505n 1.95v 579.495n 1.95v 579.505n 1.95v 589.495n 1.95v 589.505n 1.95v 599.495n 1.95v 599.505n 1.95v 609.495n 1.95v 609.505n 1.95v 619.495n 1.95v 619.505n 1.95v 629.495n 1.95v 629.505n 1.95v 639.495n 1.95v 639.505n 1.95v 649.495n 1.95v 649.505n 1.95v 659.495n 1.95v 659.505n 1.95v 669.495n 1.95v 669.505n 0.0v 679.495n 0.0v 679.505n 0.0v 689.495n 0.0v 689.505n 0.0v 699.495n 0.0v 699.505n 1.95v 709.495n 1.95v 709.505n 1.95v 719.495n 1.95v 719.505n 1.95v 729.495n 1.95v 729.505n 0.0v 739.495n 0.0v 739.505n 0.0v 749.495n 0.0v 749.505n 1.95v 759.495n 1.95v 759.505n 1.95v 769.495n 1.95v 769.505n 1.95v 779.495n 1.95v 779.505n 1.95v 789.495n 1.95v 789.505n 1.95v 799.495n 1.95v 799.505n 1.95v 809.495n 1.95v 809.505n 0.0v 819.495n 0.0v 819.505n 0.0v 829.495n 0.0v 829.505n 0.0v 839.495n 0.0v 839.505n 0.0v 849.495n 0.0v 849.505n 0.0v 859.495n 0.0v 859.505n 0.0v 869.495n 0.0v 869.505n 0.0v 879.495n 0.0v 879.505n 0.0v 889.495n 0.0v 889.505n 0.0v 899.495n 0.0v 899.505n 0.0v 909.495n 0.0v 909.505n 0.0v 919.495n 0.0v 919.505n 0.0v 929.495n 0.0v 929.505n 0.0v 939.495n 0.0v 939.505n 1.95v 949.495n 1.95v 949.505n 0.0v 959.495n 0.0v 959.505n 0.0v 969.495n 0.0v 969.505n 1.95v 979.495n 1.95v 979.505n 0.0v 989.495n 0.0v 989.505n 1.95v 999.495n 1.95v 999.505n 1.95v 1009.495n 1.95v 1009.505n 0.0v 1019.495n 0.0v 1019.505n 0.0v 1029.495n 0.0v 1029.505n 0.0v 1039.495n 0.0v 1039.505n 0.0v 1049.495n 0.0v 1049.505n 1.95v 1059.495n 1.95v 1059.505n 1.95v 1069.495n 1.95v 1069.505n 1.95v 1079.495n 1.95v 1079.505n 1.95v 1089.495n 1.95v 1089.505n 1.95v 1099.495n 1.95v 1099.505n 1.95v 1109.495n 1.95v 1109.505n 1.95v 1119.495n 1.95v 1119.505n 1.95v 1129.495n 1.95v 1129.505n 1.95v 1139.495n 1.95v 1139.505n 1.95v 1149.495n 1.95v 1149.505n 0.0v 1159.495n 0.0v 1159.505n 0.0v 1169.495n 0.0v 1169.505n 0.0v 1179.495n 0.0v 1179.505n 0.0v 1189.495n 0.0v 1189.505n 0.0v 1199.495n 0.0v 1199.505n 0.0v 1209.495n 0.0v 1209.505n 1.95v 1219.495n 1.95v 1219.505n 1.95v 1229.495n 1.95v 1229.505n 0.0v 1239.495n 0.0v 1239.505n 1.95v 1249.495n 1.95v 1249.505n 1.95v 1259.495n 1.95v 1259.505n 1.95v 1269.495n 1.95v 1269.505n 1.95v 1279.495n 1.95v 1279.505n 1.95v 1289.495n 1.95v 1289.505n 1.95v 1299.495n 1.95v 1299.505n 1.95v 1309.495n 1.95v 1309.505n 1.95v 1319.495n 1.95v 1319.505n 1.95v 1329.495n 1.95v 1329.505n 1.95v 1339.495n 1.95v 1339.505n 0.0v 1349.495n 0.0v 1349.505n 0.0v 1359.495n 0.0v 1359.505n 0.0v 1369.495n 0.0v 1369.505n 0.0v 1379.495n 0.0v 1379.505n 1.95v 1389.495n 1.95v 1389.505n 1.95v 1399.495n 1.95v 1399.505n 1.95v 1409.495n 1.95v 1409.505n 1.95v 1419.495n 1.95v 1419.505n 1.95v 1429.495n 1.95v 1429.505n 1.95v 1439.495n 1.95v 1439.505n 1.95v 1449.495n 1.95v 1449.505n 1.95v 1459.495n 1.95v 1459.505n 1.95v 1469.495n 1.95v 1469.505n 1.95v 1479.495n 1.95v 1479.505n 1.95v 1489.495n 1.95v 1489.505n 1.95v 1499.495n 1.95v 1499.505n 1.95v 1509.495n 1.95v 1509.505n 1.95v 1519.495n 1.95v 1519.505n 1.95v 1529.495n 1.95v 1529.505n 1.95v 1539.495n 1.95v 1539.505n 1.95v 1549.495n 1.95v 1549.505n 0.0v 1559.495n 0.0v 1559.505n 1.95v 1569.495n 1.95v 1569.505n 1.95v 1579.495n 1.95v 1579.505n 1.95v 1589.495n 1.95v 1589.505n 1.95v 1599.495n 1.95v 1599.505n 1.95v 1609.495n 1.95v 1609.505n 1.95v 1619.495n 1.95v 1619.505n 1.95v 1629.495n 1.95v 1629.505n 1.95v 1639.495n 1.95v 1639.505n 1.95v 1649.495n 1.95v 1649.505n 1.95v 1659.495n 1.95v 1659.505n 0.0v 1669.495n 0.0v 1669.505n 0.0v 1679.495n 0.0v 1679.505n 1.95v 1689.495n 1.95v 1689.505n 0.0v 1699.495n 0.0v 1699.505n 0.0v 1709.495n 0.0v 1709.505n 0.0v 1719.495n 0.0v 1719.505n 1.95v 1729.495n 1.95v 1729.505n 1.95v 1739.495n 1.95v 1739.505n 0.0v 1749.495n 0.0v 1749.505n 0.0v 1759.495n 0.0v 1759.505n 0.0v 1769.495n 0.0v 1769.505n 0.0v 1779.495n 0.0v 1779.505n 0.0v 1789.495n 0.0v 1789.505n 0.0v 1799.495n 0.0v 1799.505n 0.0v 1809.495n 0.0v 1809.505n 1.95v 1819.495n 1.95v 1819.505n 1.95v 1829.495n 1.95v 1829.505n 1.95v 1839.495n 1.95v 1839.505n 1.95v 1849.495n 1.95v 1849.505n 1.95v 1859.495n 1.95v 1859.505n 1.95v 1869.495n 1.95v 1869.505n 1.95v 1879.495n 1.95v 1879.505n 1.95v 1889.495n 1.95v 1889.505n 1.95v 1899.495n 1.95v 1899.505n 1.95v 1909.495n 1.95v 1909.505n 1.95v 1919.495n 1.95v 1919.505n 1.95v 1929.495n 1.95v 1929.505n 1.95v 1939.495n 1.95v 1939.505n 1.95v 1949.495n 1.95v 1949.505n 1.95v 1959.495n 1.95v 1959.505n 0.0v 1969.495n 0.0v 1969.505n 0.0v 1979.495n 0.0v 1979.505n 0.0v 1989.495n 0.0v 1989.505n 0.0v 1999.495n 0.0v 1999.505n 0.0v 2009.495n 0.0v 2009.505n 0.0v 2019.495n 0.0v 2019.505n 0.0v 2029.495n 0.0v 2029.505n 0.0v 2039.495n 0.0v 2039.505n 0.0v 2049.495n 0.0v 2049.505n 0.0v )
* (time, data): [(0, 0), (10, 1), (20, 0), (30, 0), (40, 0), (50, 0), (60, 1), (70, 1), (80, 1), (90, 1), (100, 1), (110, 1), (120, 1), (130, 1), (140, 1), (150, 1), (160, 0), (170, 0), (180, 0), (190, 0), (200, 0), (210, 0), (220, 0), (230, 0), (240, 1), (250, 1), (260, 1), (270, 0), (280, 0), (290, 0), (300, 1), (310, 1), (320, 1), (330, 1), (340, 1), (350, 1), (360, 1), (370, 0), (380, 0), (390, 0), (400, 1), (410, 1), (420, 1), (430, 1), (440, 1), (450, 1), (460, 1), (470, 1), (480, 1), (490, 1), (500, 0), (510, 1), (520, 1), (530, 1), (540, 1), (550, 1), (560, 1), (570, 1), (580, 1), (590, 1), (600, 1), (610, 1), (620, 1), (630, 1), (640, 1), (650, 0), (660, 0), (670, 1), (680, 1), (690, 1), (700, 0), (710, 0), (720, 0), (730, 0), (740, 0), (750, 1), (760, 1), (770, 1), (780, 1), (790, 0), (800, 0), (810, 0), (820, 0), (830, 1), (840, 1), (850, 0), (860, 0), (870, 0), (880, 0), (890, 0), (900, 0), (910, 0), (920, 0), (930, 0), (940, 0), (950, 0), (960, 0), (970, 0), (980, 1), (990, 1), (1000, 1), (1010, 1), (1020, 1), (1030, 1), (1040, 1), (1050, 1), (1060, 1), (1070, 1), (1080, 1), (1090, 1), (1100, 1), (1110, 1), (1120, 1), (1130, 1), (1140, 1), (1150, 0), (1160, 0), (1170, 0), (1180, 0), (1190, 0), (1200, 0), (1210, 1), (1220, 1), (1230, 0), (1240, 1), (1250, 1), (1260, 1), (1270, 1), (1280, 1), (1290, 0), (1300, 0), (1310, 0), (1320, 1), (1330, 0), (1340, 1), (1350, 1), (1360, 1), (1370, 1), (1380, 0), (1390, 1), (1400, 1), (1410, 1), (1420, 1), (1430, 1), (1440, 0), (1450, 0), (1460, 0), (1470, 0), (1480, 0), (1490, 0), (1500, 0), (1510, 0), (1520, 0), (1530, 0), (1540, 0), (1550, 0), (1560, 1), (1570, 1), (1580, 0), (1590, 0), (1600, 0), (1610, 0), (1620, 0), (1630, 0), (1640, 0), (1650, 0), (1660, 1), (1670, 1), (1680, 1), (1690, 0), (1700, 0), (1710, 0), (1720, 1), (1730, 0), (1740, 0), (1750, 0), (1760, 0), (1770, 0), (1780, 0), (1790, 0), (1800, 0), (1810, 0), (1820, 0), (1830, 0), (1840, 0), (1850, 0), (1860, 1), (1870, 1), (1880, 1), (1890, 1), (1900, 1), (1910, 1), (1920, 1), (1930, 1), (1940, 1), (1950, 0), (1960, 0), (1970, 1), (1980, 1), (1990, 1), (2000, 1), (2010, 1), (2020, 1), (2030, 1), (2040, 1), (2050, 1)]
Vdin0_13  din0_13  0 PWL (0n 0.0v 9.495n 0.0v 9.505n 1.95v 19.495n 1.95v 19.505n 0.0v 29.495n 0.0v 29.505n 0.0v 39.495n 0.0v 39.505n 0.0v 49.495n 0.0v 49.505n 0.0v 59.495n 0.0v 59.505n 1.95v 69.495n 1.95v 69.505n 1.95v 79.495n 1.95v 79.505n 1.95v 89.495n 1.95v 89.505n 1.95v 99.495n 1.95v 99.505n 1.95v 109.495n 1.95v 109.505n 1.95v 119.495n 1.95v 119.505n 1.95v 129.495n 1.95v 129.505n 1.95v 139.495n 1.95v 139.505n 1.95v 149.495n 1.95v 149.505n 1.95v 159.495n 1.95v 159.505n 0.0v 169.495n 0.0v 169.505n 0.0v 179.495n 0.0v 179.505n 0.0v 189.495n 0.0v 189.505n 0.0v 199.495n 0.0v 199.505n 0.0v 209.495n 0.0v 209.505n 0.0v 219.495n 0.0v 219.505n 0.0v 229.495n 0.0v 229.505n 0.0v 239.495n 0.0v 239.505n 1.95v 249.495n 1.95v 249.505n 1.95v 259.495n 1.95v 259.505n 1.95v 269.495n 1.95v 269.505n 0.0v 279.495n 0.0v 279.505n 0.0v 289.495n 0.0v 289.505n 0.0v 299.495n 0.0v 299.505n 1.95v 309.495n 1.95v 309.505n 1.95v 319.495n 1.95v 319.505n 1.95v 329.495n 1.95v 329.505n 1.95v 339.495n 1.95v 339.505n 1.95v 349.495n 1.95v 349.505n 1.95v 359.495n 1.95v 359.505n 1.95v 369.495n 1.95v 369.505n 0.0v 379.495n 0.0v 379.505n 0.0v 389.495n 0.0v 389.505n 0.0v 399.495n 0.0v 399.505n 1.95v 409.495n 1.95v 409.505n 1.95v 419.495n 1.95v 419.505n 1.95v 429.495n 1.95v 429.505n 1.95v 439.495n 1.95v 439.505n 1.95v 449.495n 1.95v 449.505n 1.95v 459.495n 1.95v 459.505n 1.95v 469.495n 1.95v 469.505n 1.95v 479.495n 1.95v 479.505n 1.95v 489.495n 1.95v 489.505n 1.95v 499.495n 1.95v 499.505n 0.0v 509.495n 0.0v 509.505n 1.95v 519.495n 1.95v 519.505n 1.95v 529.495n 1.95v 529.505n 1.95v 539.495n 1.95v 539.505n 1.95v 549.495n 1.95v 549.505n 1.95v 559.495n 1.95v 559.505n 1.95v 569.495n 1.95v 569.505n 1.95v 579.495n 1.95v 579.505n 1.95v 589.495n 1.95v 589.505n 1.95v 599.495n 1.95v 599.505n 1.95v 609.495n 1.95v 609.505n 1.95v 619.495n 1.95v 619.505n 1.95v 629.495n 1.95v 629.505n 1.95v 639.495n 1.95v 639.505n 1.95v 649.495n 1.95v 649.505n 0.0v 659.495n 0.0v 659.505n 0.0v 669.495n 0.0v 669.505n 1.95v 679.495n 1.95v 679.505n 1.95v 689.495n 1.95v 689.505n 1.95v 699.495n 1.95v 699.505n 0.0v 709.495n 0.0v 709.505n 0.0v 719.495n 0.0v 719.505n 0.0v 729.495n 0.0v 729.505n 0.0v 739.495n 0.0v 739.505n 0.0v 749.495n 0.0v 749.505n 1.95v 759.495n 1.95v 759.505n 1.95v 769.495n 1.95v 769.505n 1.95v 779.495n 1.95v 779.505n 1.95v 789.495n 1.95v 789.505n 0.0v 799.495n 0.0v 799.505n 0.0v 809.495n 0.0v 809.505n 0.0v 819.495n 0.0v 819.505n 0.0v 829.495n 0.0v 829.505n 1.95v 839.495n 1.95v 839.505n 1.95v 849.495n 1.95v 849.505n 0.0v 859.495n 0.0v 859.505n 0.0v 869.495n 0.0v 869.505n 0.0v 879.495n 0.0v 879.505n 0.0v 889.495n 0.0v 889.505n 0.0v 899.495n 0.0v 899.505n 0.0v 909.495n 0.0v 909.505n 0.0v 919.495n 0.0v 919.505n 0.0v 929.495n 0.0v 929.505n 0.0v 939.495n 0.0v 939.505n 0.0v 949.495n 0.0v 949.505n 0.0v 959.495n 0.0v 959.505n 0.0v 969.495n 0.0v 969.505n 0.0v 979.495n 0.0v 979.505n 1.95v 989.495n 1.95v 989.505n 1.95v 999.495n 1.95v 999.505n 1.95v 1009.495n 1.95v 1009.505n 1.95v 1019.495n 1.95v 1019.505n 1.95v 1029.495n 1.95v 1029.505n 1.95v 1039.495n 1.95v 1039.505n 1.95v 1049.495n 1.95v 1049.505n 1.95v 1059.495n 1.95v 1059.505n 1.95v 1069.495n 1.95v 1069.505n 1.95v 1079.495n 1.95v 1079.505n 1.95v 1089.495n 1.95v 1089.505n 1.95v 1099.495n 1.95v 1099.505n 1.95v 1109.495n 1.95v 1109.505n 1.95v 1119.495n 1.95v 1119.505n 1.95v 1129.495n 1.95v 1129.505n 1.95v 1139.495n 1.95v 1139.505n 1.95v 1149.495n 1.95v 1149.505n 0.0v 1159.495n 0.0v 1159.505n 0.0v 1169.495n 0.0v 1169.505n 0.0v 1179.495n 0.0v 1179.505n 0.0v 1189.495n 0.0v 1189.505n 0.0v 1199.495n 0.0v 1199.505n 0.0v 1209.495n 0.0v 1209.505n 1.95v 1219.495n 1.95v 1219.505n 1.95v 1229.495n 1.95v 1229.505n 0.0v 1239.495n 0.0v 1239.505n 1.95v 1249.495n 1.95v 1249.505n 1.95v 1259.495n 1.95v 1259.505n 1.95v 1269.495n 1.95v 1269.505n 1.95v 1279.495n 1.95v 1279.505n 1.95v 1289.495n 1.95v 1289.505n 0.0v 1299.495n 0.0v 1299.505n 0.0v 1309.495n 0.0v 1309.505n 0.0v 1319.495n 0.0v 1319.505n 1.95v 1329.495n 1.95v 1329.505n 0.0v 1339.495n 0.0v 1339.505n 1.95v 1349.495n 1.95v 1349.505n 1.95v 1359.495n 1.95v 1359.505n 1.95v 1369.495n 1.95v 1369.505n 1.95v 1379.495n 1.95v 1379.505n 0.0v 1389.495n 0.0v 1389.505n 1.95v 1399.495n 1.95v 1399.505n 1.95v 1409.495n 1.95v 1409.505n 1.95v 1419.495n 1.95v 1419.505n 1.95v 1429.495n 1.95v 1429.505n 1.95v 1439.495n 1.95v 1439.505n 0.0v 1449.495n 0.0v 1449.505n 0.0v 1459.495n 0.0v 1459.505n 0.0v 1469.495n 0.0v 1469.505n 0.0v 1479.495n 0.0v 1479.505n 0.0v 1489.495n 0.0v 1489.505n 0.0v 1499.495n 0.0v 1499.505n 0.0v 1509.495n 0.0v 1509.505n 0.0v 1519.495n 0.0v 1519.505n 0.0v 1529.495n 0.0v 1529.505n 0.0v 1539.495n 0.0v 1539.505n 0.0v 1549.495n 0.0v 1549.505n 0.0v 1559.495n 0.0v 1559.505n 1.95v 1569.495n 1.95v 1569.505n 1.95v 1579.495n 1.95v 1579.505n 0.0v 1589.495n 0.0v 1589.505n 0.0v 1599.495n 0.0v 1599.505n 0.0v 1609.495n 0.0v 1609.505n 0.0v 1619.495n 0.0v 1619.505n 0.0v 1629.495n 0.0v 1629.505n 0.0v 1639.495n 0.0v 1639.505n 0.0v 1649.495n 0.0v 1649.505n 0.0v 1659.495n 0.0v 1659.505n 1.95v 1669.495n 1.95v 1669.505n 1.95v 1679.495n 1.95v 1679.505n 1.95v 1689.495n 1.95v 1689.505n 0.0v 1699.495n 0.0v 1699.505n 0.0v 1709.495n 0.0v 1709.505n 0.0v 1719.495n 0.0v 1719.505n 1.95v 1729.495n 1.95v 1729.505n 0.0v 1739.495n 0.0v 1739.505n 0.0v 1749.495n 0.0v 1749.505n 0.0v 1759.495n 0.0v 1759.505n 0.0v 1769.495n 0.0v 1769.505n 0.0v 1779.495n 0.0v 1779.505n 0.0v 1789.495n 0.0v 1789.505n 0.0v 1799.495n 0.0v 1799.505n 0.0v 1809.495n 0.0v 1809.505n 0.0v 1819.495n 0.0v 1819.505n 0.0v 1829.495n 0.0v 1829.505n 0.0v 1839.495n 0.0v 1839.505n 0.0v 1849.495n 0.0v 1849.505n 0.0v 1859.495n 0.0v 1859.505n 1.95v 1869.495n 1.95v 1869.505n 1.95v 1879.495n 1.95v 1879.505n 1.95v 1889.495n 1.95v 1889.505n 1.95v 1899.495n 1.95v 1899.505n 1.95v 1909.495n 1.95v 1909.505n 1.95v 1919.495n 1.95v 1919.505n 1.95v 1929.495n 1.95v 1929.505n 1.95v 1939.495n 1.95v 1939.505n 1.95v 1949.495n 1.95v 1949.505n 0.0v 1959.495n 0.0v 1959.505n 0.0v 1969.495n 0.0v 1969.505n 1.95v 1979.495n 1.95v 1979.505n 1.95v 1989.495n 1.95v 1989.505n 1.95v 1999.495n 1.95v 1999.505n 1.95v 2009.495n 1.95v 2009.505n 1.95v 2019.495n 1.95v 2019.505n 1.95v 2029.495n 1.95v 2029.505n 1.95v 2039.495n 1.95v 2039.505n 1.95v 2049.495n 1.95v 2049.505n 1.95v )
* (time, data): [(0, 0), (10, 0), (20, 1), (30, 1), (40, 1), (50, 1), (60, 0), (70, 0), (80, 0), (90, 0), (100, 0), (110, 0), (120, 0), (130, 0), (140, 0), (150, 0), (160, 1), (170, 1), (180, 1), (190, 1), (200, 1), (210, 1), (220, 1), (230, 1), (240, 1), (250, 1), (260, 1), (270, 0), (280, 0), (290, 0), (300, 1), (310, 1), (320, 1), (330, 1), (340, 1), (350, 1), (360, 1), (370, 0), (380, 0), (390, 0), (400, 1), (410, 1), (420, 0), (430, 0), (440, 0), (450, 0), (460, 0), (470, 0), (480, 0), (490, 0), (500, 0), (510, 0), (520, 0), (530, 0), (540, 1), (550, 1), (560, 1), (570, 1), (580, 1), (590, 1), (600, 1), (610, 1), (620, 1), (630, 1), (640, 0), (650, 0), (660, 0), (670, 1), (680, 1), (690, 1), (700, 1), (710, 1), (720, 1), (730, 0), (740, 0), (750, 0), (760, 0), (770, 0), (780, 0), (790, 0), (800, 0), (810, 1), (820, 1), (830, 0), (840, 0), (850, 1), (860, 1), (870, 1), (880, 1), (890, 1), (900, 1), (910, 1), (920, 1), (930, 1), (940, 0), (950, 0), (960, 0), (970, 1), (980, 0), (990, 1), (1000, 1), (1010, 0), (1020, 0), (1030, 0), (1040, 0), (1050, 0), (1060, 0), (1070, 0), (1080, 0), (1090, 0), (1100, 0), (1110, 0), (1120, 0), (1130, 0), (1140, 0), (1150, 0), (1160, 0), (1170, 0), (1180, 0), (1190, 0), (1200, 0), (1210, 0), (1220, 0), (1230, 1), (1240, 0), (1250, 1), (1260, 1), (1270, 1), (1280, 1), (1290, 1), (1300, 1), (1310, 1), (1320, 0), (1330, 1), (1340, 1), (1350, 1), (1360, 1), (1370, 1), (1380, 1), (1390, 0), (1400, 0), (1410, 0), (1420, 1), (1430, 1), (1440, 0), (1450, 0), (1460, 0), (1470, 0), (1480, 0), (1490, 0), (1500, 0), (1510, 0), (1520, 0), (1530, 0), (1540, 0), (1550, 0), (1560, 0), (1570, 0), (1580, 0), (1590, 0), (1600, 0), (1610, 0), (1620, 0), (1630, 0), (1640, 0), (1650, 0), (1660, 1), (1670, 1), (1680, 0), (1690, 0), (1700, 0), (1710, 0), (1720, 1), (1730, 0), (1740, 0), (1750, 0), (1760, 1), (1770, 1), (1780, 1), (1790, 1), (1800, 1), (1810, 1), (1820, 1), (1830, 1), (1840, 0), (1850, 1), (1860, 1), (1870, 1), (1880, 1), (1890, 1), (1900, 1), (1910, 1), (1920, 1), (1930, 1), (1940, 1), (1950, 1), (1960, 1), (1970, 1), (1980, 1), (1990, 1), (2000, 1), (2010, 1), (2020, 1), (2030, 1), (2040, 1), (2050, 1)]
Vdin0_14  din0_14  0 PWL (0n 0.0v 9.495n 0.0v 9.505n 0.0v 19.495n 0.0v 19.505n 1.95v 29.495n 1.95v 29.505n 1.95v 39.495n 1.95v 39.505n 1.95v 49.495n 1.95v 49.505n 1.95v 59.495n 1.95v 59.505n 0.0v 69.495n 0.0v 69.505n 0.0v 79.495n 0.0v 79.505n 0.0v 89.495n 0.0v 89.505n 0.0v 99.495n 0.0v 99.505n 0.0v 109.495n 0.0v 109.505n 0.0v 119.495n 0.0v 119.505n 0.0v 129.495n 0.0v 129.505n 0.0v 139.495n 0.0v 139.505n 0.0v 149.495n 0.0v 149.505n 0.0v 159.495n 0.0v 159.505n 1.95v 169.495n 1.95v 169.505n 1.95v 179.495n 1.95v 179.505n 1.95v 189.495n 1.95v 189.505n 1.95v 199.495n 1.95v 199.505n 1.95v 209.495n 1.95v 209.505n 1.95v 219.495n 1.95v 219.505n 1.95v 229.495n 1.95v 229.505n 1.95v 239.495n 1.95v 239.505n 1.95v 249.495n 1.95v 249.505n 1.95v 259.495n 1.95v 259.505n 1.95v 269.495n 1.95v 269.505n 0.0v 279.495n 0.0v 279.505n 0.0v 289.495n 0.0v 289.505n 0.0v 299.495n 0.0v 299.505n 1.95v 309.495n 1.95v 309.505n 1.95v 319.495n 1.95v 319.505n 1.95v 329.495n 1.95v 329.505n 1.95v 339.495n 1.95v 339.505n 1.95v 349.495n 1.95v 349.505n 1.95v 359.495n 1.95v 359.505n 1.95v 369.495n 1.95v 369.505n 0.0v 379.495n 0.0v 379.505n 0.0v 389.495n 0.0v 389.505n 0.0v 399.495n 0.0v 399.505n 1.95v 409.495n 1.95v 409.505n 1.95v 419.495n 1.95v 419.505n 0.0v 429.495n 0.0v 429.505n 0.0v 439.495n 0.0v 439.505n 0.0v 449.495n 0.0v 449.505n 0.0v 459.495n 0.0v 459.505n 0.0v 469.495n 0.0v 469.505n 0.0v 479.495n 0.0v 479.505n 0.0v 489.495n 0.0v 489.505n 0.0v 499.495n 0.0v 499.505n 0.0v 509.495n 0.0v 509.505n 0.0v 519.495n 0.0v 519.505n 0.0v 529.495n 0.0v 529.505n 0.0v 539.495n 0.0v 539.505n 1.95v 549.495n 1.95v 549.505n 1.95v 559.495n 1.95v 559.505n 1.95v 569.495n 1.95v 569.505n 1.95v 579.495n 1.95v 579.505n 1.95v 589.495n 1.95v 589.505n 1.95v 599.495n 1.95v 599.505n 1.95v 609.495n 1.95v 609.505n 1.95v 619.495n 1.95v 619.505n 1.95v 629.495n 1.95v 629.505n 1.95v 639.495n 1.95v 639.505n 0.0v 649.495n 0.0v 649.505n 0.0v 659.495n 0.0v 659.505n 0.0v 669.495n 0.0v 669.505n 1.95v 679.495n 1.95v 679.505n 1.95v 689.495n 1.95v 689.505n 1.95v 699.495n 1.95v 699.505n 1.95v 709.495n 1.95v 709.505n 1.95v 719.495n 1.95v 719.505n 1.95v 729.495n 1.95v 729.505n 0.0v 739.495n 0.0v 739.505n 0.0v 749.495n 0.0v 749.505n 0.0v 759.495n 0.0v 759.505n 0.0v 769.495n 0.0v 769.505n 0.0v 779.495n 0.0v 779.505n 0.0v 789.495n 0.0v 789.505n 0.0v 799.495n 0.0v 799.505n 0.0v 809.495n 0.0v 809.505n 1.95v 819.495n 1.95v 819.505n 1.95v 829.495n 1.95v 829.505n 0.0v 839.495n 0.0v 839.505n 0.0v 849.495n 0.0v 849.505n 1.95v 859.495n 1.95v 859.505n 1.95v 869.495n 1.95v 869.505n 1.95v 879.495n 1.95v 879.505n 1.95v 889.495n 1.95v 889.505n 1.95v 899.495n 1.95v 899.505n 1.95v 909.495n 1.95v 909.505n 1.95v 919.495n 1.95v 919.505n 1.95v 929.495n 1.95v 929.505n 1.95v 939.495n 1.95v 939.505n 0.0v 949.495n 0.0v 949.505n 0.0v 959.495n 0.0v 959.505n 0.0v 969.495n 0.0v 969.505n 1.95v 979.495n 1.95v 979.505n 0.0v 989.495n 0.0v 989.505n 1.95v 999.495n 1.95v 999.505n 1.95v 1009.495n 1.95v 1009.505n 0.0v 1019.495n 0.0v 1019.505n 0.0v 1029.495n 0.0v 1029.505n 0.0v 1039.495n 0.0v 1039.505n 0.0v 1049.495n 0.0v 1049.505n 0.0v 1059.495n 0.0v 1059.505n 0.0v 1069.495n 0.0v 1069.505n 0.0v 1079.495n 0.0v 1079.505n 0.0v 1089.495n 0.0v 1089.505n 0.0v 1099.495n 0.0v 1099.505n 0.0v 1109.495n 0.0v 1109.505n 0.0v 1119.495n 0.0v 1119.505n 0.0v 1129.495n 0.0v 1129.505n 0.0v 1139.495n 0.0v 1139.505n 0.0v 1149.495n 0.0v 1149.505n 0.0v 1159.495n 0.0v 1159.505n 0.0v 1169.495n 0.0v 1169.505n 0.0v 1179.495n 0.0v 1179.505n 0.0v 1189.495n 0.0v 1189.505n 0.0v 1199.495n 0.0v 1199.505n 0.0v 1209.495n 0.0v 1209.505n 0.0v 1219.495n 0.0v 1219.505n 0.0v 1229.495n 0.0v 1229.505n 1.95v 1239.495n 1.95v 1239.505n 0.0v 1249.495n 0.0v 1249.505n 1.95v 1259.495n 1.95v 1259.505n 1.95v 1269.495n 1.95v 1269.505n 1.95v 1279.495n 1.95v 1279.505n 1.95v 1289.495n 1.95v 1289.505n 1.95v 1299.495n 1.95v 1299.505n 1.95v 1309.495n 1.95v 1309.505n 1.95v 1319.495n 1.95v 1319.505n 0.0v 1329.495n 0.0v 1329.505n 1.95v 1339.495n 1.95v 1339.505n 1.95v 1349.495n 1.95v 1349.505n 1.95v 1359.495n 1.95v 1359.505n 1.95v 1369.495n 1.95v 1369.505n 1.95v 1379.495n 1.95v 1379.505n 1.95v 1389.495n 1.95v 1389.505n 0.0v 1399.495n 0.0v 1399.505n 0.0v 1409.495n 0.0v 1409.505n 0.0v 1419.495n 0.0v 1419.505n 1.95v 1429.495n 1.95v 1429.505n 1.95v 1439.495n 1.95v 1439.505n 0.0v 1449.495n 0.0v 1449.505n 0.0v 1459.495n 0.0v 1459.505n 0.0v 1469.495n 0.0v 1469.505n 0.0v 1479.495n 0.0v 1479.505n 0.0v 1489.495n 0.0v 1489.505n 0.0v 1499.495n 0.0v 1499.505n 0.0v 1509.495n 0.0v 1509.505n 0.0v 1519.495n 0.0v 1519.505n 0.0v 1529.495n 0.0v 1529.505n 0.0v 1539.495n 0.0v 1539.505n 0.0v 1549.495n 0.0v 1549.505n 0.0v 1559.495n 0.0v 1559.505n 0.0v 1569.495n 0.0v 1569.505n 0.0v 1579.495n 0.0v 1579.505n 0.0v 1589.495n 0.0v 1589.505n 0.0v 1599.495n 0.0v 1599.505n 0.0v 1609.495n 0.0v 1609.505n 0.0v 1619.495n 0.0v 1619.505n 0.0v 1629.495n 0.0v 1629.505n 0.0v 1639.495n 0.0v 1639.505n 0.0v 1649.495n 0.0v 1649.505n 0.0v 1659.495n 0.0v 1659.505n 1.95v 1669.495n 1.95v 1669.505n 1.95v 1679.495n 1.95v 1679.505n 0.0v 1689.495n 0.0v 1689.505n 0.0v 1699.495n 0.0v 1699.505n 0.0v 1709.495n 0.0v 1709.505n 0.0v 1719.495n 0.0v 1719.505n 1.95v 1729.495n 1.95v 1729.505n 0.0v 1739.495n 0.0v 1739.505n 0.0v 1749.495n 0.0v 1749.505n 0.0v 1759.495n 0.0v 1759.505n 1.95v 1769.495n 1.95v 1769.505n 1.95v 1779.495n 1.95v 1779.505n 1.95v 1789.495n 1.95v 1789.505n 1.95v 1799.495n 1.95v 1799.505n 1.95v 1809.495n 1.95v 1809.505n 1.95v 1819.495n 1.95v 1819.505n 1.95v 1829.495n 1.95v 1829.505n 1.95v 1839.495n 1.95v 1839.505n 0.0v 1849.495n 0.0v 1849.505n 1.95v 1859.495n 1.95v 1859.505n 1.95v 1869.495n 1.95v 1869.505n 1.95v 1879.495n 1.95v 1879.505n 1.95v 1889.495n 1.95v 1889.505n 1.95v 1899.495n 1.95v 1899.505n 1.95v 1909.495n 1.95v 1909.505n 1.95v 1919.495n 1.95v 1919.505n 1.95v 1929.495n 1.95v 1929.505n 1.95v 1939.495n 1.95v 1939.505n 1.95v 1949.495n 1.95v 1949.505n 1.95v 1959.495n 1.95v 1959.505n 1.95v 1969.495n 1.95v 1969.505n 1.95v 1979.495n 1.95v 1979.505n 1.95v 1989.495n 1.95v 1989.505n 1.95v 1999.495n 1.95v 1999.505n 1.95v 2009.495n 1.95v 2009.505n 1.95v 2019.495n 1.95v 2019.505n 1.95v 2029.495n 1.95v 2029.505n 1.95v 2039.495n 1.95v 2039.505n 1.95v 2049.495n 1.95v 2049.505n 1.95v )
* (time, data): [(0, 0), (10, 1), (20, 0), (30, 0), (40, 0), (50, 0), (60, 0), (70, 0), (80, 0), (90, 0), (100, 0), (110, 1), (120, 1), (130, 1), (140, 1), (150, 1), (160, 1), (170, 1), (180, 1), (190, 1), (200, 1), (210, 1), (220, 1), (230, 1), (240, 1), (250, 1), (260, 1), (270, 0), (280, 0), (290, 0), (300, 1), (310, 1), (320, 1), (330, 1), (340, 1), (350, 1), (360, 1), (370, 1), (380, 1), (390, 1), (400, 1), (410, 1), (420, 0), (430, 0), (440, 0), (450, 0), (460, 0), (470, 0), (480, 0), (490, 0), (500, 1), (510, 0), (520, 0), (530, 0), (540, 1), (550, 0), (560, 0), (570, 0), (580, 0), (590, 0), (600, 0), (610, 0), (620, 0), (630, 0), (640, 0), (650, 0), (660, 0), (670, 0), (680, 0), (690, 0), (700, 0), (710, 0), (720, 0), (730, 0), (740, 0), (750, 0), (760, 0), (770, 1), (780, 1), (790, 1), (800, 1), (810, 1), (820, 1), (830, 1), (840, 1), (850, 1), (860, 1), (870, 1), (880, 1), (890, 1), (900, 1), (910, 1), (920, 1), (930, 1), (940, 1), (950, 0), (960, 0), (970, 0), (980, 0), (990, 1), (1000, 1), (1010, 1), (1020, 1), (1030, 0), (1040, 0), (1050, 0), (1060, 0), (1070, 0), (1080, 0), (1090, 0), (1100, 0), (1110, 0), (1120, 0), (1130, 0), (1140, 0), (1150, 1), (1160, 1), (1170, 1), (1180, 1), (1190, 1), (1200, 1), (1210, 0), (1220, 0), (1230, 1), (1240, 1), (1250, 1), (1260, 1), (1270, 1), (1280, 1), (1290, 0), (1300, 0), (1310, 0), (1320, 1), (1330, 1), (1340, 1), (1350, 1), (1360, 1), (1370, 1), (1380, 0), (1390, 0), (1400, 0), (1410, 0), (1420, 1), (1430, 1), (1440, 1), (1450, 1), (1460, 1), (1470, 1), (1480, 1), (1490, 1), (1500, 1), (1510, 1), (1520, 1), (1530, 1), (1540, 1), (1550, 1), (1560, 0), (1570, 0), (1580, 1), (1590, 1), (1600, 1), (1610, 0), (1620, 0), (1630, 0), (1640, 0), (1650, 0), (1660, 1), (1670, 1), (1680, 0), (1690, 1), (1700, 1), (1710, 1), (1720, 1), (1730, 1), (1740, 0), (1750, 0), (1760, 0), (1770, 0), (1780, 0), (1790, 0), (1800, 0), (1810, 1), (1820, 1), (1830, 1), (1840, 1), (1850, 1), (1860, 0), (1870, 0), (1880, 0), (1890, 0), (1900, 0), (1910, 0), (1920, 0), (1930, 0), (1940, 0), (1950, 1), (1960, 1), (1970, 0), (1980, 0), (1990, 1), (2000, 1), (2010, 1), (2020, 1), (2030, 1), (2040, 1), (2050, 1)]
Vdin0_15  din0_15  0 PWL (0n 0.0v 9.495n 0.0v 9.505n 1.95v 19.495n 1.95v 19.505n 0.0v 29.495n 0.0v 29.505n 0.0v 39.495n 0.0v 39.505n 0.0v 49.495n 0.0v 49.505n 0.0v 59.495n 0.0v 59.505n 0.0v 69.495n 0.0v 69.505n 0.0v 79.495n 0.0v 79.505n 0.0v 89.495n 0.0v 89.505n 0.0v 99.495n 0.0v 99.505n 0.0v 109.495n 0.0v 109.505n 1.95v 119.495n 1.95v 119.505n 1.95v 129.495n 1.95v 129.505n 1.95v 139.495n 1.95v 139.505n 1.95v 149.495n 1.95v 149.505n 1.95v 159.495n 1.95v 159.505n 1.95v 169.495n 1.95v 169.505n 1.95v 179.495n 1.95v 179.505n 1.95v 189.495n 1.95v 189.505n 1.95v 199.495n 1.95v 199.505n 1.95v 209.495n 1.95v 209.505n 1.95v 219.495n 1.95v 219.505n 1.95v 229.495n 1.95v 229.505n 1.95v 239.495n 1.95v 239.505n 1.95v 249.495n 1.95v 249.505n 1.95v 259.495n 1.95v 259.505n 1.95v 269.495n 1.95v 269.505n 0.0v 279.495n 0.0v 279.505n 0.0v 289.495n 0.0v 289.505n 0.0v 299.495n 0.0v 299.505n 1.95v 309.495n 1.95v 309.505n 1.95v 319.495n 1.95v 319.505n 1.95v 329.495n 1.95v 329.505n 1.95v 339.495n 1.95v 339.505n 1.95v 349.495n 1.95v 349.505n 1.95v 359.495n 1.95v 359.505n 1.95v 369.495n 1.95v 369.505n 1.95v 379.495n 1.95v 379.505n 1.95v 389.495n 1.95v 389.505n 1.95v 399.495n 1.95v 399.505n 1.95v 409.495n 1.95v 409.505n 1.95v 419.495n 1.95v 419.505n 0.0v 429.495n 0.0v 429.505n 0.0v 439.495n 0.0v 439.505n 0.0v 449.495n 0.0v 449.505n 0.0v 459.495n 0.0v 459.505n 0.0v 469.495n 0.0v 469.505n 0.0v 479.495n 0.0v 479.505n 0.0v 489.495n 0.0v 489.505n 0.0v 499.495n 0.0v 499.505n 1.95v 509.495n 1.95v 509.505n 0.0v 519.495n 0.0v 519.505n 0.0v 529.495n 0.0v 529.505n 0.0v 539.495n 0.0v 539.505n 1.95v 549.495n 1.95v 549.505n 0.0v 559.495n 0.0v 559.505n 0.0v 569.495n 0.0v 569.505n 0.0v 579.495n 0.0v 579.505n 0.0v 589.495n 0.0v 589.505n 0.0v 599.495n 0.0v 599.505n 0.0v 609.495n 0.0v 609.505n 0.0v 619.495n 0.0v 619.505n 0.0v 629.495n 0.0v 629.505n 0.0v 639.495n 0.0v 639.505n 0.0v 649.495n 0.0v 649.505n 0.0v 659.495n 0.0v 659.505n 0.0v 669.495n 0.0v 669.505n 0.0v 679.495n 0.0v 679.505n 0.0v 689.495n 0.0v 689.505n 0.0v 699.495n 0.0v 699.505n 0.0v 709.495n 0.0v 709.505n 0.0v 719.495n 0.0v 719.505n 0.0v 729.495n 0.0v 729.505n 0.0v 739.495n 0.0v 739.505n 0.0v 749.495n 0.0v 749.505n 0.0v 759.495n 0.0v 759.505n 0.0v 769.495n 0.0v 769.505n 1.95v 779.495n 1.95v 779.505n 1.95v 789.495n 1.95v 789.505n 1.95v 799.495n 1.95v 799.505n 1.95v 809.495n 1.95v 809.505n 1.95v 819.495n 1.95v 819.505n 1.95v 829.495n 1.95v 829.505n 1.95v 839.495n 1.95v 839.505n 1.95v 849.495n 1.95v 849.505n 1.95v 859.495n 1.95v 859.505n 1.95v 869.495n 1.95v 869.505n 1.95v 879.495n 1.95v 879.505n 1.95v 889.495n 1.95v 889.505n 1.95v 899.495n 1.95v 899.505n 1.95v 909.495n 1.95v 909.505n 1.95v 919.495n 1.95v 919.505n 1.95v 929.495n 1.95v 929.505n 1.95v 939.495n 1.95v 939.505n 1.95v 949.495n 1.95v 949.505n 0.0v 959.495n 0.0v 959.505n 0.0v 969.495n 0.0v 969.505n 0.0v 979.495n 0.0v 979.505n 0.0v 989.495n 0.0v 989.505n 1.95v 999.495n 1.95v 999.505n 1.95v 1009.495n 1.95v 1009.505n 1.95v 1019.495n 1.95v 1019.505n 1.95v 1029.495n 1.95v 1029.505n 0.0v 1039.495n 0.0v 1039.505n 0.0v 1049.495n 0.0v 1049.505n 0.0v 1059.495n 0.0v 1059.505n 0.0v 1069.495n 0.0v 1069.505n 0.0v 1079.495n 0.0v 1079.505n 0.0v 1089.495n 0.0v 1089.505n 0.0v 1099.495n 0.0v 1099.505n 0.0v 1109.495n 0.0v 1109.505n 0.0v 1119.495n 0.0v 1119.505n 0.0v 1129.495n 0.0v 1129.505n 0.0v 1139.495n 0.0v 1139.505n 0.0v 1149.495n 0.0v 1149.505n 1.95v 1159.495n 1.95v 1159.505n 1.95v 1169.495n 1.95v 1169.505n 1.95v 1179.495n 1.95v 1179.505n 1.95v 1189.495n 1.95v 1189.505n 1.95v 1199.495n 1.95v 1199.505n 1.95v 1209.495n 1.95v 1209.505n 0.0v 1219.495n 0.0v 1219.505n 0.0v 1229.495n 0.0v 1229.505n 1.95v 1239.495n 1.95v 1239.505n 1.95v 1249.495n 1.95v 1249.505n 1.95v 1259.495n 1.95v 1259.505n 1.95v 1269.495n 1.95v 1269.505n 1.95v 1279.495n 1.95v 1279.505n 1.95v 1289.495n 1.95v 1289.505n 0.0v 1299.495n 0.0v 1299.505n 0.0v 1309.495n 0.0v 1309.505n 0.0v 1319.495n 0.0v 1319.505n 1.95v 1329.495n 1.95v 1329.505n 1.95v 1339.495n 1.95v 1339.505n 1.95v 1349.495n 1.95v 1349.505n 1.95v 1359.495n 1.95v 1359.505n 1.95v 1369.495n 1.95v 1369.505n 1.95v 1379.495n 1.95v 1379.505n 0.0v 1389.495n 0.0v 1389.505n 0.0v 1399.495n 0.0v 1399.505n 0.0v 1409.495n 0.0v 1409.505n 0.0v 1419.495n 0.0v 1419.505n 1.95v 1429.495n 1.95v 1429.505n 1.95v 1439.495n 1.95v 1439.505n 1.95v 1449.495n 1.95v 1449.505n 1.95v 1459.495n 1.95v 1459.505n 1.95v 1469.495n 1.95v 1469.505n 1.95v 1479.495n 1.95v 1479.505n 1.95v 1489.495n 1.95v 1489.505n 1.95v 1499.495n 1.95v 1499.505n 1.95v 1509.495n 1.95v 1509.505n 1.95v 1519.495n 1.95v 1519.505n 1.95v 1529.495n 1.95v 1529.505n 1.95v 1539.495n 1.95v 1539.505n 1.95v 1549.495n 1.95v 1549.505n 1.95v 1559.495n 1.95v 1559.505n 0.0v 1569.495n 0.0v 1569.505n 0.0v 1579.495n 0.0v 1579.505n 1.95v 1589.495n 1.95v 1589.505n 1.95v 1599.495n 1.95v 1599.505n 1.95v 1609.495n 1.95v 1609.505n 0.0v 1619.495n 0.0v 1619.505n 0.0v 1629.495n 0.0v 1629.505n 0.0v 1639.495n 0.0v 1639.505n 0.0v 1649.495n 0.0v 1649.505n 0.0v 1659.495n 0.0v 1659.505n 1.95v 1669.495n 1.95v 1669.505n 1.95v 1679.495n 1.95v 1679.505n 0.0v 1689.495n 0.0v 1689.505n 1.95v 1699.495n 1.95v 1699.505n 1.95v 1709.495n 1.95v 1709.505n 1.95v 1719.495n 1.95v 1719.505n 1.95v 1729.495n 1.95v 1729.505n 1.95v 1739.495n 1.95v 1739.505n 0.0v 1749.495n 0.0v 1749.505n 0.0v 1759.495n 0.0v 1759.505n 0.0v 1769.495n 0.0v 1769.505n 0.0v 1779.495n 0.0v 1779.505n 0.0v 1789.495n 0.0v 1789.505n 0.0v 1799.495n 0.0v 1799.505n 0.0v 1809.495n 0.0v 1809.505n 1.95v 1819.495n 1.95v 1819.505n 1.95v 1829.495n 1.95v 1829.505n 1.95v 1839.495n 1.95v 1839.505n 1.95v 1849.495n 1.95v 1849.505n 1.95v 1859.495n 1.95v 1859.505n 0.0v 1869.495n 0.0v 1869.505n 0.0v 1879.495n 0.0v 1879.505n 0.0v 1889.495n 0.0v 1889.505n 0.0v 1899.495n 0.0v 1899.505n 0.0v 1909.495n 0.0v 1909.505n 0.0v 1919.495n 0.0v 1919.505n 0.0v 1929.495n 0.0v 1929.505n 0.0v 1939.495n 0.0v 1939.505n 0.0v 1949.495n 0.0v 1949.505n 1.95v 1959.495n 1.95v 1959.505n 1.95v 1969.495n 1.95v 1969.505n 0.0v 1979.495n 0.0v 1979.505n 0.0v 1989.495n 0.0v 1989.505n 1.95v 1999.495n 1.95v 1999.505n 1.95v 2009.495n 1.95v 2009.505n 1.95v 2019.495n 1.95v 2019.505n 1.95v 2029.495n 1.95v 2029.505n 1.95v 2039.495n 1.95v 2039.505n 1.95v 2049.495n 1.95v 2049.505n 1.95v )
* (time, data): [(0, 0), (10, 1), (20, 0), (30, 1), (40, 1), (50, 1), (60, 1), (70, 1), (80, 1), (90, 1), (100, 1), (110, 1), (120, 1), (130, 1), (140, 1), (150, 1), (160, 0), (170, 0), (180, 0), (190, 0), (200, 0), (210, 0), (220, 0), (230, 0), (240, 0), (250, 0), (260, 0), (270, 0), (280, 0), (290, 0), (300, 0), (310, 0), (320, 0), (330, 0), (340, 0), (350, 0), (360, 0), (370, 1), (380, 1), (390, 1), (400, 1), (410, 1), (420, 0), (430, 0), (440, 0), (450, 0), (460, 0), (470, 0), (480, 0), (490, 0), (500, 1), (510, 1), (520, 1), (530, 1), (540, 1), (550, 0), (560, 0), (570, 0), (580, 0), (590, 0), (600, 0), (610, 0), (620, 0), (630, 0), (640, 0), (650, 1), (660, 1), (670, 0), (680, 0), (690, 0), (700, 0), (710, 0), (720, 0), (730, 1), (740, 1), (750, 1), (760, 1), (770, 1), (780, 1), (790, 1), (800, 1), (810, 1), (820, 1), (830, 1), (840, 1), (850, 0), (860, 0), (870, 0), (880, 0), (890, 0), (900, 0), (910, 0), (920, 0), (930, 0), (940, 0), (950, 0), (960, 0), (970, 1), (980, 0), (990, 1), (1000, 1), (1010, 1), (1020, 1), (1030, 1), (1040, 1), (1050, 0), (1060, 0), (1070, 0), (1080, 0), (1090, 0), (1100, 0), (1110, 0), (1120, 0), (1130, 0), (1140, 0), (1150, 0), (1160, 0), (1170, 0), (1180, 0), (1190, 0), (1200, 0), (1210, 0), (1220, 0), (1230, 1), (1240, 0), (1250, 1), (1260, 1), (1270, 1), (1280, 1), (1290, 0), (1300, 0), (1310, 0), (1320, 1), (1330, 0), (1340, 1), (1350, 1), (1360, 1), (1370, 1), (1380, 1), (1390, 1), (1400, 1), (1410, 1), (1420, 0), (1430, 0), (1440, 1), (1450, 1), (1460, 1), (1470, 1), (1480, 1), (1490, 1), (1500, 1), (1510, 1), (1520, 1), (1530, 1), (1540, 1), (1550, 1), (1560, 0), (1570, 0), (1580, 1), (1590, 1), (1600, 0), (1610, 1), (1620, 1), (1630, 1), (1640, 1), (1650, 1), (1660, 0), (1670, 0), (1680, 0), (1690, 1), (1700, 1), (1710, 1), (1720, 1), (1730, 1), (1740, 0), (1750, 0), (1760, 0), (1770, 0), (1780, 0), (1790, 0), (1800, 0), (1810, 1), (1820, 1), (1830, 1), (1840, 1), (1850, 0), (1860, 0), (1870, 0), (1880, 0), (1890, 0), (1900, 0), (1910, 0), (1920, 0), (1930, 0), (1940, 0), (1950, 1), (1960, 0), (1970, 0), (1980, 0), (1990, 0), (2000, 0), (2010, 0), (2020, 0), (2030, 0), (2040, 0), (2050, 0)]
Vdin0_16  din0_16  0 PWL (0n 0.0v 9.495n 0.0v 9.505n 1.95v 19.495n 1.95v 19.505n 0.0v 29.495n 0.0v 29.505n 1.95v 39.495n 1.95v 39.505n 1.95v 49.495n 1.95v 49.505n 1.95v 59.495n 1.95v 59.505n 1.95v 69.495n 1.95v 69.505n 1.95v 79.495n 1.95v 79.505n 1.95v 89.495n 1.95v 89.505n 1.95v 99.495n 1.95v 99.505n 1.95v 109.495n 1.95v 109.505n 1.95v 119.495n 1.95v 119.505n 1.95v 129.495n 1.95v 129.505n 1.95v 139.495n 1.95v 139.505n 1.95v 149.495n 1.95v 149.505n 1.95v 159.495n 1.95v 159.505n 0.0v 169.495n 0.0v 169.505n 0.0v 179.495n 0.0v 179.505n 0.0v 189.495n 0.0v 189.505n 0.0v 199.495n 0.0v 199.505n 0.0v 209.495n 0.0v 209.505n 0.0v 219.495n 0.0v 219.505n 0.0v 229.495n 0.0v 229.505n 0.0v 239.495n 0.0v 239.505n 0.0v 249.495n 0.0v 249.505n 0.0v 259.495n 0.0v 259.505n 0.0v 269.495n 0.0v 269.505n 0.0v 279.495n 0.0v 279.505n 0.0v 289.495n 0.0v 289.505n 0.0v 299.495n 0.0v 299.505n 0.0v 309.495n 0.0v 309.505n 0.0v 319.495n 0.0v 319.505n 0.0v 329.495n 0.0v 329.505n 0.0v 339.495n 0.0v 339.505n 0.0v 349.495n 0.0v 349.505n 0.0v 359.495n 0.0v 359.505n 0.0v 369.495n 0.0v 369.505n 1.95v 379.495n 1.95v 379.505n 1.95v 389.495n 1.95v 389.505n 1.95v 399.495n 1.95v 399.505n 1.95v 409.495n 1.95v 409.505n 1.95v 419.495n 1.95v 419.505n 0.0v 429.495n 0.0v 429.505n 0.0v 439.495n 0.0v 439.505n 0.0v 449.495n 0.0v 449.505n 0.0v 459.495n 0.0v 459.505n 0.0v 469.495n 0.0v 469.505n 0.0v 479.495n 0.0v 479.505n 0.0v 489.495n 0.0v 489.505n 0.0v 499.495n 0.0v 499.505n 1.95v 509.495n 1.95v 509.505n 1.95v 519.495n 1.95v 519.505n 1.95v 529.495n 1.95v 529.505n 1.95v 539.495n 1.95v 539.505n 1.95v 549.495n 1.95v 549.505n 0.0v 559.495n 0.0v 559.505n 0.0v 569.495n 0.0v 569.505n 0.0v 579.495n 0.0v 579.505n 0.0v 589.495n 0.0v 589.505n 0.0v 599.495n 0.0v 599.505n 0.0v 609.495n 0.0v 609.505n 0.0v 619.495n 0.0v 619.505n 0.0v 629.495n 0.0v 629.505n 0.0v 639.495n 0.0v 639.505n 0.0v 649.495n 0.0v 649.505n 1.95v 659.495n 1.95v 659.505n 1.95v 669.495n 1.95v 669.505n 0.0v 679.495n 0.0v 679.505n 0.0v 689.495n 0.0v 689.505n 0.0v 699.495n 0.0v 699.505n 0.0v 709.495n 0.0v 709.505n 0.0v 719.495n 0.0v 719.505n 0.0v 729.495n 0.0v 729.505n 1.95v 739.495n 1.95v 739.505n 1.95v 749.495n 1.95v 749.505n 1.95v 759.495n 1.95v 759.505n 1.95v 769.495n 1.95v 769.505n 1.95v 779.495n 1.95v 779.505n 1.95v 789.495n 1.95v 789.505n 1.95v 799.495n 1.95v 799.505n 1.95v 809.495n 1.95v 809.505n 1.95v 819.495n 1.95v 819.505n 1.95v 829.495n 1.95v 829.505n 1.95v 839.495n 1.95v 839.505n 1.95v 849.495n 1.95v 849.505n 0.0v 859.495n 0.0v 859.505n 0.0v 869.495n 0.0v 869.505n 0.0v 879.495n 0.0v 879.505n 0.0v 889.495n 0.0v 889.505n 0.0v 899.495n 0.0v 899.505n 0.0v 909.495n 0.0v 909.505n 0.0v 919.495n 0.0v 919.505n 0.0v 929.495n 0.0v 929.505n 0.0v 939.495n 0.0v 939.505n 0.0v 949.495n 0.0v 949.505n 0.0v 959.495n 0.0v 959.505n 0.0v 969.495n 0.0v 969.505n 1.95v 979.495n 1.95v 979.505n 0.0v 989.495n 0.0v 989.505n 1.95v 999.495n 1.95v 999.505n 1.95v 1009.495n 1.95v 1009.505n 1.95v 1019.495n 1.95v 1019.505n 1.95v 1029.495n 1.95v 1029.505n 1.95v 1039.495n 1.95v 1039.505n 1.95v 1049.495n 1.95v 1049.505n 0.0v 1059.495n 0.0v 1059.505n 0.0v 1069.495n 0.0v 1069.505n 0.0v 1079.495n 0.0v 1079.505n 0.0v 1089.495n 0.0v 1089.505n 0.0v 1099.495n 0.0v 1099.505n 0.0v 1109.495n 0.0v 1109.505n 0.0v 1119.495n 0.0v 1119.505n 0.0v 1129.495n 0.0v 1129.505n 0.0v 1139.495n 0.0v 1139.505n 0.0v 1149.495n 0.0v 1149.505n 0.0v 1159.495n 0.0v 1159.505n 0.0v 1169.495n 0.0v 1169.505n 0.0v 1179.495n 0.0v 1179.505n 0.0v 1189.495n 0.0v 1189.505n 0.0v 1199.495n 0.0v 1199.505n 0.0v 1209.495n 0.0v 1209.505n 0.0v 1219.495n 0.0v 1219.505n 0.0v 1229.495n 0.0v 1229.505n 1.95v 1239.495n 1.95v 1239.505n 0.0v 1249.495n 0.0v 1249.505n 1.95v 1259.495n 1.95v 1259.505n 1.95v 1269.495n 1.95v 1269.505n 1.95v 1279.495n 1.95v 1279.505n 1.95v 1289.495n 1.95v 1289.505n 0.0v 1299.495n 0.0v 1299.505n 0.0v 1309.495n 0.0v 1309.505n 0.0v 1319.495n 0.0v 1319.505n 1.95v 1329.495n 1.95v 1329.505n 0.0v 1339.495n 0.0v 1339.505n 1.95v 1349.495n 1.95v 1349.505n 1.95v 1359.495n 1.95v 1359.505n 1.95v 1369.495n 1.95v 1369.505n 1.95v 1379.495n 1.95v 1379.505n 1.95v 1389.495n 1.95v 1389.505n 1.95v 1399.495n 1.95v 1399.505n 1.95v 1409.495n 1.95v 1409.505n 1.95v 1419.495n 1.95v 1419.505n 0.0v 1429.495n 0.0v 1429.505n 0.0v 1439.495n 0.0v 1439.505n 1.95v 1449.495n 1.95v 1449.505n 1.95v 1459.495n 1.95v 1459.505n 1.95v 1469.495n 1.95v 1469.505n 1.95v 1479.495n 1.95v 1479.505n 1.95v 1489.495n 1.95v 1489.505n 1.95v 1499.495n 1.95v 1499.505n 1.95v 1509.495n 1.95v 1509.505n 1.95v 1519.495n 1.95v 1519.505n 1.95v 1529.495n 1.95v 1529.505n 1.95v 1539.495n 1.95v 1539.505n 1.95v 1549.495n 1.95v 1549.505n 1.95v 1559.495n 1.95v 1559.505n 0.0v 1569.495n 0.0v 1569.505n 0.0v 1579.495n 0.0v 1579.505n 1.95v 1589.495n 1.95v 1589.505n 1.95v 1599.495n 1.95v 1599.505n 0.0v 1609.495n 0.0v 1609.505n 1.95v 1619.495n 1.95v 1619.505n 1.95v 1629.495n 1.95v 1629.505n 1.95v 1639.495n 1.95v 1639.505n 1.95v 1649.495n 1.95v 1649.505n 1.95v 1659.495n 1.95v 1659.505n 0.0v 1669.495n 0.0v 1669.505n 0.0v 1679.495n 0.0v 1679.505n 0.0v 1689.495n 0.0v 1689.505n 1.95v 1699.495n 1.95v 1699.505n 1.95v 1709.495n 1.95v 1709.505n 1.95v 1719.495n 1.95v 1719.505n 1.95v 1729.495n 1.95v 1729.505n 1.95v 1739.495n 1.95v 1739.505n 0.0v 1749.495n 0.0v 1749.505n 0.0v 1759.495n 0.0v 1759.505n 0.0v 1769.495n 0.0v 1769.505n 0.0v 1779.495n 0.0v 1779.505n 0.0v 1789.495n 0.0v 1789.505n 0.0v 1799.495n 0.0v 1799.505n 0.0v 1809.495n 0.0v 1809.505n 1.95v 1819.495n 1.95v 1819.505n 1.95v 1829.495n 1.95v 1829.505n 1.95v 1839.495n 1.95v 1839.505n 1.95v 1849.495n 1.95v 1849.505n 0.0v 1859.495n 0.0v 1859.505n 0.0v 1869.495n 0.0v 1869.505n 0.0v 1879.495n 0.0v 1879.505n 0.0v 1889.495n 0.0v 1889.505n 0.0v 1899.495n 0.0v 1899.505n 0.0v 1909.495n 0.0v 1909.505n 0.0v 1919.495n 0.0v 1919.505n 0.0v 1929.495n 0.0v 1929.505n 0.0v 1939.495n 0.0v 1939.505n 0.0v 1949.495n 0.0v 1949.505n 1.95v 1959.495n 1.95v 1959.505n 0.0v 1969.495n 0.0v 1969.505n 0.0v 1979.495n 0.0v 1979.505n 0.0v 1989.495n 0.0v 1989.505n 0.0v 1999.495n 0.0v 1999.505n 0.0v 2009.495n 0.0v 2009.505n 0.0v 2019.495n 0.0v 2019.505n 0.0v 2029.495n 0.0v 2029.505n 0.0v 2039.495n 0.0v 2039.505n 0.0v 2049.495n 0.0v 2049.505n 0.0v )
* (time, data): [(0, 0), (10, 0), (20, 0), (30, 1), (40, 1), (50, 1), (60, 0), (70, 0), (80, 1), (90, 1), (100, 1), (110, 1), (120, 1), (130, 1), (140, 1), (150, 1), (160, 0), (170, 0), (180, 0), (190, 0), (200, 0), (210, 0), (220, 0), (230, 0), (240, 1), (250, 1), (260, 1), (270, 0), (280, 0), (290, 0), (300, 1), (310, 1), (320, 1), (330, 1), (340, 1), (350, 1), (360, 1), (370, 0), (380, 0), (390, 0), (400, 0), (410, 0), (420, 1), (430, 1), (440, 1), (450, 1), (460, 1), (470, 1), (480, 1), (490, 1), (500, 1), (510, 0), (520, 0), (530, 0), (540, 1), (550, 1), (560, 1), (570, 1), (580, 1), (590, 0), (600, 0), (610, 0), (620, 0), (630, 0), (640, 0), (650, 0), (660, 0), (670, 0), (680, 0), (690, 0), (700, 0), (710, 0), (720, 0), (730, 1), (740, 1), (750, 0), (760, 0), (770, 1), (780, 1), (790, 0), (800, 0), (810, 1), (820, 1), (830, 1), (840, 1), (850, 1), (860, 1), (870, 1), (880, 1), (890, 1), (900, 1), (910, 1), (920, 1), (930, 1), (940, 0), (950, 0), (960, 0), (970, 0), (980, 1), (990, 0), (1000, 0), (1010, 0), (1020, 0), (1030, 0), (1040, 0), (1050, 0), (1060, 0), (1070, 0), (1080, 0), (1090, 0), (1100, 0), (1110, 1), (1120, 1), (1130, 1), (1140, 1), (1150, 0), (1160, 0), (1170, 0), (1180, 0), (1190, 0), (1200, 0), (1210, 1), (1220, 1), (1230, 1), (1240, 0), (1250, 0), (1260, 0), (1270, 0), (1280, 0), (1290, 0), (1300, 0), (1310, 0), (1320, 1), (1330, 0), (1340, 0), (1350, 0), (1360, 0), (1370, 0), (1380, 1), (1390, 1), (1400, 1), (1410, 1), (1420, 1), (1430, 1), (1440, 0), (1450, 0), (1460, 0), (1470, 0), (1480, 0), (1490, 0), (1500, 0), (1510, 0), (1520, 0), (1530, 0), (1540, 0), (1550, 0), (1560, 0), (1570, 0), (1580, 1), (1590, 1), (1600, 0), (1610, 0), (1620, 0), (1630, 0), (1640, 0), (1650, 0), (1660, 0), (1670, 0), (1680, 0), (1690, 0), (1700, 0), (1710, 0), (1720, 1), (1730, 0), (1740, 1), (1750, 1), (1760, 1), (1770, 1), (1780, 1), (1790, 1), (1800, 1), (1810, 0), (1820, 0), (1830, 0), (1840, 1), (1850, 0), (1860, 0), (1870, 0), (1880, 0), (1890, 0), (1900, 0), (1910, 0), (1920, 0), (1930, 0), (1940, 0), (1950, 1), (1960, 0), (1970, 0), (1980, 0), (1990, 0), (2000, 0), (2010, 0), (2020, 0), (2030, 0), (2040, 0), (2050, 0)]
Vdin0_17  din0_17  0 PWL (0n 0.0v 9.495n 0.0v 9.505n 0.0v 19.495n 0.0v 19.505n 0.0v 29.495n 0.0v 29.505n 1.95v 39.495n 1.95v 39.505n 1.95v 49.495n 1.95v 49.505n 1.95v 59.495n 1.95v 59.505n 0.0v 69.495n 0.0v 69.505n 0.0v 79.495n 0.0v 79.505n 1.95v 89.495n 1.95v 89.505n 1.95v 99.495n 1.95v 99.505n 1.95v 109.495n 1.95v 109.505n 1.95v 119.495n 1.95v 119.505n 1.95v 129.495n 1.95v 129.505n 1.95v 139.495n 1.95v 139.505n 1.95v 149.495n 1.95v 149.505n 1.95v 159.495n 1.95v 159.505n 0.0v 169.495n 0.0v 169.505n 0.0v 179.495n 0.0v 179.505n 0.0v 189.495n 0.0v 189.505n 0.0v 199.495n 0.0v 199.505n 0.0v 209.495n 0.0v 209.505n 0.0v 219.495n 0.0v 219.505n 0.0v 229.495n 0.0v 229.505n 0.0v 239.495n 0.0v 239.505n 1.95v 249.495n 1.95v 249.505n 1.95v 259.495n 1.95v 259.505n 1.95v 269.495n 1.95v 269.505n 0.0v 279.495n 0.0v 279.505n 0.0v 289.495n 0.0v 289.505n 0.0v 299.495n 0.0v 299.505n 1.95v 309.495n 1.95v 309.505n 1.95v 319.495n 1.95v 319.505n 1.95v 329.495n 1.95v 329.505n 1.95v 339.495n 1.95v 339.505n 1.95v 349.495n 1.95v 349.505n 1.95v 359.495n 1.95v 359.505n 1.95v 369.495n 1.95v 369.505n 0.0v 379.495n 0.0v 379.505n 0.0v 389.495n 0.0v 389.505n 0.0v 399.495n 0.0v 399.505n 0.0v 409.495n 0.0v 409.505n 0.0v 419.495n 0.0v 419.505n 1.95v 429.495n 1.95v 429.505n 1.95v 439.495n 1.95v 439.505n 1.95v 449.495n 1.95v 449.505n 1.95v 459.495n 1.95v 459.505n 1.95v 469.495n 1.95v 469.505n 1.95v 479.495n 1.95v 479.505n 1.95v 489.495n 1.95v 489.505n 1.95v 499.495n 1.95v 499.505n 1.95v 509.495n 1.95v 509.505n 0.0v 519.495n 0.0v 519.505n 0.0v 529.495n 0.0v 529.505n 0.0v 539.495n 0.0v 539.505n 1.95v 549.495n 1.95v 549.505n 1.95v 559.495n 1.95v 559.505n 1.95v 569.495n 1.95v 569.505n 1.95v 579.495n 1.95v 579.505n 1.95v 589.495n 1.95v 589.505n 0.0v 599.495n 0.0v 599.505n 0.0v 609.495n 0.0v 609.505n 0.0v 619.495n 0.0v 619.505n 0.0v 629.495n 0.0v 629.505n 0.0v 639.495n 0.0v 639.505n 0.0v 649.495n 0.0v 649.505n 0.0v 659.495n 0.0v 659.505n 0.0v 669.495n 0.0v 669.505n 0.0v 679.495n 0.0v 679.505n 0.0v 689.495n 0.0v 689.505n 0.0v 699.495n 0.0v 699.505n 0.0v 709.495n 0.0v 709.505n 0.0v 719.495n 0.0v 719.505n 0.0v 729.495n 0.0v 729.505n 1.95v 739.495n 1.95v 739.505n 1.95v 749.495n 1.95v 749.505n 0.0v 759.495n 0.0v 759.505n 0.0v 769.495n 0.0v 769.505n 1.95v 779.495n 1.95v 779.505n 1.95v 789.495n 1.95v 789.505n 0.0v 799.495n 0.0v 799.505n 0.0v 809.495n 0.0v 809.505n 1.95v 819.495n 1.95v 819.505n 1.95v 829.495n 1.95v 829.505n 1.95v 839.495n 1.95v 839.505n 1.95v 849.495n 1.95v 849.505n 1.95v 859.495n 1.95v 859.505n 1.95v 869.495n 1.95v 869.505n 1.95v 879.495n 1.95v 879.505n 1.95v 889.495n 1.95v 889.505n 1.95v 899.495n 1.95v 899.505n 1.95v 909.495n 1.95v 909.505n 1.95v 919.495n 1.95v 919.505n 1.95v 929.495n 1.95v 929.505n 1.95v 939.495n 1.95v 939.505n 0.0v 949.495n 0.0v 949.505n 0.0v 959.495n 0.0v 959.505n 0.0v 969.495n 0.0v 969.505n 0.0v 979.495n 0.0v 979.505n 1.95v 989.495n 1.95v 989.505n 0.0v 999.495n 0.0v 999.505n 0.0v 1009.495n 0.0v 1009.505n 0.0v 1019.495n 0.0v 1019.505n 0.0v 1029.495n 0.0v 1029.505n 0.0v 1039.495n 0.0v 1039.505n 0.0v 1049.495n 0.0v 1049.505n 0.0v 1059.495n 0.0v 1059.505n 0.0v 1069.495n 0.0v 1069.505n 0.0v 1079.495n 0.0v 1079.505n 0.0v 1089.495n 0.0v 1089.505n 0.0v 1099.495n 0.0v 1099.505n 0.0v 1109.495n 0.0v 1109.505n 1.95v 1119.495n 1.95v 1119.505n 1.95v 1129.495n 1.95v 1129.505n 1.95v 1139.495n 1.95v 1139.505n 1.95v 1149.495n 1.95v 1149.505n 0.0v 1159.495n 0.0v 1159.505n 0.0v 1169.495n 0.0v 1169.505n 0.0v 1179.495n 0.0v 1179.505n 0.0v 1189.495n 0.0v 1189.505n 0.0v 1199.495n 0.0v 1199.505n 0.0v 1209.495n 0.0v 1209.505n 1.95v 1219.495n 1.95v 1219.505n 1.95v 1229.495n 1.95v 1229.505n 1.95v 1239.495n 1.95v 1239.505n 0.0v 1249.495n 0.0v 1249.505n 0.0v 1259.495n 0.0v 1259.505n 0.0v 1269.495n 0.0v 1269.505n 0.0v 1279.495n 0.0v 1279.505n 0.0v 1289.495n 0.0v 1289.505n 0.0v 1299.495n 0.0v 1299.505n 0.0v 1309.495n 0.0v 1309.505n 0.0v 1319.495n 0.0v 1319.505n 1.95v 1329.495n 1.95v 1329.505n 0.0v 1339.495n 0.0v 1339.505n 0.0v 1349.495n 0.0v 1349.505n 0.0v 1359.495n 0.0v 1359.505n 0.0v 1369.495n 0.0v 1369.505n 0.0v 1379.495n 0.0v 1379.505n 1.95v 1389.495n 1.95v 1389.505n 1.95v 1399.495n 1.95v 1399.505n 1.95v 1409.495n 1.95v 1409.505n 1.95v 1419.495n 1.95v 1419.505n 1.95v 1429.495n 1.95v 1429.505n 1.95v 1439.495n 1.95v 1439.505n 0.0v 1449.495n 0.0v 1449.505n 0.0v 1459.495n 0.0v 1459.505n 0.0v 1469.495n 0.0v 1469.505n 0.0v 1479.495n 0.0v 1479.505n 0.0v 1489.495n 0.0v 1489.505n 0.0v 1499.495n 0.0v 1499.505n 0.0v 1509.495n 0.0v 1509.505n 0.0v 1519.495n 0.0v 1519.505n 0.0v 1529.495n 0.0v 1529.505n 0.0v 1539.495n 0.0v 1539.505n 0.0v 1549.495n 0.0v 1549.505n 0.0v 1559.495n 0.0v 1559.505n 0.0v 1569.495n 0.0v 1569.505n 0.0v 1579.495n 0.0v 1579.505n 1.95v 1589.495n 1.95v 1589.505n 1.95v 1599.495n 1.95v 1599.505n 0.0v 1609.495n 0.0v 1609.505n 0.0v 1619.495n 0.0v 1619.505n 0.0v 1629.495n 0.0v 1629.505n 0.0v 1639.495n 0.0v 1639.505n 0.0v 1649.495n 0.0v 1649.505n 0.0v 1659.495n 0.0v 1659.505n 0.0v 1669.495n 0.0v 1669.505n 0.0v 1679.495n 0.0v 1679.505n 0.0v 1689.495n 0.0v 1689.505n 0.0v 1699.495n 0.0v 1699.505n 0.0v 1709.495n 0.0v 1709.505n 0.0v 1719.495n 0.0v 1719.505n 1.95v 1729.495n 1.95v 1729.505n 0.0v 1739.495n 0.0v 1739.505n 1.95v 1749.495n 1.95v 1749.505n 1.95v 1759.495n 1.95v 1759.505n 1.95v 1769.495n 1.95v 1769.505n 1.95v 1779.495n 1.95v 1779.505n 1.95v 1789.495n 1.95v 1789.505n 1.95v 1799.495n 1.95v 1799.505n 1.95v 1809.495n 1.95v 1809.505n 0.0v 1819.495n 0.0v 1819.505n 0.0v 1829.495n 0.0v 1829.505n 0.0v 1839.495n 0.0v 1839.505n 1.95v 1849.495n 1.95v 1849.505n 0.0v 1859.495n 0.0v 1859.505n 0.0v 1869.495n 0.0v 1869.505n 0.0v 1879.495n 0.0v 1879.505n 0.0v 1889.495n 0.0v 1889.505n 0.0v 1899.495n 0.0v 1899.505n 0.0v 1909.495n 0.0v 1909.505n 0.0v 1919.495n 0.0v 1919.505n 0.0v 1929.495n 0.0v 1929.505n 0.0v 1939.495n 0.0v 1939.505n 0.0v 1949.495n 0.0v 1949.505n 1.95v 1959.495n 1.95v 1959.505n 0.0v 1969.495n 0.0v 1969.505n 0.0v 1979.495n 0.0v 1979.505n 0.0v 1989.495n 0.0v 1989.505n 0.0v 1999.495n 0.0v 1999.505n 0.0v 2009.495n 0.0v 2009.505n 0.0v 2019.495n 0.0v 2019.505n 0.0v 2029.495n 0.0v 2029.505n 0.0v 2039.495n 0.0v 2039.505n 0.0v 2049.495n 0.0v 2049.505n 0.0v )
* (time, data): [(0, 0), (10, 0), (20, 1), (30, 1), (40, 1), (50, 1), (60, 1), (70, 1), (80, 1), (90, 1), (100, 1), (110, 1), (120, 1), (130, 1), (140, 1), (150, 1), (160, 1), (170, 1), (180, 1), (190, 1), (200, 1), (210, 1), (220, 1), (230, 1), (240, 1), (250, 1), (260, 1), (270, 0), (280, 0), (290, 0), (300, 0), (310, 0), (320, 0), (330, 0), (340, 1), (350, 1), (360, 1), (370, 1), (380, 1), (390, 1), (400, 0), (410, 0), (420, 1), (430, 1), (440, 1), (450, 1), (460, 1), (470, 1), (480, 1), (490, 1), (500, 0), (510, 1), (520, 1), (530, 1), (540, 1), (550, 1), (560, 1), (570, 1), (580, 1), (590, 1), (600, 1), (610, 1), (620, 1), (630, 1), (640, 0), (650, 0), (660, 0), (670, 0), (680, 0), (690, 0), (700, 0), (710, 0), (720, 0), (730, 0), (740, 0), (750, 0), (760, 0), (770, 1), (780, 1), (790, 1), (800, 1), (810, 1), (820, 1), (830, 0), (840, 0), (850, 0), (860, 0), (870, 0), (880, 0), (890, 0), (900, 0), (910, 0), (920, 0), (930, 0), (940, 1), (950, 0), (960, 0), (970, 1), (980, 1), (990, 1), (1000, 1), (1010, 1), (1020, 1), (1030, 0), (1040, 0), (1050, 0), (1060, 0), (1070, 0), (1080, 0), (1090, 0), (1100, 0), (1110, 1), (1120, 1), (1130, 1), (1140, 1), (1150, 0), (1160, 0), (1170, 0), (1180, 0), (1190, 0), (1200, 0), (1210, 1), (1220, 1), (1230, 1), (1240, 0), (1250, 1), (1260, 1), (1270, 1), (1280, 1), (1290, 0), (1300, 0), (1310, 0), (1320, 0), (1330, 1), (1340, 0), (1350, 0), (1360, 0), (1370, 0), (1380, 0), (1390, 1), (1400, 1), (1410, 1), (1420, 1), (1430, 1), (1440, 1), (1450, 1), (1460, 1), (1470, 1), (1480, 1), (1490, 1), (1500, 1), (1510, 1), (1520, 1), (1530, 1), (1540, 1), (1550, 0), (1560, 1), (1570, 1), (1580, 0), (1590, 0), (1600, 0), (1610, 1), (1620, 1), (1630, 1), (1640, 1), (1650, 1), (1660, 1), (1670, 1), (1680, 1), (1690, 0), (1700, 0), (1710, 0), (1720, 1), (1730, 1), (1740, 1), (1750, 1), (1760, 0), (1770, 0), (1780, 0), (1790, 0), (1800, 0), (1810, 0), (1820, 0), (1830, 0), (1840, 0), (1850, 0), (1860, 1), (1870, 1), (1880, 1), (1890, 1), (1900, 1), (1910, 1), (1920, 1), (1930, 1), (1940, 1), (1950, 0), (1960, 1), (1970, 0), (1980, 0), (1990, 1), (2000, 1), (2010, 1), (2020, 1), (2030, 1), (2040, 1), (2050, 1)]
Vdin0_18  din0_18  0 PWL (0n 0.0v 9.495n 0.0v 9.505n 0.0v 19.495n 0.0v 19.505n 1.95v 29.495n 1.95v 29.505n 1.95v 39.495n 1.95v 39.505n 1.95v 49.495n 1.95v 49.505n 1.95v 59.495n 1.95v 59.505n 1.95v 69.495n 1.95v 69.505n 1.95v 79.495n 1.95v 79.505n 1.95v 89.495n 1.95v 89.505n 1.95v 99.495n 1.95v 99.505n 1.95v 109.495n 1.95v 109.505n 1.95v 119.495n 1.95v 119.505n 1.95v 129.495n 1.95v 129.505n 1.95v 139.495n 1.95v 139.505n 1.95v 149.495n 1.95v 149.505n 1.95v 159.495n 1.95v 159.505n 1.95v 169.495n 1.95v 169.505n 1.95v 179.495n 1.95v 179.505n 1.95v 189.495n 1.95v 189.505n 1.95v 199.495n 1.95v 199.505n 1.95v 209.495n 1.95v 209.505n 1.95v 219.495n 1.95v 219.505n 1.95v 229.495n 1.95v 229.505n 1.95v 239.495n 1.95v 239.505n 1.95v 249.495n 1.95v 249.505n 1.95v 259.495n 1.95v 259.505n 1.95v 269.495n 1.95v 269.505n 0.0v 279.495n 0.0v 279.505n 0.0v 289.495n 0.0v 289.505n 0.0v 299.495n 0.0v 299.505n 0.0v 309.495n 0.0v 309.505n 0.0v 319.495n 0.0v 319.505n 0.0v 329.495n 0.0v 329.505n 0.0v 339.495n 0.0v 339.505n 1.95v 349.495n 1.95v 349.505n 1.95v 359.495n 1.95v 359.505n 1.95v 369.495n 1.95v 369.505n 1.95v 379.495n 1.95v 379.505n 1.95v 389.495n 1.95v 389.505n 1.95v 399.495n 1.95v 399.505n 0.0v 409.495n 0.0v 409.505n 0.0v 419.495n 0.0v 419.505n 1.95v 429.495n 1.95v 429.505n 1.95v 439.495n 1.95v 439.505n 1.95v 449.495n 1.95v 449.505n 1.95v 459.495n 1.95v 459.505n 1.95v 469.495n 1.95v 469.505n 1.95v 479.495n 1.95v 479.505n 1.95v 489.495n 1.95v 489.505n 1.95v 499.495n 1.95v 499.505n 0.0v 509.495n 0.0v 509.505n 1.95v 519.495n 1.95v 519.505n 1.95v 529.495n 1.95v 529.505n 1.95v 539.495n 1.95v 539.505n 1.95v 549.495n 1.95v 549.505n 1.95v 559.495n 1.95v 559.505n 1.95v 569.495n 1.95v 569.505n 1.95v 579.495n 1.95v 579.505n 1.95v 589.495n 1.95v 589.505n 1.95v 599.495n 1.95v 599.505n 1.95v 609.495n 1.95v 609.505n 1.95v 619.495n 1.95v 619.505n 1.95v 629.495n 1.95v 629.505n 1.95v 639.495n 1.95v 639.505n 0.0v 649.495n 0.0v 649.505n 0.0v 659.495n 0.0v 659.505n 0.0v 669.495n 0.0v 669.505n 0.0v 679.495n 0.0v 679.505n 0.0v 689.495n 0.0v 689.505n 0.0v 699.495n 0.0v 699.505n 0.0v 709.495n 0.0v 709.505n 0.0v 719.495n 0.0v 719.505n 0.0v 729.495n 0.0v 729.505n 0.0v 739.495n 0.0v 739.505n 0.0v 749.495n 0.0v 749.505n 0.0v 759.495n 0.0v 759.505n 0.0v 769.495n 0.0v 769.505n 1.95v 779.495n 1.95v 779.505n 1.95v 789.495n 1.95v 789.505n 1.95v 799.495n 1.95v 799.505n 1.95v 809.495n 1.95v 809.505n 1.95v 819.495n 1.95v 819.505n 1.95v 829.495n 1.95v 829.505n 0.0v 839.495n 0.0v 839.505n 0.0v 849.495n 0.0v 849.505n 0.0v 859.495n 0.0v 859.505n 0.0v 869.495n 0.0v 869.505n 0.0v 879.495n 0.0v 879.505n 0.0v 889.495n 0.0v 889.505n 0.0v 899.495n 0.0v 899.505n 0.0v 909.495n 0.0v 909.505n 0.0v 919.495n 0.0v 919.505n 0.0v 929.495n 0.0v 929.505n 0.0v 939.495n 0.0v 939.505n 1.95v 949.495n 1.95v 949.505n 0.0v 959.495n 0.0v 959.505n 0.0v 969.495n 0.0v 969.505n 1.95v 979.495n 1.95v 979.505n 1.95v 989.495n 1.95v 989.505n 1.95v 999.495n 1.95v 999.505n 1.95v 1009.495n 1.95v 1009.505n 1.95v 1019.495n 1.95v 1019.505n 1.95v 1029.495n 1.95v 1029.505n 0.0v 1039.495n 0.0v 1039.505n 0.0v 1049.495n 0.0v 1049.505n 0.0v 1059.495n 0.0v 1059.505n 0.0v 1069.495n 0.0v 1069.505n 0.0v 1079.495n 0.0v 1079.505n 0.0v 1089.495n 0.0v 1089.505n 0.0v 1099.495n 0.0v 1099.505n 0.0v 1109.495n 0.0v 1109.505n 1.95v 1119.495n 1.95v 1119.505n 1.95v 1129.495n 1.95v 1129.505n 1.95v 1139.495n 1.95v 1139.505n 1.95v 1149.495n 1.95v 1149.505n 0.0v 1159.495n 0.0v 1159.505n 0.0v 1169.495n 0.0v 1169.505n 0.0v 1179.495n 0.0v 1179.505n 0.0v 1189.495n 0.0v 1189.505n 0.0v 1199.495n 0.0v 1199.505n 0.0v 1209.495n 0.0v 1209.505n 1.95v 1219.495n 1.95v 1219.505n 1.95v 1229.495n 1.95v 1229.505n 1.95v 1239.495n 1.95v 1239.505n 0.0v 1249.495n 0.0v 1249.505n 1.95v 1259.495n 1.95v 1259.505n 1.95v 1269.495n 1.95v 1269.505n 1.95v 1279.495n 1.95v 1279.505n 1.95v 1289.495n 1.95v 1289.505n 0.0v 1299.495n 0.0v 1299.505n 0.0v 1309.495n 0.0v 1309.505n 0.0v 1319.495n 0.0v 1319.505n 0.0v 1329.495n 0.0v 1329.505n 1.95v 1339.495n 1.95v 1339.505n 0.0v 1349.495n 0.0v 1349.505n 0.0v 1359.495n 0.0v 1359.505n 0.0v 1369.495n 0.0v 1369.505n 0.0v 1379.495n 0.0v 1379.505n 0.0v 1389.495n 0.0v 1389.505n 1.95v 1399.495n 1.95v 1399.505n 1.95v 1409.495n 1.95v 1409.505n 1.95v 1419.495n 1.95v 1419.505n 1.95v 1429.495n 1.95v 1429.505n 1.95v 1439.495n 1.95v 1439.505n 1.95v 1449.495n 1.95v 1449.505n 1.95v 1459.495n 1.95v 1459.505n 1.95v 1469.495n 1.95v 1469.505n 1.95v 1479.495n 1.95v 1479.505n 1.95v 1489.495n 1.95v 1489.505n 1.95v 1499.495n 1.95v 1499.505n 1.95v 1509.495n 1.95v 1509.505n 1.95v 1519.495n 1.95v 1519.505n 1.95v 1529.495n 1.95v 1529.505n 1.95v 1539.495n 1.95v 1539.505n 1.95v 1549.495n 1.95v 1549.505n 0.0v 1559.495n 0.0v 1559.505n 1.95v 1569.495n 1.95v 1569.505n 1.95v 1579.495n 1.95v 1579.505n 0.0v 1589.495n 0.0v 1589.505n 0.0v 1599.495n 0.0v 1599.505n 0.0v 1609.495n 0.0v 1609.505n 1.95v 1619.495n 1.95v 1619.505n 1.95v 1629.495n 1.95v 1629.505n 1.95v 1639.495n 1.95v 1639.505n 1.95v 1649.495n 1.95v 1649.505n 1.95v 1659.495n 1.95v 1659.505n 1.95v 1669.495n 1.95v 1669.505n 1.95v 1679.495n 1.95v 1679.505n 1.95v 1689.495n 1.95v 1689.505n 0.0v 1699.495n 0.0v 1699.505n 0.0v 1709.495n 0.0v 1709.505n 0.0v 1719.495n 0.0v 1719.505n 1.95v 1729.495n 1.95v 1729.505n 1.95v 1739.495n 1.95v 1739.505n 1.95v 1749.495n 1.95v 1749.505n 1.95v 1759.495n 1.95v 1759.505n 0.0v 1769.495n 0.0v 1769.505n 0.0v 1779.495n 0.0v 1779.505n 0.0v 1789.495n 0.0v 1789.505n 0.0v 1799.495n 0.0v 1799.505n 0.0v 1809.495n 0.0v 1809.505n 0.0v 1819.495n 0.0v 1819.505n 0.0v 1829.495n 0.0v 1829.505n 0.0v 1839.495n 0.0v 1839.505n 0.0v 1849.495n 0.0v 1849.505n 0.0v 1859.495n 0.0v 1859.505n 1.95v 1869.495n 1.95v 1869.505n 1.95v 1879.495n 1.95v 1879.505n 1.95v 1889.495n 1.95v 1889.505n 1.95v 1899.495n 1.95v 1899.505n 1.95v 1909.495n 1.95v 1909.505n 1.95v 1919.495n 1.95v 1919.505n 1.95v 1929.495n 1.95v 1929.505n 1.95v 1939.495n 1.95v 1939.505n 1.95v 1949.495n 1.95v 1949.505n 0.0v 1959.495n 0.0v 1959.505n 1.95v 1969.495n 1.95v 1969.505n 0.0v 1979.495n 0.0v 1979.505n 0.0v 1989.495n 0.0v 1989.505n 1.95v 1999.495n 1.95v 1999.505n 1.95v 2009.495n 1.95v 2009.505n 1.95v 2019.495n 1.95v 2019.505n 1.95v 2029.495n 1.95v 2029.505n 1.95v 2039.495n 1.95v 2039.505n 1.95v 2049.495n 1.95v 2049.505n 1.95v )
* (time, data): [(0, 0), (10, 1), (20, 1), (30, 1), (40, 1), (50, 1), (60, 0), (70, 1), (80, 0), (90, 0), (100, 0), (110, 1), (120, 1), (130, 1), (140, 1), (150, 1), (160, 0), (170, 0), (180, 0), (190, 0), (200, 0), (210, 0), (220, 0), (230, 0), (240, 0), (250, 0), (260, 0), (270, 1), (280, 1), (290, 1), (300, 0), (310, 0), (320, 0), (330, 0), (340, 1), (350, 1), (360, 1), (370, 1), (380, 1), (390, 1), (400, 1), (410, 1), (420, 0), (430, 0), (440, 0), (450, 0), (460, 0), (470, 0), (480, 0), (490, 0), (500, 1), (510, 1), (520, 1), (530, 1), (540, 0), (550, 0), (560, 0), (570, 0), (580, 0), (590, 0), (600, 0), (610, 0), (620, 0), (630, 0), (640, 1), (650, 1), (660, 1), (670, 0), (680, 0), (690, 0), (700, 1), (710, 1), (720, 1), (730, 0), (740, 0), (750, 1), (760, 1), (770, 1), (780, 1), (790, 0), (800, 0), (810, 1), (820, 1), (830, 0), (840, 0), (850, 0), (860, 0), (870, 0), (880, 0), (890, 0), (900, 0), (910, 0), (920, 0), (930, 0), (940, 0), (950, 0), (960, 0), (970, 0), (980, 1), (990, 0), (1000, 0), (1010, 0), (1020, 0), (1030, 1), (1040, 1), (1050, 0), (1060, 0), (1070, 0), (1080, 0), (1090, 0), (1100, 0), (1110, 0), (1120, 0), (1130, 0), (1140, 0), (1150, 1), (1160, 1), (1170, 1), (1180, 1), (1190, 1), (1200, 1), (1210, 0), (1220, 0), (1230, 0), (1240, 1), (1250, 1), (1260, 1), (1270, 1), (1280, 1), (1290, 0), (1300, 0), (1310, 0), (1320, 0), (1330, 0), (1340, 1), (1350, 1), (1360, 1), (1370, 1), (1380, 0), (1390, 1), (1400, 1), (1410, 1), (1420, 0), (1430, 0), (1440, 1), (1450, 1), (1460, 1), (1470, 1), (1480, 1), (1490, 1), (1500, 1), (1510, 1), (1520, 1), (1530, 1), (1540, 1), (1550, 1), (1560, 1), (1570, 1), (1580, 0), (1590, 0), (1600, 0), (1610, 0), (1620, 0), (1630, 0), (1640, 0), (1650, 0), (1660, 0), (1670, 0), (1680, 0), (1690, 0), (1700, 0), (1710, 0), (1720, 0), (1730, 1), (1740, 1), (1750, 1), (1760, 0), (1770, 0), (1780, 0), (1790, 0), (1800, 0), (1810, 0), (1820, 0), (1830, 0), (1840, 0), (1850, 0), (1860, 1), (1870, 1), (1880, 1), (1890, 1), (1900, 1), (1910, 1), (1920, 1), (1930, 1), (1940, 1), (1950, 0), (1960, 1), (1970, 1), (1980, 1), (1990, 0), (2000, 0), (2010, 0), (2020, 0), (2030, 0), (2040, 0), (2050, 0)]
Vdin0_19  din0_19  0 PWL (0n 0.0v 9.495n 0.0v 9.505n 1.95v 19.495n 1.95v 19.505n 1.95v 29.495n 1.95v 29.505n 1.95v 39.495n 1.95v 39.505n 1.95v 49.495n 1.95v 49.505n 1.95v 59.495n 1.95v 59.505n 0.0v 69.495n 0.0v 69.505n 1.95v 79.495n 1.95v 79.505n 0.0v 89.495n 0.0v 89.505n 0.0v 99.495n 0.0v 99.505n 0.0v 109.495n 0.0v 109.505n 1.95v 119.495n 1.95v 119.505n 1.95v 129.495n 1.95v 129.505n 1.95v 139.495n 1.95v 139.505n 1.95v 149.495n 1.95v 149.505n 1.95v 159.495n 1.95v 159.505n 0.0v 169.495n 0.0v 169.505n 0.0v 179.495n 0.0v 179.505n 0.0v 189.495n 0.0v 189.505n 0.0v 199.495n 0.0v 199.505n 0.0v 209.495n 0.0v 209.505n 0.0v 219.495n 0.0v 219.505n 0.0v 229.495n 0.0v 229.505n 0.0v 239.495n 0.0v 239.505n 0.0v 249.495n 0.0v 249.505n 0.0v 259.495n 0.0v 259.505n 0.0v 269.495n 0.0v 269.505n 1.95v 279.495n 1.95v 279.505n 1.95v 289.495n 1.95v 289.505n 1.95v 299.495n 1.95v 299.505n 0.0v 309.495n 0.0v 309.505n 0.0v 319.495n 0.0v 319.505n 0.0v 329.495n 0.0v 329.505n 0.0v 339.495n 0.0v 339.505n 1.95v 349.495n 1.95v 349.505n 1.95v 359.495n 1.95v 359.505n 1.95v 369.495n 1.95v 369.505n 1.95v 379.495n 1.95v 379.505n 1.95v 389.495n 1.95v 389.505n 1.95v 399.495n 1.95v 399.505n 1.95v 409.495n 1.95v 409.505n 1.95v 419.495n 1.95v 419.505n 0.0v 429.495n 0.0v 429.505n 0.0v 439.495n 0.0v 439.505n 0.0v 449.495n 0.0v 449.505n 0.0v 459.495n 0.0v 459.505n 0.0v 469.495n 0.0v 469.505n 0.0v 479.495n 0.0v 479.505n 0.0v 489.495n 0.0v 489.505n 0.0v 499.495n 0.0v 499.505n 1.95v 509.495n 1.95v 509.505n 1.95v 519.495n 1.95v 519.505n 1.95v 529.495n 1.95v 529.505n 1.95v 539.495n 1.95v 539.505n 0.0v 549.495n 0.0v 549.505n 0.0v 559.495n 0.0v 559.505n 0.0v 569.495n 0.0v 569.505n 0.0v 579.495n 0.0v 579.505n 0.0v 589.495n 0.0v 589.505n 0.0v 599.495n 0.0v 599.505n 0.0v 609.495n 0.0v 609.505n 0.0v 619.495n 0.0v 619.505n 0.0v 629.495n 0.0v 629.505n 0.0v 639.495n 0.0v 639.505n 1.95v 649.495n 1.95v 649.505n 1.95v 659.495n 1.95v 659.505n 1.95v 669.495n 1.95v 669.505n 0.0v 679.495n 0.0v 679.505n 0.0v 689.495n 0.0v 689.505n 0.0v 699.495n 0.0v 699.505n 1.95v 709.495n 1.95v 709.505n 1.95v 719.495n 1.95v 719.505n 1.95v 729.495n 1.95v 729.505n 0.0v 739.495n 0.0v 739.505n 0.0v 749.495n 0.0v 749.505n 1.95v 759.495n 1.95v 759.505n 1.95v 769.495n 1.95v 769.505n 1.95v 779.495n 1.95v 779.505n 1.95v 789.495n 1.95v 789.505n 0.0v 799.495n 0.0v 799.505n 0.0v 809.495n 0.0v 809.505n 1.95v 819.495n 1.95v 819.505n 1.95v 829.495n 1.95v 829.505n 0.0v 839.495n 0.0v 839.505n 0.0v 849.495n 0.0v 849.505n 0.0v 859.495n 0.0v 859.505n 0.0v 869.495n 0.0v 869.505n 0.0v 879.495n 0.0v 879.505n 0.0v 889.495n 0.0v 889.505n 0.0v 899.495n 0.0v 899.505n 0.0v 909.495n 0.0v 909.505n 0.0v 919.495n 0.0v 919.505n 0.0v 929.495n 0.0v 929.505n 0.0v 939.495n 0.0v 939.505n 0.0v 949.495n 0.0v 949.505n 0.0v 959.495n 0.0v 959.505n 0.0v 969.495n 0.0v 969.505n 0.0v 979.495n 0.0v 979.505n 1.95v 989.495n 1.95v 989.505n 0.0v 999.495n 0.0v 999.505n 0.0v 1009.495n 0.0v 1009.505n 0.0v 1019.495n 0.0v 1019.505n 0.0v 1029.495n 0.0v 1029.505n 1.95v 1039.495n 1.95v 1039.505n 1.95v 1049.495n 1.95v 1049.505n 0.0v 1059.495n 0.0v 1059.505n 0.0v 1069.495n 0.0v 1069.505n 0.0v 1079.495n 0.0v 1079.505n 0.0v 1089.495n 0.0v 1089.505n 0.0v 1099.495n 0.0v 1099.505n 0.0v 1109.495n 0.0v 1109.505n 0.0v 1119.495n 0.0v 1119.505n 0.0v 1129.495n 0.0v 1129.505n 0.0v 1139.495n 0.0v 1139.505n 0.0v 1149.495n 0.0v 1149.505n 1.95v 1159.495n 1.95v 1159.505n 1.95v 1169.495n 1.95v 1169.505n 1.95v 1179.495n 1.95v 1179.505n 1.95v 1189.495n 1.95v 1189.505n 1.95v 1199.495n 1.95v 1199.505n 1.95v 1209.495n 1.95v 1209.505n 0.0v 1219.495n 0.0v 1219.505n 0.0v 1229.495n 0.0v 1229.505n 0.0v 1239.495n 0.0v 1239.505n 1.95v 1249.495n 1.95v 1249.505n 1.95v 1259.495n 1.95v 1259.505n 1.95v 1269.495n 1.95v 1269.505n 1.95v 1279.495n 1.95v 1279.505n 1.95v 1289.495n 1.95v 1289.505n 0.0v 1299.495n 0.0v 1299.505n 0.0v 1309.495n 0.0v 1309.505n 0.0v 1319.495n 0.0v 1319.505n 0.0v 1329.495n 0.0v 1329.505n 0.0v 1339.495n 0.0v 1339.505n 1.95v 1349.495n 1.95v 1349.505n 1.95v 1359.495n 1.95v 1359.505n 1.95v 1369.495n 1.95v 1369.505n 1.95v 1379.495n 1.95v 1379.505n 0.0v 1389.495n 0.0v 1389.505n 1.95v 1399.495n 1.95v 1399.505n 1.95v 1409.495n 1.95v 1409.505n 1.95v 1419.495n 1.95v 1419.505n 0.0v 1429.495n 0.0v 1429.505n 0.0v 1439.495n 0.0v 1439.505n 1.95v 1449.495n 1.95v 1449.505n 1.95v 1459.495n 1.95v 1459.505n 1.95v 1469.495n 1.95v 1469.505n 1.95v 1479.495n 1.95v 1479.505n 1.95v 1489.495n 1.95v 1489.505n 1.95v 1499.495n 1.95v 1499.505n 1.95v 1509.495n 1.95v 1509.505n 1.95v 1519.495n 1.95v 1519.505n 1.95v 1529.495n 1.95v 1529.505n 1.95v 1539.495n 1.95v 1539.505n 1.95v 1549.495n 1.95v 1549.505n 1.95v 1559.495n 1.95v 1559.505n 1.95v 1569.495n 1.95v 1569.505n 1.95v 1579.495n 1.95v 1579.505n 0.0v 1589.495n 0.0v 1589.505n 0.0v 1599.495n 0.0v 1599.505n 0.0v 1609.495n 0.0v 1609.505n 0.0v 1619.495n 0.0v 1619.505n 0.0v 1629.495n 0.0v 1629.505n 0.0v 1639.495n 0.0v 1639.505n 0.0v 1649.495n 0.0v 1649.505n 0.0v 1659.495n 0.0v 1659.505n 0.0v 1669.495n 0.0v 1669.505n 0.0v 1679.495n 0.0v 1679.505n 0.0v 1689.495n 0.0v 1689.505n 0.0v 1699.495n 0.0v 1699.505n 0.0v 1709.495n 0.0v 1709.505n 0.0v 1719.495n 0.0v 1719.505n 0.0v 1729.495n 0.0v 1729.505n 1.95v 1739.495n 1.95v 1739.505n 1.95v 1749.495n 1.95v 1749.505n 1.95v 1759.495n 1.95v 1759.505n 0.0v 1769.495n 0.0v 1769.505n 0.0v 1779.495n 0.0v 1779.505n 0.0v 1789.495n 0.0v 1789.505n 0.0v 1799.495n 0.0v 1799.505n 0.0v 1809.495n 0.0v 1809.505n 0.0v 1819.495n 0.0v 1819.505n 0.0v 1829.495n 0.0v 1829.505n 0.0v 1839.495n 0.0v 1839.505n 0.0v 1849.495n 0.0v 1849.505n 0.0v 1859.495n 0.0v 1859.505n 1.95v 1869.495n 1.95v 1869.505n 1.95v 1879.495n 1.95v 1879.505n 1.95v 1889.495n 1.95v 1889.505n 1.95v 1899.495n 1.95v 1899.505n 1.95v 1909.495n 1.95v 1909.505n 1.95v 1919.495n 1.95v 1919.505n 1.95v 1929.495n 1.95v 1929.505n 1.95v 1939.495n 1.95v 1939.505n 1.95v 1949.495n 1.95v 1949.505n 0.0v 1959.495n 0.0v 1959.505n 1.95v 1969.495n 1.95v 1969.505n 1.95v 1979.495n 1.95v 1979.505n 1.95v 1989.495n 1.95v 1989.505n 0.0v 1999.495n 0.0v 1999.505n 0.0v 2009.495n 0.0v 2009.505n 0.0v 2019.495n 0.0v 2019.505n 0.0v 2029.495n 0.0v 2029.505n 0.0v 2039.495n 0.0v 2039.505n 0.0v 2049.495n 0.0v 2049.505n 0.0v )
* (time, data): [(0, 0), (10, 1), (20, 1), (30, 0), (40, 0), (50, 0), (60, 1), (70, 1), (80, 0), (90, 0), (100, 0), (110, 0), (120, 0), (130, 0), (140, 0), (150, 0), (160, 1), (170, 1), (180, 1), (190, 1), (200, 1), (210, 1), (220, 1), (230, 1), (240, 1), (250, 1), (260, 1), (270, 1), (280, 1), (290, 1), (300, 0), (310, 0), (320, 0), (330, 0), (340, 0), (350, 0), (360, 0), (370, 1), (380, 1), (390, 1), (400, 0), (410, 0), (420, 0), (430, 0), (440, 0), (450, 0), (460, 0), (470, 0), (480, 0), (490, 0), (500, 0), (510, 1), (520, 1), (530, 1), (540, 0), (550, 0), (560, 0), (570, 0), (580, 0), (590, 1), (600, 1), (610, 1), (620, 1), (630, 1), (640, 0), (650, 0), (660, 0), (670, 1), (680, 1), (690, 1), (700, 1), (710, 1), (720, 1), (730, 0), (740, 0), (750, 1), (760, 1), (770, 0), (780, 0), (790, 1), (800, 1), (810, 1), (820, 1), (830, 0), (840, 0), (850, 0), (860, 0), (870, 0), (880, 0), (890, 0), (900, 0), (910, 0), (920, 0), (930, 0), (940, 1), (950, 1), (960, 1), (970, 0), (980, 0), (990, 0), (1000, 0), (1010, 0), (1020, 0), (1030, 0), (1040, 0), (1050, 0), (1060, 0), (1070, 0), (1080, 0), (1090, 0), (1100, 0), (1110, 1), (1120, 1), (1130, 1), (1140, 1), (1150, 0), (1160, 0), (1170, 0), (1180, 0), (1190, 0), (1200, 0), (1210, 1), (1220, 1), (1230, 1), (1240, 0), (1250, 0), (1260, 0), (1270, 0), (1280, 0), (1290, 0), (1300, 0), (1310, 0), (1320, 0), (1330, 1), (1340, 1), (1350, 1), (1360, 1), (1370, 1), (1380, 1), (1390, 0), (1400, 0), (1410, 0), (1420, 1), (1430, 1), (1440, 1), (1450, 1), (1460, 1), (1470, 1), (1480, 1), (1490, 1), (1500, 1), (1510, 1), (1520, 1), (1530, 1), (1540, 1), (1550, 0), (1560, 1), (1570, 1), (1580, 0), (1590, 0), (1600, 1), (1610, 0), (1620, 0), (1630, 0), (1640, 0), (1650, 0), (1660, 1), (1670, 1), (1680, 0), (1690, 1), (1700, 1), (1710, 1), (1720, 0), (1730, 1), (1740, 0), (1750, 0), (1760, 1), (1770, 1), (1780, 1), (1790, 1), (1800, 1), (1810, 1), (1820, 1), (1830, 1), (1840, 0), (1850, 0), (1860, 0), (1870, 0), (1880, 0), (1890, 0), (1900, 0), (1910, 0), (1920, 0), (1930, 0), (1940, 0), (1950, 1), (1960, 1), (1970, 1), (1980, 1), (1990, 1), (2000, 1), (2010, 1), (2020, 1), (2030, 1), (2040, 1), (2050, 1)]
Vdin0_20  din0_20  0 PWL (0n 0.0v 9.495n 0.0v 9.505n 1.95v 19.495n 1.95v 19.505n 1.95v 29.495n 1.95v 29.505n 0.0v 39.495n 0.0v 39.505n 0.0v 49.495n 0.0v 49.505n 0.0v 59.495n 0.0v 59.505n 1.95v 69.495n 1.95v 69.505n 1.95v 79.495n 1.95v 79.505n 0.0v 89.495n 0.0v 89.505n 0.0v 99.495n 0.0v 99.505n 0.0v 109.495n 0.0v 109.505n 0.0v 119.495n 0.0v 119.505n 0.0v 129.495n 0.0v 129.505n 0.0v 139.495n 0.0v 139.505n 0.0v 149.495n 0.0v 149.505n 0.0v 159.495n 0.0v 159.505n 1.95v 169.495n 1.95v 169.505n 1.95v 179.495n 1.95v 179.505n 1.95v 189.495n 1.95v 189.505n 1.95v 199.495n 1.95v 199.505n 1.95v 209.495n 1.95v 209.505n 1.95v 219.495n 1.95v 219.505n 1.95v 229.495n 1.95v 229.505n 1.95v 239.495n 1.95v 239.505n 1.95v 249.495n 1.95v 249.505n 1.95v 259.495n 1.95v 259.505n 1.95v 269.495n 1.95v 269.505n 1.95v 279.495n 1.95v 279.505n 1.95v 289.495n 1.95v 289.505n 1.95v 299.495n 1.95v 299.505n 0.0v 309.495n 0.0v 309.505n 0.0v 319.495n 0.0v 319.505n 0.0v 329.495n 0.0v 329.505n 0.0v 339.495n 0.0v 339.505n 0.0v 349.495n 0.0v 349.505n 0.0v 359.495n 0.0v 359.505n 0.0v 369.495n 0.0v 369.505n 1.95v 379.495n 1.95v 379.505n 1.95v 389.495n 1.95v 389.505n 1.95v 399.495n 1.95v 399.505n 0.0v 409.495n 0.0v 409.505n 0.0v 419.495n 0.0v 419.505n 0.0v 429.495n 0.0v 429.505n 0.0v 439.495n 0.0v 439.505n 0.0v 449.495n 0.0v 449.505n 0.0v 459.495n 0.0v 459.505n 0.0v 469.495n 0.0v 469.505n 0.0v 479.495n 0.0v 479.505n 0.0v 489.495n 0.0v 489.505n 0.0v 499.495n 0.0v 499.505n 0.0v 509.495n 0.0v 509.505n 1.95v 519.495n 1.95v 519.505n 1.95v 529.495n 1.95v 529.505n 1.95v 539.495n 1.95v 539.505n 0.0v 549.495n 0.0v 549.505n 0.0v 559.495n 0.0v 559.505n 0.0v 569.495n 0.0v 569.505n 0.0v 579.495n 0.0v 579.505n 0.0v 589.495n 0.0v 589.505n 1.95v 599.495n 1.95v 599.505n 1.95v 609.495n 1.95v 609.505n 1.95v 619.495n 1.95v 619.505n 1.95v 629.495n 1.95v 629.505n 1.95v 639.495n 1.95v 639.505n 0.0v 649.495n 0.0v 649.505n 0.0v 659.495n 0.0v 659.505n 0.0v 669.495n 0.0v 669.505n 1.95v 679.495n 1.95v 679.505n 1.95v 689.495n 1.95v 689.505n 1.95v 699.495n 1.95v 699.505n 1.95v 709.495n 1.95v 709.505n 1.95v 719.495n 1.95v 719.505n 1.95v 729.495n 1.95v 729.505n 0.0v 739.495n 0.0v 739.505n 0.0v 749.495n 0.0v 749.505n 1.95v 759.495n 1.95v 759.505n 1.95v 769.495n 1.95v 769.505n 0.0v 779.495n 0.0v 779.505n 0.0v 789.495n 0.0v 789.505n 1.95v 799.495n 1.95v 799.505n 1.95v 809.495n 1.95v 809.505n 1.95v 819.495n 1.95v 819.505n 1.95v 829.495n 1.95v 829.505n 0.0v 839.495n 0.0v 839.505n 0.0v 849.495n 0.0v 849.505n 0.0v 859.495n 0.0v 859.505n 0.0v 869.495n 0.0v 869.505n 0.0v 879.495n 0.0v 879.505n 0.0v 889.495n 0.0v 889.505n 0.0v 899.495n 0.0v 899.505n 0.0v 909.495n 0.0v 909.505n 0.0v 919.495n 0.0v 919.505n 0.0v 929.495n 0.0v 929.505n 0.0v 939.495n 0.0v 939.505n 1.95v 949.495n 1.95v 949.505n 1.95v 959.495n 1.95v 959.505n 1.95v 969.495n 1.95v 969.505n 0.0v 979.495n 0.0v 979.505n 0.0v 989.495n 0.0v 989.505n 0.0v 999.495n 0.0v 999.505n 0.0v 1009.495n 0.0v 1009.505n 0.0v 1019.495n 0.0v 1019.505n 0.0v 1029.495n 0.0v 1029.505n 0.0v 1039.495n 0.0v 1039.505n 0.0v 1049.495n 0.0v 1049.505n 0.0v 1059.495n 0.0v 1059.505n 0.0v 1069.495n 0.0v 1069.505n 0.0v 1079.495n 0.0v 1079.505n 0.0v 1089.495n 0.0v 1089.505n 0.0v 1099.495n 0.0v 1099.505n 0.0v 1109.495n 0.0v 1109.505n 1.95v 1119.495n 1.95v 1119.505n 1.95v 1129.495n 1.95v 1129.505n 1.95v 1139.495n 1.95v 1139.505n 1.95v 1149.495n 1.95v 1149.505n 0.0v 1159.495n 0.0v 1159.505n 0.0v 1169.495n 0.0v 1169.505n 0.0v 1179.495n 0.0v 1179.505n 0.0v 1189.495n 0.0v 1189.505n 0.0v 1199.495n 0.0v 1199.505n 0.0v 1209.495n 0.0v 1209.505n 1.95v 1219.495n 1.95v 1219.505n 1.95v 1229.495n 1.95v 1229.505n 1.95v 1239.495n 1.95v 1239.505n 0.0v 1249.495n 0.0v 1249.505n 0.0v 1259.495n 0.0v 1259.505n 0.0v 1269.495n 0.0v 1269.505n 0.0v 1279.495n 0.0v 1279.505n 0.0v 1289.495n 0.0v 1289.505n 0.0v 1299.495n 0.0v 1299.505n 0.0v 1309.495n 0.0v 1309.505n 0.0v 1319.495n 0.0v 1319.505n 0.0v 1329.495n 0.0v 1329.505n 1.95v 1339.495n 1.95v 1339.505n 1.95v 1349.495n 1.95v 1349.505n 1.95v 1359.495n 1.95v 1359.505n 1.95v 1369.495n 1.95v 1369.505n 1.95v 1379.495n 1.95v 1379.505n 1.95v 1389.495n 1.95v 1389.505n 0.0v 1399.495n 0.0v 1399.505n 0.0v 1409.495n 0.0v 1409.505n 0.0v 1419.495n 0.0v 1419.505n 1.95v 1429.495n 1.95v 1429.505n 1.95v 1439.495n 1.95v 1439.505n 1.95v 1449.495n 1.95v 1449.505n 1.95v 1459.495n 1.95v 1459.505n 1.95v 1469.495n 1.95v 1469.505n 1.95v 1479.495n 1.95v 1479.505n 1.95v 1489.495n 1.95v 1489.505n 1.95v 1499.495n 1.95v 1499.505n 1.95v 1509.495n 1.95v 1509.505n 1.95v 1519.495n 1.95v 1519.505n 1.95v 1529.495n 1.95v 1529.505n 1.95v 1539.495n 1.95v 1539.505n 1.95v 1549.495n 1.95v 1549.505n 0.0v 1559.495n 0.0v 1559.505n 1.95v 1569.495n 1.95v 1569.505n 1.95v 1579.495n 1.95v 1579.505n 0.0v 1589.495n 0.0v 1589.505n 0.0v 1599.495n 0.0v 1599.505n 1.95v 1609.495n 1.95v 1609.505n 0.0v 1619.495n 0.0v 1619.505n 0.0v 1629.495n 0.0v 1629.505n 0.0v 1639.495n 0.0v 1639.505n 0.0v 1649.495n 0.0v 1649.505n 0.0v 1659.495n 0.0v 1659.505n 1.95v 1669.495n 1.95v 1669.505n 1.95v 1679.495n 1.95v 1679.505n 0.0v 1689.495n 0.0v 1689.505n 1.95v 1699.495n 1.95v 1699.505n 1.95v 1709.495n 1.95v 1709.505n 1.95v 1719.495n 1.95v 1719.505n 0.0v 1729.495n 0.0v 1729.505n 1.95v 1739.495n 1.95v 1739.505n 0.0v 1749.495n 0.0v 1749.505n 0.0v 1759.495n 0.0v 1759.505n 1.95v 1769.495n 1.95v 1769.505n 1.95v 1779.495n 1.95v 1779.505n 1.95v 1789.495n 1.95v 1789.505n 1.95v 1799.495n 1.95v 1799.505n 1.95v 1809.495n 1.95v 1809.505n 1.95v 1819.495n 1.95v 1819.505n 1.95v 1829.495n 1.95v 1829.505n 1.95v 1839.495n 1.95v 1839.505n 0.0v 1849.495n 0.0v 1849.505n 0.0v 1859.495n 0.0v 1859.505n 0.0v 1869.495n 0.0v 1869.505n 0.0v 1879.495n 0.0v 1879.505n 0.0v 1889.495n 0.0v 1889.505n 0.0v 1899.495n 0.0v 1899.505n 0.0v 1909.495n 0.0v 1909.505n 0.0v 1919.495n 0.0v 1919.505n 0.0v 1929.495n 0.0v 1929.505n 0.0v 1939.495n 0.0v 1939.505n 0.0v 1949.495n 0.0v 1949.505n 1.95v 1959.495n 1.95v 1959.505n 1.95v 1969.495n 1.95v 1969.505n 1.95v 1979.495n 1.95v 1979.505n 1.95v 1989.495n 1.95v 1989.505n 1.95v 1999.495n 1.95v 1999.505n 1.95v 2009.495n 1.95v 2009.505n 1.95v 2019.495n 1.95v 2019.505n 1.95v 2029.495n 1.95v 2029.505n 1.95v 2039.495n 1.95v 2039.505n 1.95v 2049.495n 1.95v 2049.505n 1.95v )
* (time, data): [(0, 0), (10, 0), (20, 0), (30, 1), (40, 1), (50, 1), (60, 1), (70, 1), (80, 1), (90, 1), (100, 1), (110, 0), (120, 0), (130, 0), (140, 0), (150, 0), (160, 0), (170, 0), (180, 0), (190, 0), (200, 0), (210, 0), (220, 0), (230, 0), (240, 0), (250, 0), (260, 0), (270, 0), (280, 0), (290, 0), (300, 1), (310, 1), (320, 1), (330, 1), (340, 0), (350, 0), (360, 0), (370, 1), (380, 1), (390, 1), (400, 0), (410, 0), (420, 1), (430, 1), (440, 1), (450, 1), (460, 1), (470, 1), (480, 1), (490, 1), (500, 0), (510, 1), (520, 1), (530, 1), (540, 1), (550, 0), (560, 0), (570, 0), (580, 0), (590, 1), (600, 1), (610, 1), (620, 1), (630, 1), (640, 0), (650, 0), (660, 0), (670, 1), (680, 1), (690, 1), (700, 1), (710, 1), (720, 1), (730, 1), (740, 1), (750, 1), (760, 1), (770, 1), (780, 0), (790, 1), (800, 1), (810, 1), (820, 1), (830, 1), (840, 1), (850, 0), (860, 0), (870, 0), (880, 0), (890, 0), (900, 0), (910, 0), (920, 0), (930, 0), (940, 0), (950, 1), (960, 1), (970, 0), (980, 1), (990, 1), (1000, 1), (1010, 0), (1020, 0), (1030, 1), (1040, 1), (1050, 1), (1060, 1), (1070, 1), (1080, 1), (1090, 1), (1100, 1), (1110, 1), (1120, 1), (1130, 1), (1140, 1), (1150, 1), (1160, 1), (1170, 1), (1180, 1), (1190, 1), (1200, 1), (1210, 1), (1220, 1), (1230, 0), (1240, 0), (1250, 0), (1260, 0), (1270, 0), (1280, 0), (1290, 0), (1300, 0), (1310, 0), (1320, 0), (1330, 1), (1340, 1), (1350, 1), (1360, 1), (1370, 1), (1380, 0), (1390, 1), (1400, 1), (1410, 1), (1420, 1), (1430, 1), (1440, 0), (1450, 0), (1460, 0), (1470, 0), (1480, 0), (1490, 0), (1500, 0), (1510, 0), (1520, 0), (1530, 0), (1540, 0), (1550, 1), (1560, 0), (1570, 0), (1580, 1), (1590, 1), (1600, 0), (1610, 0), (1620, 0), (1630, 0), (1640, 0), (1650, 0), (1660, 0), (1670, 0), (1680, 1), (1690, 1), (1700, 1), (1710, 1), (1720, 1), (1730, 0), (1740, 1), (1750, 1), (1760, 0), (1770, 0), (1780, 0), (1790, 0), (1800, 0), (1810, 0), (1820, 0), (1830, 0), (1840, 0), (1850, 1), (1860, 1), (1870, 1), (1880, 1), (1890, 1), (1900, 1), (1910, 1), (1920, 1), (1930, 1), (1940, 1), (1950, 1), (1960, 1), (1970, 1), (1980, 1), (1990, 0), (2000, 0), (2010, 0), (2020, 0), (2030, 0), (2040, 0), (2050, 0)]
Vdin0_21  din0_21  0 PWL (0n 0.0v 9.495n 0.0v 9.505n 0.0v 19.495n 0.0v 19.505n 0.0v 29.495n 0.0v 29.505n 1.95v 39.495n 1.95v 39.505n 1.95v 49.495n 1.95v 49.505n 1.95v 59.495n 1.95v 59.505n 1.95v 69.495n 1.95v 69.505n 1.95v 79.495n 1.95v 79.505n 1.95v 89.495n 1.95v 89.505n 1.95v 99.495n 1.95v 99.505n 1.95v 109.495n 1.95v 109.505n 0.0v 119.495n 0.0v 119.505n 0.0v 129.495n 0.0v 129.505n 0.0v 139.495n 0.0v 139.505n 0.0v 149.495n 0.0v 149.505n 0.0v 159.495n 0.0v 159.505n 0.0v 169.495n 0.0v 169.505n 0.0v 179.495n 0.0v 179.505n 0.0v 189.495n 0.0v 189.505n 0.0v 199.495n 0.0v 199.505n 0.0v 209.495n 0.0v 209.505n 0.0v 219.495n 0.0v 219.505n 0.0v 229.495n 0.0v 229.505n 0.0v 239.495n 0.0v 239.505n 0.0v 249.495n 0.0v 249.505n 0.0v 259.495n 0.0v 259.505n 0.0v 269.495n 0.0v 269.505n 0.0v 279.495n 0.0v 279.505n 0.0v 289.495n 0.0v 289.505n 0.0v 299.495n 0.0v 299.505n 1.95v 309.495n 1.95v 309.505n 1.95v 319.495n 1.95v 319.505n 1.95v 329.495n 1.95v 329.505n 1.95v 339.495n 1.95v 339.505n 0.0v 349.495n 0.0v 349.505n 0.0v 359.495n 0.0v 359.505n 0.0v 369.495n 0.0v 369.505n 1.95v 379.495n 1.95v 379.505n 1.95v 389.495n 1.95v 389.505n 1.95v 399.495n 1.95v 399.505n 0.0v 409.495n 0.0v 409.505n 0.0v 419.495n 0.0v 419.505n 1.95v 429.495n 1.95v 429.505n 1.95v 439.495n 1.95v 439.505n 1.95v 449.495n 1.95v 449.505n 1.95v 459.495n 1.95v 459.505n 1.95v 469.495n 1.95v 469.505n 1.95v 479.495n 1.95v 479.505n 1.95v 489.495n 1.95v 489.505n 1.95v 499.495n 1.95v 499.505n 0.0v 509.495n 0.0v 509.505n 1.95v 519.495n 1.95v 519.505n 1.95v 529.495n 1.95v 529.505n 1.95v 539.495n 1.95v 539.505n 1.95v 549.495n 1.95v 549.505n 0.0v 559.495n 0.0v 559.505n 0.0v 569.495n 0.0v 569.505n 0.0v 579.495n 0.0v 579.505n 0.0v 589.495n 0.0v 589.505n 1.95v 599.495n 1.95v 599.505n 1.95v 609.495n 1.95v 609.505n 1.95v 619.495n 1.95v 619.505n 1.95v 629.495n 1.95v 629.505n 1.95v 639.495n 1.95v 639.505n 0.0v 649.495n 0.0v 649.505n 0.0v 659.495n 0.0v 659.505n 0.0v 669.495n 0.0v 669.505n 1.95v 679.495n 1.95v 679.505n 1.95v 689.495n 1.95v 689.505n 1.95v 699.495n 1.95v 699.505n 1.95v 709.495n 1.95v 709.505n 1.95v 719.495n 1.95v 719.505n 1.95v 729.495n 1.95v 729.505n 1.95v 739.495n 1.95v 739.505n 1.95v 749.495n 1.95v 749.505n 1.95v 759.495n 1.95v 759.505n 1.95v 769.495n 1.95v 769.505n 1.95v 779.495n 1.95v 779.505n 0.0v 789.495n 0.0v 789.505n 1.95v 799.495n 1.95v 799.505n 1.95v 809.495n 1.95v 809.505n 1.95v 819.495n 1.95v 819.505n 1.95v 829.495n 1.95v 829.505n 1.95v 839.495n 1.95v 839.505n 1.95v 849.495n 1.95v 849.505n 0.0v 859.495n 0.0v 859.505n 0.0v 869.495n 0.0v 869.505n 0.0v 879.495n 0.0v 879.505n 0.0v 889.495n 0.0v 889.505n 0.0v 899.495n 0.0v 899.505n 0.0v 909.495n 0.0v 909.505n 0.0v 919.495n 0.0v 919.505n 0.0v 929.495n 0.0v 929.505n 0.0v 939.495n 0.0v 939.505n 0.0v 949.495n 0.0v 949.505n 1.95v 959.495n 1.95v 959.505n 1.95v 969.495n 1.95v 969.505n 0.0v 979.495n 0.0v 979.505n 1.95v 989.495n 1.95v 989.505n 1.95v 999.495n 1.95v 999.505n 1.95v 1009.495n 1.95v 1009.505n 0.0v 1019.495n 0.0v 1019.505n 0.0v 1029.495n 0.0v 1029.505n 1.95v 1039.495n 1.95v 1039.505n 1.95v 1049.495n 1.95v 1049.505n 1.95v 1059.495n 1.95v 1059.505n 1.95v 1069.495n 1.95v 1069.505n 1.95v 1079.495n 1.95v 1079.505n 1.95v 1089.495n 1.95v 1089.505n 1.95v 1099.495n 1.95v 1099.505n 1.95v 1109.495n 1.95v 1109.505n 1.95v 1119.495n 1.95v 1119.505n 1.95v 1129.495n 1.95v 1129.505n 1.95v 1139.495n 1.95v 1139.505n 1.95v 1149.495n 1.95v 1149.505n 1.95v 1159.495n 1.95v 1159.505n 1.95v 1169.495n 1.95v 1169.505n 1.95v 1179.495n 1.95v 1179.505n 1.95v 1189.495n 1.95v 1189.505n 1.95v 1199.495n 1.95v 1199.505n 1.95v 1209.495n 1.95v 1209.505n 1.95v 1219.495n 1.95v 1219.505n 1.95v 1229.495n 1.95v 1229.505n 0.0v 1239.495n 0.0v 1239.505n 0.0v 1249.495n 0.0v 1249.505n 0.0v 1259.495n 0.0v 1259.505n 0.0v 1269.495n 0.0v 1269.505n 0.0v 1279.495n 0.0v 1279.505n 0.0v 1289.495n 0.0v 1289.505n 0.0v 1299.495n 0.0v 1299.505n 0.0v 1309.495n 0.0v 1309.505n 0.0v 1319.495n 0.0v 1319.505n 0.0v 1329.495n 0.0v 1329.505n 1.95v 1339.495n 1.95v 1339.505n 1.95v 1349.495n 1.95v 1349.505n 1.95v 1359.495n 1.95v 1359.505n 1.95v 1369.495n 1.95v 1369.505n 1.95v 1379.495n 1.95v 1379.505n 0.0v 1389.495n 0.0v 1389.505n 1.95v 1399.495n 1.95v 1399.505n 1.95v 1409.495n 1.95v 1409.505n 1.95v 1419.495n 1.95v 1419.505n 1.95v 1429.495n 1.95v 1429.505n 1.95v 1439.495n 1.95v 1439.505n 0.0v 1449.495n 0.0v 1449.505n 0.0v 1459.495n 0.0v 1459.505n 0.0v 1469.495n 0.0v 1469.505n 0.0v 1479.495n 0.0v 1479.505n 0.0v 1489.495n 0.0v 1489.505n 0.0v 1499.495n 0.0v 1499.505n 0.0v 1509.495n 0.0v 1509.505n 0.0v 1519.495n 0.0v 1519.505n 0.0v 1529.495n 0.0v 1529.505n 0.0v 1539.495n 0.0v 1539.505n 0.0v 1549.495n 0.0v 1549.505n 1.95v 1559.495n 1.95v 1559.505n 0.0v 1569.495n 0.0v 1569.505n 0.0v 1579.495n 0.0v 1579.505n 1.95v 1589.495n 1.95v 1589.505n 1.95v 1599.495n 1.95v 1599.505n 0.0v 1609.495n 0.0v 1609.505n 0.0v 1619.495n 0.0v 1619.505n 0.0v 1629.495n 0.0v 1629.505n 0.0v 1639.495n 0.0v 1639.505n 0.0v 1649.495n 0.0v 1649.505n 0.0v 1659.495n 0.0v 1659.505n 0.0v 1669.495n 0.0v 1669.505n 0.0v 1679.495n 0.0v 1679.505n 1.95v 1689.495n 1.95v 1689.505n 1.95v 1699.495n 1.95v 1699.505n 1.95v 1709.495n 1.95v 1709.505n 1.95v 1719.495n 1.95v 1719.505n 1.95v 1729.495n 1.95v 1729.505n 0.0v 1739.495n 0.0v 1739.505n 1.95v 1749.495n 1.95v 1749.505n 1.95v 1759.495n 1.95v 1759.505n 0.0v 1769.495n 0.0v 1769.505n 0.0v 1779.495n 0.0v 1779.505n 0.0v 1789.495n 0.0v 1789.505n 0.0v 1799.495n 0.0v 1799.505n 0.0v 1809.495n 0.0v 1809.505n 0.0v 1819.495n 0.0v 1819.505n 0.0v 1829.495n 0.0v 1829.505n 0.0v 1839.495n 0.0v 1839.505n 0.0v 1849.495n 0.0v 1849.505n 1.95v 1859.495n 1.95v 1859.505n 1.95v 1869.495n 1.95v 1869.505n 1.95v 1879.495n 1.95v 1879.505n 1.95v 1889.495n 1.95v 1889.505n 1.95v 1899.495n 1.95v 1899.505n 1.95v 1909.495n 1.95v 1909.505n 1.95v 1919.495n 1.95v 1919.505n 1.95v 1929.495n 1.95v 1929.505n 1.95v 1939.495n 1.95v 1939.505n 1.95v 1949.495n 1.95v 1949.505n 1.95v 1959.495n 1.95v 1959.505n 1.95v 1969.495n 1.95v 1969.505n 1.95v 1979.495n 1.95v 1979.505n 1.95v 1989.495n 1.95v 1989.505n 0.0v 1999.495n 0.0v 1999.505n 0.0v 2009.495n 0.0v 2009.505n 0.0v 2019.495n 0.0v 2019.505n 0.0v 2029.495n 0.0v 2029.505n 0.0v 2039.495n 0.0v 2039.505n 0.0v 2049.495n 0.0v 2049.505n 0.0v )
* (time, data): [(0, 0), (10, 0), (20, 1), (30, 0), (40, 0), (50, 0), (60, 0), (70, 1), (80, 0), (90, 0), (100, 0), (110, 0), (120, 0), (130, 0), (140, 0), (150, 0), (160, 1), (170, 1), (180, 1), (190, 1), (200, 1), (210, 1), (220, 1), (230, 1), (240, 1), (250, 1), (260, 1), (270, 1), (280, 1), (290, 1), (300, 1), (310, 1), (320, 1), (330, 1), (340, 1), (350, 1), (360, 1), (370, 1), (380, 1), (390, 1), (400, 0), (410, 0), (420, 1), (430, 1), (440, 1), (450, 1), (460, 1), (470, 1), (480, 1), (490, 1), (500, 1), (510, 0), (520, 0), (530, 0), (540, 1), (550, 0), (560, 0), (570, 0), (580, 0), (590, 1), (600, 1), (610, 1), (620, 1), (630, 1), (640, 1), (650, 1), (660, 1), (670, 0), (680, 0), (690, 0), (700, 1), (710, 1), (720, 1), (730, 0), (740, 0), (750, 1), (760, 1), (770, 0), (780, 0), (790, 0), (800, 0), (810, 1), (820, 1), (830, 1), (840, 1), (850, 0), (860, 0), (870, 0), (880, 0), (890, 0), (900, 0), (910, 0), (920, 0), (930, 0), (940, 0), (950, 0), (960, 0), (970, 1), (980, 1), (990, 0), (1000, 0), (1010, 1), (1020, 1), (1030, 1), (1040, 1), (1050, 0), (1060, 0), (1070, 0), (1080, 0), (1090, 0), (1100, 0), (1110, 1), (1120, 1), (1130, 1), (1140, 1), (1150, 0), (1160, 0), (1170, 0), (1180, 0), (1190, 0), (1200, 0), (1210, 0), (1220, 0), (1230, 1), (1240, 1), (1250, 1), (1260, 1), (1270, 1), (1280, 1), (1290, 1), (1300, 1), (1310, 1), (1320, 0), (1330, 1), (1340, 0), (1350, 0), (1360, 0), (1370, 0), (1380, 0), (1390, 0), (1400, 0), (1410, 0), (1420, 0), (1430, 0), (1440, 1), (1450, 1), (1460, 1), (1470, 1), (1480, 1), (1490, 1), (1500, 1), (1510, 1), (1520, 1), (1530, 1), (1540, 1), (1550, 1), (1560, 1), (1570, 1), (1580, 0), (1590, 0), (1600, 1), (1610, 1), (1620, 1), (1630, 1), (1640, 1), (1650, 1), (1660, 0), (1670, 0), (1680, 0), (1690, 0), (1700, 0), (1710, 0), (1720, 1), (1730, 0), (1740, 1), (1750, 1), (1760, 1), (1770, 1), (1780, 1), (1790, 1), (1800, 1), (1810, 1), (1820, 1), (1830, 1), (1840, 0), (1850, 1), (1860, 0), (1870, 0), (1880, 0), (1890, 0), (1900, 0), (1910, 0), (1920, 0), (1930, 0), (1940, 0), (1950, 1), (1960, 0), (1970, 0), (1980, 0), (1990, 1), (2000, 1), (2010, 1), (2020, 1), (2030, 1), (2040, 1), (2050, 1)]
Vdin0_22  din0_22  0 PWL (0n 0.0v 9.495n 0.0v 9.505n 0.0v 19.495n 0.0v 19.505n 1.95v 29.495n 1.95v 29.505n 0.0v 39.495n 0.0v 39.505n 0.0v 49.495n 0.0v 49.505n 0.0v 59.495n 0.0v 59.505n 0.0v 69.495n 0.0v 69.505n 1.95v 79.495n 1.95v 79.505n 0.0v 89.495n 0.0v 89.505n 0.0v 99.495n 0.0v 99.505n 0.0v 109.495n 0.0v 109.505n 0.0v 119.495n 0.0v 119.505n 0.0v 129.495n 0.0v 129.505n 0.0v 139.495n 0.0v 139.505n 0.0v 149.495n 0.0v 149.505n 0.0v 159.495n 0.0v 159.505n 1.95v 169.495n 1.95v 169.505n 1.95v 179.495n 1.95v 179.505n 1.95v 189.495n 1.95v 189.505n 1.95v 199.495n 1.95v 199.505n 1.95v 209.495n 1.95v 209.505n 1.95v 219.495n 1.95v 219.505n 1.95v 229.495n 1.95v 229.505n 1.95v 239.495n 1.95v 239.505n 1.95v 249.495n 1.95v 249.505n 1.95v 259.495n 1.95v 259.505n 1.95v 269.495n 1.95v 269.505n 1.95v 279.495n 1.95v 279.505n 1.95v 289.495n 1.95v 289.505n 1.95v 299.495n 1.95v 299.505n 1.95v 309.495n 1.95v 309.505n 1.95v 319.495n 1.95v 319.505n 1.95v 329.495n 1.95v 329.505n 1.95v 339.495n 1.95v 339.505n 1.95v 349.495n 1.95v 349.505n 1.95v 359.495n 1.95v 359.505n 1.95v 369.495n 1.95v 369.505n 1.95v 379.495n 1.95v 379.505n 1.95v 389.495n 1.95v 389.505n 1.95v 399.495n 1.95v 399.505n 0.0v 409.495n 0.0v 409.505n 0.0v 419.495n 0.0v 419.505n 1.95v 429.495n 1.95v 429.505n 1.95v 439.495n 1.95v 439.505n 1.95v 449.495n 1.95v 449.505n 1.95v 459.495n 1.95v 459.505n 1.95v 469.495n 1.95v 469.505n 1.95v 479.495n 1.95v 479.505n 1.95v 489.495n 1.95v 489.505n 1.95v 499.495n 1.95v 499.505n 1.95v 509.495n 1.95v 509.505n 0.0v 519.495n 0.0v 519.505n 0.0v 529.495n 0.0v 529.505n 0.0v 539.495n 0.0v 539.505n 1.95v 549.495n 1.95v 549.505n 0.0v 559.495n 0.0v 559.505n 0.0v 569.495n 0.0v 569.505n 0.0v 579.495n 0.0v 579.505n 0.0v 589.495n 0.0v 589.505n 1.95v 599.495n 1.95v 599.505n 1.95v 609.495n 1.95v 609.505n 1.95v 619.495n 1.95v 619.505n 1.95v 629.495n 1.95v 629.505n 1.95v 639.495n 1.95v 639.505n 1.95v 649.495n 1.95v 649.505n 1.95v 659.495n 1.95v 659.505n 1.95v 669.495n 1.95v 669.505n 0.0v 679.495n 0.0v 679.505n 0.0v 689.495n 0.0v 689.505n 0.0v 699.495n 0.0v 699.505n 1.95v 709.495n 1.95v 709.505n 1.95v 719.495n 1.95v 719.505n 1.95v 729.495n 1.95v 729.505n 0.0v 739.495n 0.0v 739.505n 0.0v 749.495n 0.0v 749.505n 1.95v 759.495n 1.95v 759.505n 1.95v 769.495n 1.95v 769.505n 0.0v 779.495n 0.0v 779.505n 0.0v 789.495n 0.0v 789.505n 0.0v 799.495n 0.0v 799.505n 0.0v 809.495n 0.0v 809.505n 1.95v 819.495n 1.95v 819.505n 1.95v 829.495n 1.95v 829.505n 1.95v 839.495n 1.95v 839.505n 1.95v 849.495n 1.95v 849.505n 0.0v 859.495n 0.0v 859.505n 0.0v 869.495n 0.0v 869.505n 0.0v 879.495n 0.0v 879.505n 0.0v 889.495n 0.0v 889.505n 0.0v 899.495n 0.0v 899.505n 0.0v 909.495n 0.0v 909.505n 0.0v 919.495n 0.0v 919.505n 0.0v 929.495n 0.0v 929.505n 0.0v 939.495n 0.0v 939.505n 0.0v 949.495n 0.0v 949.505n 0.0v 959.495n 0.0v 959.505n 0.0v 969.495n 0.0v 969.505n 1.95v 979.495n 1.95v 979.505n 1.95v 989.495n 1.95v 989.505n 0.0v 999.495n 0.0v 999.505n 0.0v 1009.495n 0.0v 1009.505n 1.95v 1019.495n 1.95v 1019.505n 1.95v 1029.495n 1.95v 1029.505n 1.95v 1039.495n 1.95v 1039.505n 1.95v 1049.495n 1.95v 1049.505n 0.0v 1059.495n 0.0v 1059.505n 0.0v 1069.495n 0.0v 1069.505n 0.0v 1079.495n 0.0v 1079.505n 0.0v 1089.495n 0.0v 1089.505n 0.0v 1099.495n 0.0v 1099.505n 0.0v 1109.495n 0.0v 1109.505n 1.95v 1119.495n 1.95v 1119.505n 1.95v 1129.495n 1.95v 1129.505n 1.95v 1139.495n 1.95v 1139.505n 1.95v 1149.495n 1.95v 1149.505n 0.0v 1159.495n 0.0v 1159.505n 0.0v 1169.495n 0.0v 1169.505n 0.0v 1179.495n 0.0v 1179.505n 0.0v 1189.495n 0.0v 1189.505n 0.0v 1199.495n 0.0v 1199.505n 0.0v 1209.495n 0.0v 1209.505n 0.0v 1219.495n 0.0v 1219.505n 0.0v 1229.495n 0.0v 1229.505n 1.95v 1239.495n 1.95v 1239.505n 1.95v 1249.495n 1.95v 1249.505n 1.95v 1259.495n 1.95v 1259.505n 1.95v 1269.495n 1.95v 1269.505n 1.95v 1279.495n 1.95v 1279.505n 1.95v 1289.495n 1.95v 1289.505n 1.95v 1299.495n 1.95v 1299.505n 1.95v 1309.495n 1.95v 1309.505n 1.95v 1319.495n 1.95v 1319.505n 0.0v 1329.495n 0.0v 1329.505n 1.95v 1339.495n 1.95v 1339.505n 0.0v 1349.495n 0.0v 1349.505n 0.0v 1359.495n 0.0v 1359.505n 0.0v 1369.495n 0.0v 1369.505n 0.0v 1379.495n 0.0v 1379.505n 0.0v 1389.495n 0.0v 1389.505n 0.0v 1399.495n 0.0v 1399.505n 0.0v 1409.495n 0.0v 1409.505n 0.0v 1419.495n 0.0v 1419.505n 0.0v 1429.495n 0.0v 1429.505n 0.0v 1439.495n 0.0v 1439.505n 1.95v 1449.495n 1.95v 1449.505n 1.95v 1459.495n 1.95v 1459.505n 1.95v 1469.495n 1.95v 1469.505n 1.95v 1479.495n 1.95v 1479.505n 1.95v 1489.495n 1.95v 1489.505n 1.95v 1499.495n 1.95v 1499.505n 1.95v 1509.495n 1.95v 1509.505n 1.95v 1519.495n 1.95v 1519.505n 1.95v 1529.495n 1.95v 1529.505n 1.95v 1539.495n 1.95v 1539.505n 1.95v 1549.495n 1.95v 1549.505n 1.95v 1559.495n 1.95v 1559.505n 1.95v 1569.495n 1.95v 1569.505n 1.95v 1579.495n 1.95v 1579.505n 0.0v 1589.495n 0.0v 1589.505n 0.0v 1599.495n 0.0v 1599.505n 1.95v 1609.495n 1.95v 1609.505n 1.95v 1619.495n 1.95v 1619.505n 1.95v 1629.495n 1.95v 1629.505n 1.95v 1639.495n 1.95v 1639.505n 1.95v 1649.495n 1.95v 1649.505n 1.95v 1659.495n 1.95v 1659.505n 0.0v 1669.495n 0.0v 1669.505n 0.0v 1679.495n 0.0v 1679.505n 0.0v 1689.495n 0.0v 1689.505n 0.0v 1699.495n 0.0v 1699.505n 0.0v 1709.495n 0.0v 1709.505n 0.0v 1719.495n 0.0v 1719.505n 1.95v 1729.495n 1.95v 1729.505n 0.0v 1739.495n 0.0v 1739.505n 1.95v 1749.495n 1.95v 1749.505n 1.95v 1759.495n 1.95v 1759.505n 1.95v 1769.495n 1.95v 1769.505n 1.95v 1779.495n 1.95v 1779.505n 1.95v 1789.495n 1.95v 1789.505n 1.95v 1799.495n 1.95v 1799.505n 1.95v 1809.495n 1.95v 1809.505n 1.95v 1819.495n 1.95v 1819.505n 1.95v 1829.495n 1.95v 1829.505n 1.95v 1839.495n 1.95v 1839.505n 0.0v 1849.495n 0.0v 1849.505n 1.95v 1859.495n 1.95v 1859.505n 0.0v 1869.495n 0.0v 1869.505n 0.0v 1879.495n 0.0v 1879.505n 0.0v 1889.495n 0.0v 1889.505n 0.0v 1899.495n 0.0v 1899.505n 0.0v 1909.495n 0.0v 1909.505n 0.0v 1919.495n 0.0v 1919.505n 0.0v 1929.495n 0.0v 1929.505n 0.0v 1939.495n 0.0v 1939.505n 0.0v 1949.495n 0.0v 1949.505n 1.95v 1959.495n 1.95v 1959.505n 0.0v 1969.495n 0.0v 1969.505n 0.0v 1979.495n 0.0v 1979.505n 0.0v 1989.495n 0.0v 1989.505n 1.95v 1999.495n 1.95v 1999.505n 1.95v 2009.495n 1.95v 2009.505n 1.95v 2019.495n 1.95v 2019.505n 1.95v 2029.495n 1.95v 2029.505n 1.95v 2039.495n 1.95v 2039.505n 1.95v 2049.495n 1.95v 2049.505n 1.95v )
* (time, data): [(0, 0), (10, 1), (20, 1), (30, 1), (40, 1), (50, 1), (60, 0), (70, 0), (80, 0), (90, 0), (100, 0), (110, 0), (120, 0), (130, 0), (140, 0), (150, 0), (160, 0), (170, 0), (180, 0), (190, 0), (200, 0), (210, 0), (220, 0), (230, 0), (240, 0), (250, 0), (260, 0), (270, 1), (280, 1), (290, 1), (300, 0), (310, 0), (320, 0), (330, 0), (340, 0), (350, 0), (360, 0), (370, 1), (380, 1), (390, 1), (400, 0), (410, 0), (420, 0), (430, 0), (440, 0), (450, 0), (460, 0), (470, 0), (480, 0), (490, 0), (500, 0), (510, 1), (520, 1), (530, 1), (540, 1), (550, 1), (560, 1), (570, 1), (580, 1), (590, 0), (600, 0), (610, 0), (620, 0), (630, 0), (640, 0), (650, 1), (660, 1), (670, 1), (680, 1), (690, 1), (700, 0), (710, 0), (720, 0), (730, 0), (740, 0), (750, 0), (760, 0), (770, 1), (780, 0), (790, 1), (800, 1), (810, 1), (820, 1), (830, 1), (840, 1), (850, 0), (860, 0), (870, 0), (880, 0), (890, 0), (900, 0), (910, 0), (920, 0), (930, 0), (940, 0), (950, 1), (960, 1), (970, 1), (980, 1), (990, 0), (1000, 0), (1010, 1), (1020, 1), (1030, 0), (1040, 0), (1050, 0), (1060, 0), (1070, 0), (1080, 0), (1090, 0), (1100, 0), (1110, 0), (1120, 0), (1130, 0), (1140, 0), (1150, 1), (1160, 1), (1170, 1), (1180, 1), (1190, 1), (1200, 1), (1210, 0), (1220, 0), (1230, 0), (1240, 0), (1250, 0), (1260, 0), (1270, 0), (1280, 0), (1290, 0), (1300, 0), (1310, 0), (1320, 1), (1330, 1), (1340, 1), (1350, 1), (1360, 1), (1370, 1), (1380, 0), (1390, 0), (1400, 0), (1410, 0), (1420, 0), (1430, 0), (1440, 0), (1450, 0), (1460, 0), (1470, 0), (1480, 0), (1490, 0), (1500, 0), (1510, 0), (1520, 0), (1530, 0), (1540, 0), (1550, 0), (1560, 1), (1570, 1), (1580, 1), (1590, 1), (1600, 0), (1610, 0), (1620, 0), (1630, 0), (1640, 0), (1650, 0), (1660, 0), (1670, 0), (1680, 1), (1690, 1), (1700, 1), (1710, 1), (1720, 0), (1730, 0), (1740, 1), (1750, 1), (1760, 0), (1770, 0), (1780, 0), (1790, 0), (1800, 0), (1810, 0), (1820, 0), (1830, 0), (1840, 0), (1850, 0), (1860, 0), (1870, 0), (1880, 0), (1890, 0), (1900, 0), (1910, 0), (1920, 0), (1930, 0), (1940, 0), (1950, 1), (1960, 1), (1970, 1), (1980, 1), (1990, 0), (2000, 0), (2010, 0), (2020, 0), (2030, 0), (2040, 0), (2050, 0)]
Vdin0_23  din0_23  0 PWL (0n 0.0v 9.495n 0.0v 9.505n 1.95v 19.495n 1.95v 19.505n 1.95v 29.495n 1.95v 29.505n 1.95v 39.495n 1.95v 39.505n 1.95v 49.495n 1.95v 49.505n 1.95v 59.495n 1.95v 59.505n 0.0v 69.495n 0.0v 69.505n 0.0v 79.495n 0.0v 79.505n 0.0v 89.495n 0.0v 89.505n 0.0v 99.495n 0.0v 99.505n 0.0v 109.495n 0.0v 109.505n 0.0v 119.495n 0.0v 119.505n 0.0v 129.495n 0.0v 129.505n 0.0v 139.495n 0.0v 139.505n 0.0v 149.495n 0.0v 149.505n 0.0v 159.495n 0.0v 159.505n 0.0v 169.495n 0.0v 169.505n 0.0v 179.495n 0.0v 179.505n 0.0v 189.495n 0.0v 189.505n 0.0v 199.495n 0.0v 199.505n 0.0v 209.495n 0.0v 209.505n 0.0v 219.495n 0.0v 219.505n 0.0v 229.495n 0.0v 229.505n 0.0v 239.495n 0.0v 239.505n 0.0v 249.495n 0.0v 249.505n 0.0v 259.495n 0.0v 259.505n 0.0v 269.495n 0.0v 269.505n 1.95v 279.495n 1.95v 279.505n 1.95v 289.495n 1.95v 289.505n 1.95v 299.495n 1.95v 299.505n 0.0v 309.495n 0.0v 309.505n 0.0v 319.495n 0.0v 319.505n 0.0v 329.495n 0.0v 329.505n 0.0v 339.495n 0.0v 339.505n 0.0v 349.495n 0.0v 349.505n 0.0v 359.495n 0.0v 359.505n 0.0v 369.495n 0.0v 369.505n 1.95v 379.495n 1.95v 379.505n 1.95v 389.495n 1.95v 389.505n 1.95v 399.495n 1.95v 399.505n 0.0v 409.495n 0.0v 409.505n 0.0v 419.495n 0.0v 419.505n 0.0v 429.495n 0.0v 429.505n 0.0v 439.495n 0.0v 439.505n 0.0v 449.495n 0.0v 449.505n 0.0v 459.495n 0.0v 459.505n 0.0v 469.495n 0.0v 469.505n 0.0v 479.495n 0.0v 479.505n 0.0v 489.495n 0.0v 489.505n 0.0v 499.495n 0.0v 499.505n 0.0v 509.495n 0.0v 509.505n 1.95v 519.495n 1.95v 519.505n 1.95v 529.495n 1.95v 529.505n 1.95v 539.495n 1.95v 539.505n 1.95v 549.495n 1.95v 549.505n 1.95v 559.495n 1.95v 559.505n 1.95v 569.495n 1.95v 569.505n 1.95v 579.495n 1.95v 579.505n 1.95v 589.495n 1.95v 589.505n 0.0v 599.495n 0.0v 599.505n 0.0v 609.495n 0.0v 609.505n 0.0v 619.495n 0.0v 619.505n 0.0v 629.495n 0.0v 629.505n 0.0v 639.495n 0.0v 639.505n 0.0v 649.495n 0.0v 649.505n 1.95v 659.495n 1.95v 659.505n 1.95v 669.495n 1.95v 669.505n 1.95v 679.495n 1.95v 679.505n 1.95v 689.495n 1.95v 689.505n 1.95v 699.495n 1.95v 699.505n 0.0v 709.495n 0.0v 709.505n 0.0v 719.495n 0.0v 719.505n 0.0v 729.495n 0.0v 729.505n 0.0v 739.495n 0.0v 739.505n 0.0v 749.495n 0.0v 749.505n 0.0v 759.495n 0.0v 759.505n 0.0v 769.495n 0.0v 769.505n 1.95v 779.495n 1.95v 779.505n 0.0v 789.495n 0.0v 789.505n 1.95v 799.495n 1.95v 799.505n 1.95v 809.495n 1.95v 809.505n 1.95v 819.495n 1.95v 819.505n 1.95v 829.495n 1.95v 829.505n 1.95v 839.495n 1.95v 839.505n 1.95v 849.495n 1.95v 849.505n 0.0v 859.495n 0.0v 859.505n 0.0v 869.495n 0.0v 869.505n 0.0v 879.495n 0.0v 879.505n 0.0v 889.495n 0.0v 889.505n 0.0v 899.495n 0.0v 899.505n 0.0v 909.495n 0.0v 909.505n 0.0v 919.495n 0.0v 919.505n 0.0v 929.495n 0.0v 929.505n 0.0v 939.495n 0.0v 939.505n 0.0v 949.495n 0.0v 949.505n 1.95v 959.495n 1.95v 959.505n 1.95v 969.495n 1.95v 969.505n 1.95v 979.495n 1.95v 979.505n 1.95v 989.495n 1.95v 989.505n 0.0v 999.495n 0.0v 999.505n 0.0v 1009.495n 0.0v 1009.505n 1.95v 1019.495n 1.95v 1019.505n 1.95v 1029.495n 1.95v 1029.505n 0.0v 1039.495n 0.0v 1039.505n 0.0v 1049.495n 0.0v 1049.505n 0.0v 1059.495n 0.0v 1059.505n 0.0v 1069.495n 0.0v 1069.505n 0.0v 1079.495n 0.0v 1079.505n 0.0v 1089.495n 0.0v 1089.505n 0.0v 1099.495n 0.0v 1099.505n 0.0v 1109.495n 0.0v 1109.505n 0.0v 1119.495n 0.0v 1119.505n 0.0v 1129.495n 0.0v 1129.505n 0.0v 1139.495n 0.0v 1139.505n 0.0v 1149.495n 0.0v 1149.505n 1.95v 1159.495n 1.95v 1159.505n 1.95v 1169.495n 1.95v 1169.505n 1.95v 1179.495n 1.95v 1179.505n 1.95v 1189.495n 1.95v 1189.505n 1.95v 1199.495n 1.95v 1199.505n 1.95v 1209.495n 1.95v 1209.505n 0.0v 1219.495n 0.0v 1219.505n 0.0v 1229.495n 0.0v 1229.505n 0.0v 1239.495n 0.0v 1239.505n 0.0v 1249.495n 0.0v 1249.505n 0.0v 1259.495n 0.0v 1259.505n 0.0v 1269.495n 0.0v 1269.505n 0.0v 1279.495n 0.0v 1279.505n 0.0v 1289.495n 0.0v 1289.505n 0.0v 1299.495n 0.0v 1299.505n 0.0v 1309.495n 0.0v 1309.505n 0.0v 1319.495n 0.0v 1319.505n 1.95v 1329.495n 1.95v 1329.505n 1.95v 1339.495n 1.95v 1339.505n 1.95v 1349.495n 1.95v 1349.505n 1.95v 1359.495n 1.95v 1359.505n 1.95v 1369.495n 1.95v 1369.505n 1.95v 1379.495n 1.95v 1379.505n 0.0v 1389.495n 0.0v 1389.505n 0.0v 1399.495n 0.0v 1399.505n 0.0v 1409.495n 0.0v 1409.505n 0.0v 1419.495n 0.0v 1419.505n 0.0v 1429.495n 0.0v 1429.505n 0.0v 1439.495n 0.0v 1439.505n 0.0v 1449.495n 0.0v 1449.505n 0.0v 1459.495n 0.0v 1459.505n 0.0v 1469.495n 0.0v 1469.505n 0.0v 1479.495n 0.0v 1479.505n 0.0v 1489.495n 0.0v 1489.505n 0.0v 1499.495n 0.0v 1499.505n 0.0v 1509.495n 0.0v 1509.505n 0.0v 1519.495n 0.0v 1519.505n 0.0v 1529.495n 0.0v 1529.505n 0.0v 1539.495n 0.0v 1539.505n 0.0v 1549.495n 0.0v 1549.505n 0.0v 1559.495n 0.0v 1559.505n 1.95v 1569.495n 1.95v 1569.505n 1.95v 1579.495n 1.95v 1579.505n 1.95v 1589.495n 1.95v 1589.505n 1.95v 1599.495n 1.95v 1599.505n 0.0v 1609.495n 0.0v 1609.505n 0.0v 1619.495n 0.0v 1619.505n 0.0v 1629.495n 0.0v 1629.505n 0.0v 1639.495n 0.0v 1639.505n 0.0v 1649.495n 0.0v 1649.505n 0.0v 1659.495n 0.0v 1659.505n 0.0v 1669.495n 0.0v 1669.505n 0.0v 1679.495n 0.0v 1679.505n 1.95v 1689.495n 1.95v 1689.505n 1.95v 1699.495n 1.95v 1699.505n 1.95v 1709.495n 1.95v 1709.505n 1.95v 1719.495n 1.95v 1719.505n 0.0v 1729.495n 0.0v 1729.505n 0.0v 1739.495n 0.0v 1739.505n 1.95v 1749.495n 1.95v 1749.505n 1.95v 1759.495n 1.95v 1759.505n 0.0v 1769.495n 0.0v 1769.505n 0.0v 1779.495n 0.0v 1779.505n 0.0v 1789.495n 0.0v 1789.505n 0.0v 1799.495n 0.0v 1799.505n 0.0v 1809.495n 0.0v 1809.505n 0.0v 1819.495n 0.0v 1819.505n 0.0v 1829.495n 0.0v 1829.505n 0.0v 1839.495n 0.0v 1839.505n 0.0v 1849.495n 0.0v 1849.505n 0.0v 1859.495n 0.0v 1859.505n 0.0v 1869.495n 0.0v 1869.505n 0.0v 1879.495n 0.0v 1879.505n 0.0v 1889.495n 0.0v 1889.505n 0.0v 1899.495n 0.0v 1899.505n 0.0v 1909.495n 0.0v 1909.505n 0.0v 1919.495n 0.0v 1919.505n 0.0v 1929.495n 0.0v 1929.505n 0.0v 1939.495n 0.0v 1939.505n 0.0v 1949.495n 0.0v 1949.505n 1.95v 1959.495n 1.95v 1959.505n 1.95v 1969.495n 1.95v 1969.505n 1.95v 1979.495n 1.95v 1979.505n 1.95v 1989.495n 1.95v 1989.505n 0.0v 1999.495n 0.0v 1999.505n 0.0v 2009.495n 0.0v 2009.505n 0.0v 2019.495n 0.0v 2019.505n 0.0v 2029.495n 0.0v 2029.505n 0.0v 2039.495n 0.0v 2039.505n 0.0v 2049.495n 0.0v 2049.505n 0.0v )
* (time, data): [(0, 0), (10, 1), (20, 1), (30, 1), (40, 1), (50, 1), (60, 0), (70, 1), (80, 1), (90, 1), (100, 1), (110, 0), (120, 0), (130, 0), (140, 0), (150, 0), (160, 1), (170, 1), (180, 1), (190, 1), (200, 1), (210, 1), (220, 1), (230, 1), (240, 1), (250, 1), (260, 1), (270, 1), (280, 1), (290, 1), (300, 1), (310, 1), (320, 1), (330, 1), (340, 0), (350, 0), (360, 0), (370, 0), (380, 0), (390, 0), (400, 0), (410, 0), (420, 1), (430, 1), (440, 1), (450, 1), (460, 1), (470, 1), (480, 1), (490, 1), (500, 1), (510, 1), (520, 1), (530, 1), (540, 1), (550, 1), (560, 1), (570, 1), (580, 1), (590, 1), (600, 1), (610, 1), (620, 1), (630, 1), (640, 1), (650, 1), (660, 1), (670, 1), (680, 1), (690, 1), (700, 0), (710, 0), (720, 0), (730, 1), (740, 1), (750, 1), (760, 1), (770, 1), (780, 0), (790, 0), (800, 0), (810, 0), (820, 0), (830, 0), (840, 0), (850, 0), (860, 0), (870, 0), (880, 0), (890, 0), (900, 0), (910, 0), (920, 0), (930, 0), (940, 0), (950, 1), (960, 1), (970, 1), (980, 0), (990, 1), (1000, 1), (1010, 1), (1020, 1), (1030, 1), (1040, 1), (1050, 0), (1060, 0), (1070, 0), (1080, 0), (1090, 0), (1100, 0), (1110, 1), (1120, 1), (1130, 1), (1140, 1), (1150, 1), (1160, 1), (1170, 1), (1180, 1), (1190, 1), (1200, 1), (1210, 1), (1220, 1), (1230, 1), (1240, 1), (1250, 1), (1260, 1), (1270, 1), (1280, 1), (1290, 1), (1300, 1), (1310, 1), (1320, 1), (1330, 0), (1340, 0), (1350, 0), (1360, 0), (1370, 0), (1380, 1), (1390, 1), (1400, 1), (1410, 1), (1420, 1), (1430, 1), (1440, 1), (1450, 1), (1460, 1), (1470, 1), (1480, 1), (1490, 1), (1500, 1), (1510, 1), (1520, 1), (1530, 1), (1540, 1), (1550, 0), (1560, 1), (1570, 1), (1580, 1), (1590, 1), (1600, 1), (1610, 1), (1620, 1), (1630, 1), (1640, 1), (1650, 1), (1660, 0), (1670, 0), (1680, 1), (1690, 1), (1700, 1), (1710, 1), (1720, 0), (1730, 0), (1740, 1), (1750, 1), (1760, 1), (1770, 1), (1780, 1), (1790, 1), (1800, 1), (1810, 1), (1820, 1), (1830, 1), (1840, 1), (1850, 0), (1860, 1), (1870, 1), (1880, 1), (1890, 1), (1900, 1), (1910, 1), (1920, 1), (1930, 1), (1940, 1), (1950, 0), (1960, 0), (1970, 0), (1980, 0), (1990, 1), (2000, 1), (2010, 1), (2020, 1), (2030, 1), (2040, 1), (2050, 1)]
Vdin0_24  din0_24  0 PWL (0n 0.0v 9.495n 0.0v 9.505n 1.95v 19.495n 1.95v 19.505n 1.95v 29.495n 1.95v 29.505n 1.95v 39.495n 1.95v 39.505n 1.95v 49.495n 1.95v 49.505n 1.95v 59.495n 1.95v 59.505n 0.0v 69.495n 0.0v 69.505n 1.95v 79.495n 1.95v 79.505n 1.95v 89.495n 1.95v 89.505n 1.95v 99.495n 1.95v 99.505n 1.95v 109.495n 1.95v 109.505n 0.0v 119.495n 0.0v 119.505n 0.0v 129.495n 0.0v 129.505n 0.0v 139.495n 0.0v 139.505n 0.0v 149.495n 0.0v 149.505n 0.0v 159.495n 0.0v 159.505n 1.95v 169.495n 1.95v 169.505n 1.95v 179.495n 1.95v 179.505n 1.95v 189.495n 1.95v 189.505n 1.95v 199.495n 1.95v 199.505n 1.95v 209.495n 1.95v 209.505n 1.95v 219.495n 1.95v 219.505n 1.95v 229.495n 1.95v 229.505n 1.95v 239.495n 1.95v 239.505n 1.95v 249.495n 1.95v 249.505n 1.95v 259.495n 1.95v 259.505n 1.95v 269.495n 1.95v 269.505n 1.95v 279.495n 1.95v 279.505n 1.95v 289.495n 1.95v 289.505n 1.95v 299.495n 1.95v 299.505n 1.95v 309.495n 1.95v 309.505n 1.95v 319.495n 1.95v 319.505n 1.95v 329.495n 1.95v 329.505n 1.95v 339.495n 1.95v 339.505n 0.0v 349.495n 0.0v 349.505n 0.0v 359.495n 0.0v 359.505n 0.0v 369.495n 0.0v 369.505n 0.0v 379.495n 0.0v 379.505n 0.0v 389.495n 0.0v 389.505n 0.0v 399.495n 0.0v 399.505n 0.0v 409.495n 0.0v 409.505n 0.0v 419.495n 0.0v 419.505n 1.95v 429.495n 1.95v 429.505n 1.95v 439.495n 1.95v 439.505n 1.95v 449.495n 1.95v 449.505n 1.95v 459.495n 1.95v 459.505n 1.95v 469.495n 1.95v 469.505n 1.95v 479.495n 1.95v 479.505n 1.95v 489.495n 1.95v 489.505n 1.95v 499.495n 1.95v 499.505n 1.95v 509.495n 1.95v 509.505n 1.95v 519.495n 1.95v 519.505n 1.95v 529.495n 1.95v 529.505n 1.95v 539.495n 1.95v 539.505n 1.95v 549.495n 1.95v 549.505n 1.95v 559.495n 1.95v 559.505n 1.95v 569.495n 1.95v 569.505n 1.95v 579.495n 1.95v 579.505n 1.95v 589.495n 1.95v 589.505n 1.95v 599.495n 1.95v 599.505n 1.95v 609.495n 1.95v 609.505n 1.95v 619.495n 1.95v 619.505n 1.95v 629.495n 1.95v 629.505n 1.95v 639.495n 1.95v 639.505n 1.95v 649.495n 1.95v 649.505n 1.95v 659.495n 1.95v 659.505n 1.95v 669.495n 1.95v 669.505n 1.95v 679.495n 1.95v 679.505n 1.95v 689.495n 1.95v 689.505n 1.95v 699.495n 1.95v 699.505n 0.0v 709.495n 0.0v 709.505n 0.0v 719.495n 0.0v 719.505n 0.0v 729.495n 0.0v 729.505n 1.95v 739.495n 1.95v 739.505n 1.95v 749.495n 1.95v 749.505n 1.95v 759.495n 1.95v 759.505n 1.95v 769.495n 1.95v 769.505n 1.95v 779.495n 1.95v 779.505n 0.0v 789.495n 0.0v 789.505n 0.0v 799.495n 0.0v 799.505n 0.0v 809.495n 0.0v 809.505n 0.0v 819.495n 0.0v 819.505n 0.0v 829.495n 0.0v 829.505n 0.0v 839.495n 0.0v 839.505n 0.0v 849.495n 0.0v 849.505n 0.0v 859.495n 0.0v 859.505n 0.0v 869.495n 0.0v 869.505n 0.0v 879.495n 0.0v 879.505n 0.0v 889.495n 0.0v 889.505n 0.0v 899.495n 0.0v 899.505n 0.0v 909.495n 0.0v 909.505n 0.0v 919.495n 0.0v 919.505n 0.0v 929.495n 0.0v 929.505n 0.0v 939.495n 0.0v 939.505n 0.0v 949.495n 0.0v 949.505n 1.95v 959.495n 1.95v 959.505n 1.95v 969.495n 1.95v 969.505n 1.95v 979.495n 1.95v 979.505n 0.0v 989.495n 0.0v 989.505n 1.95v 999.495n 1.95v 999.505n 1.95v 1009.495n 1.95v 1009.505n 1.95v 1019.495n 1.95v 1019.505n 1.95v 1029.495n 1.95v 1029.505n 1.95v 1039.495n 1.95v 1039.505n 1.95v 1049.495n 1.95v 1049.505n 0.0v 1059.495n 0.0v 1059.505n 0.0v 1069.495n 0.0v 1069.505n 0.0v 1079.495n 0.0v 1079.505n 0.0v 1089.495n 0.0v 1089.505n 0.0v 1099.495n 0.0v 1099.505n 0.0v 1109.495n 0.0v 1109.505n 1.95v 1119.495n 1.95v 1119.505n 1.95v 1129.495n 1.95v 1129.505n 1.95v 1139.495n 1.95v 1139.505n 1.95v 1149.495n 1.95v 1149.505n 1.95v 1159.495n 1.95v 1159.505n 1.95v 1169.495n 1.95v 1169.505n 1.95v 1179.495n 1.95v 1179.505n 1.95v 1189.495n 1.95v 1189.505n 1.95v 1199.495n 1.95v 1199.505n 1.95v 1209.495n 1.95v 1209.505n 1.95v 1219.495n 1.95v 1219.505n 1.95v 1229.495n 1.95v 1229.505n 1.95v 1239.495n 1.95v 1239.505n 1.95v 1249.495n 1.95v 1249.505n 1.95v 1259.495n 1.95v 1259.505n 1.95v 1269.495n 1.95v 1269.505n 1.95v 1279.495n 1.95v 1279.505n 1.95v 1289.495n 1.95v 1289.505n 1.95v 1299.495n 1.95v 1299.505n 1.95v 1309.495n 1.95v 1309.505n 1.95v 1319.495n 1.95v 1319.505n 1.95v 1329.495n 1.95v 1329.505n 0.0v 1339.495n 0.0v 1339.505n 0.0v 1349.495n 0.0v 1349.505n 0.0v 1359.495n 0.0v 1359.505n 0.0v 1369.495n 0.0v 1369.505n 0.0v 1379.495n 0.0v 1379.505n 1.95v 1389.495n 1.95v 1389.505n 1.95v 1399.495n 1.95v 1399.505n 1.95v 1409.495n 1.95v 1409.505n 1.95v 1419.495n 1.95v 1419.505n 1.95v 1429.495n 1.95v 1429.505n 1.95v 1439.495n 1.95v 1439.505n 1.95v 1449.495n 1.95v 1449.505n 1.95v 1459.495n 1.95v 1459.505n 1.95v 1469.495n 1.95v 1469.505n 1.95v 1479.495n 1.95v 1479.505n 1.95v 1489.495n 1.95v 1489.505n 1.95v 1499.495n 1.95v 1499.505n 1.95v 1509.495n 1.95v 1509.505n 1.95v 1519.495n 1.95v 1519.505n 1.95v 1529.495n 1.95v 1529.505n 1.95v 1539.495n 1.95v 1539.505n 1.95v 1549.495n 1.95v 1549.505n 0.0v 1559.495n 0.0v 1559.505n 1.95v 1569.495n 1.95v 1569.505n 1.95v 1579.495n 1.95v 1579.505n 1.95v 1589.495n 1.95v 1589.505n 1.95v 1599.495n 1.95v 1599.505n 1.95v 1609.495n 1.95v 1609.505n 1.95v 1619.495n 1.95v 1619.505n 1.95v 1629.495n 1.95v 1629.505n 1.95v 1639.495n 1.95v 1639.505n 1.95v 1649.495n 1.95v 1649.505n 1.95v 1659.495n 1.95v 1659.505n 0.0v 1669.495n 0.0v 1669.505n 0.0v 1679.495n 0.0v 1679.505n 1.95v 1689.495n 1.95v 1689.505n 1.95v 1699.495n 1.95v 1699.505n 1.95v 1709.495n 1.95v 1709.505n 1.95v 1719.495n 1.95v 1719.505n 0.0v 1729.495n 0.0v 1729.505n 0.0v 1739.495n 0.0v 1739.505n 1.95v 1749.495n 1.95v 1749.505n 1.95v 1759.495n 1.95v 1759.505n 1.95v 1769.495n 1.95v 1769.505n 1.95v 1779.495n 1.95v 1779.505n 1.95v 1789.495n 1.95v 1789.505n 1.95v 1799.495n 1.95v 1799.505n 1.95v 1809.495n 1.95v 1809.505n 1.95v 1819.495n 1.95v 1819.505n 1.95v 1829.495n 1.95v 1829.505n 1.95v 1839.495n 1.95v 1839.505n 1.95v 1849.495n 1.95v 1849.505n 0.0v 1859.495n 0.0v 1859.505n 1.95v 1869.495n 1.95v 1869.505n 1.95v 1879.495n 1.95v 1879.505n 1.95v 1889.495n 1.95v 1889.505n 1.95v 1899.495n 1.95v 1899.505n 1.95v 1909.495n 1.95v 1909.505n 1.95v 1919.495n 1.95v 1919.505n 1.95v 1929.495n 1.95v 1929.505n 1.95v 1939.495n 1.95v 1939.505n 1.95v 1949.495n 1.95v 1949.505n 0.0v 1959.495n 0.0v 1959.505n 0.0v 1969.495n 0.0v 1969.505n 0.0v 1979.495n 0.0v 1979.505n 0.0v 1989.495n 0.0v 1989.505n 1.95v 1999.495n 1.95v 1999.505n 1.95v 2009.495n 1.95v 2009.505n 1.95v 2019.495n 1.95v 2019.505n 1.95v 2029.495n 1.95v 2029.505n 1.95v 2039.495n 1.95v 2039.505n 1.95v 2049.495n 1.95v 2049.505n 1.95v )
* (time, data): [(0, 0), (10, 1), (20, 0), (30, 1), (40, 1), (50, 1), (60, 0), (70, 1), (80, 0), (90, 0), (100, 0), (110, 0), (120, 0), (130, 0), (140, 0), (150, 0), (160, 0), (170, 0), (180, 0), (190, 0), (200, 0), (210, 0), (220, 0), (230, 0), (240, 1), (250, 1), (260, 1), (270, 1), (280, 1), (290, 1), (300, 1), (310, 1), (320, 1), (330, 1), (340, 0), (350, 0), (360, 0), (370, 1), (380, 1), (390, 1), (400, 1), (410, 1), (420, 1), (430, 1), (440, 1), (450, 1), (460, 1), (470, 1), (480, 1), (490, 1), (500, 1), (510, 0), (520, 0), (530, 0), (540, 1), (550, 0), (560, 0), (570, 0), (580, 0), (590, 1), (600, 1), (610, 1), (620, 1), (630, 1), (640, 1), (650, 0), (660, 0), (670, 1), (680, 1), (690, 1), (700, 1), (710, 1), (720, 1), (730, 0), (740, 0), (750, 0), (760, 0), (770, 1), (780, 0), (790, 1), (800, 1), (810, 1), (820, 1), (830, 1), (840, 1), (850, 1), (860, 1), (870, 1), (880, 1), (890, 1), (900, 1), (910, 1), (920, 1), (930, 1), (940, 1), (950, 1), (960, 1), (970, 0), (980, 1), (990, 1), (1000, 1), (1010, 0), (1020, 0), (1030, 1), (1040, 1), (1050, 1), (1060, 1), (1070, 1), (1080, 1), (1090, 1), (1100, 1), (1110, 1), (1120, 1), (1130, 1), (1140, 1), (1150, 0), (1160, 0), (1170, 0), (1180, 0), (1190, 0), (1200, 0), (1210, 1), (1220, 1), (1230, 1), (1240, 0), (1250, 0), (1260, 0), (1270, 0), (1280, 0), (1290, 0), (1300, 0), (1310, 0), (1320, 0), (1330, 0), (1340, 1), (1350, 1), (1360, 1), (1370, 1), (1380, 1), (1390, 1), (1400, 1), (1410, 1), (1420, 0), (1430, 0), (1440, 0), (1450, 0), (1460, 0), (1470, 0), (1480, 0), (1490, 0), (1500, 0), (1510, 0), (1520, 0), (1530, 0), (1540, 0), (1550, 0), (1560, 0), (1570, 0), (1580, 0), (1590, 0), (1600, 1), (1610, 1), (1620, 1), (1630, 1), (1640, 1), (1650, 1), (1660, 0), (1670, 0), (1680, 0), (1690, 0), (1700, 0), (1710, 0), (1720, 0), (1730, 0), (1740, 0), (1750, 0), (1760, 0), (1770, 0), (1780, 0), (1790, 0), (1800, 0), (1810, 0), (1820, 0), (1830, 0), (1840, 0), (1850, 0), (1860, 1), (1870, 1), (1880, 1), (1890, 1), (1900, 1), (1910, 1), (1920, 1), (1930, 1), (1940, 1), (1950, 0), (1960, 0), (1970, 0), (1980, 0), (1990, 1), (2000, 1), (2010, 1), (2020, 1), (2030, 1), (2040, 1), (2050, 1)]
Vdin0_25  din0_25  0 PWL (0n 0.0v 9.495n 0.0v 9.505n 1.95v 19.495n 1.95v 19.505n 0.0v 29.495n 0.0v 29.505n 1.95v 39.495n 1.95v 39.505n 1.95v 49.495n 1.95v 49.505n 1.95v 59.495n 1.95v 59.505n 0.0v 69.495n 0.0v 69.505n 1.95v 79.495n 1.95v 79.505n 0.0v 89.495n 0.0v 89.505n 0.0v 99.495n 0.0v 99.505n 0.0v 109.495n 0.0v 109.505n 0.0v 119.495n 0.0v 119.505n 0.0v 129.495n 0.0v 129.505n 0.0v 139.495n 0.0v 139.505n 0.0v 149.495n 0.0v 149.505n 0.0v 159.495n 0.0v 159.505n 0.0v 169.495n 0.0v 169.505n 0.0v 179.495n 0.0v 179.505n 0.0v 189.495n 0.0v 189.505n 0.0v 199.495n 0.0v 199.505n 0.0v 209.495n 0.0v 209.505n 0.0v 219.495n 0.0v 219.505n 0.0v 229.495n 0.0v 229.505n 0.0v 239.495n 0.0v 239.505n 1.95v 249.495n 1.95v 249.505n 1.95v 259.495n 1.95v 259.505n 1.95v 269.495n 1.95v 269.505n 1.95v 279.495n 1.95v 279.505n 1.95v 289.495n 1.95v 289.505n 1.95v 299.495n 1.95v 299.505n 1.95v 309.495n 1.95v 309.505n 1.95v 319.495n 1.95v 319.505n 1.95v 329.495n 1.95v 329.505n 1.95v 339.495n 1.95v 339.505n 0.0v 349.495n 0.0v 349.505n 0.0v 359.495n 0.0v 359.505n 0.0v 369.495n 0.0v 369.505n 1.95v 379.495n 1.95v 379.505n 1.95v 389.495n 1.95v 389.505n 1.95v 399.495n 1.95v 399.505n 1.95v 409.495n 1.95v 409.505n 1.95v 419.495n 1.95v 419.505n 1.95v 429.495n 1.95v 429.505n 1.95v 439.495n 1.95v 439.505n 1.95v 449.495n 1.95v 449.505n 1.95v 459.495n 1.95v 459.505n 1.95v 469.495n 1.95v 469.505n 1.95v 479.495n 1.95v 479.505n 1.95v 489.495n 1.95v 489.505n 1.95v 499.495n 1.95v 499.505n 1.95v 509.495n 1.95v 509.505n 0.0v 519.495n 0.0v 519.505n 0.0v 529.495n 0.0v 529.505n 0.0v 539.495n 0.0v 539.505n 1.95v 549.495n 1.95v 549.505n 0.0v 559.495n 0.0v 559.505n 0.0v 569.495n 0.0v 569.505n 0.0v 579.495n 0.0v 579.505n 0.0v 589.495n 0.0v 589.505n 1.95v 599.495n 1.95v 599.505n 1.95v 609.495n 1.95v 609.505n 1.95v 619.495n 1.95v 619.505n 1.95v 629.495n 1.95v 629.505n 1.95v 639.495n 1.95v 639.505n 1.95v 649.495n 1.95v 649.505n 0.0v 659.495n 0.0v 659.505n 0.0v 669.495n 0.0v 669.505n 1.95v 679.495n 1.95v 679.505n 1.95v 689.495n 1.95v 689.505n 1.95v 699.495n 1.95v 699.505n 1.95v 709.495n 1.95v 709.505n 1.95v 719.495n 1.95v 719.505n 1.95v 729.495n 1.95v 729.505n 0.0v 739.495n 0.0v 739.505n 0.0v 749.495n 0.0v 749.505n 0.0v 759.495n 0.0v 759.505n 0.0v 769.495n 0.0v 769.505n 1.95v 779.495n 1.95v 779.505n 0.0v 789.495n 0.0v 789.505n 1.95v 799.495n 1.95v 799.505n 1.95v 809.495n 1.95v 809.505n 1.95v 819.495n 1.95v 819.505n 1.95v 829.495n 1.95v 829.505n 1.95v 839.495n 1.95v 839.505n 1.95v 849.495n 1.95v 849.505n 1.95v 859.495n 1.95v 859.505n 1.95v 869.495n 1.95v 869.505n 1.95v 879.495n 1.95v 879.505n 1.95v 889.495n 1.95v 889.505n 1.95v 899.495n 1.95v 899.505n 1.95v 909.495n 1.95v 909.505n 1.95v 919.495n 1.95v 919.505n 1.95v 929.495n 1.95v 929.505n 1.95v 939.495n 1.95v 939.505n 1.95v 949.495n 1.95v 949.505n 1.95v 959.495n 1.95v 959.505n 1.95v 969.495n 1.95v 969.505n 0.0v 979.495n 0.0v 979.505n 1.95v 989.495n 1.95v 989.505n 1.95v 999.495n 1.95v 999.505n 1.95v 1009.495n 1.95v 1009.505n 0.0v 1019.495n 0.0v 1019.505n 0.0v 1029.495n 0.0v 1029.505n 1.95v 1039.495n 1.95v 1039.505n 1.95v 1049.495n 1.95v 1049.505n 1.95v 1059.495n 1.95v 1059.505n 1.95v 1069.495n 1.95v 1069.505n 1.95v 1079.495n 1.95v 1079.505n 1.95v 1089.495n 1.95v 1089.505n 1.95v 1099.495n 1.95v 1099.505n 1.95v 1109.495n 1.95v 1109.505n 1.95v 1119.495n 1.95v 1119.505n 1.95v 1129.495n 1.95v 1129.505n 1.95v 1139.495n 1.95v 1139.505n 1.95v 1149.495n 1.95v 1149.505n 0.0v 1159.495n 0.0v 1159.505n 0.0v 1169.495n 0.0v 1169.505n 0.0v 1179.495n 0.0v 1179.505n 0.0v 1189.495n 0.0v 1189.505n 0.0v 1199.495n 0.0v 1199.505n 0.0v 1209.495n 0.0v 1209.505n 1.95v 1219.495n 1.95v 1219.505n 1.95v 1229.495n 1.95v 1229.505n 1.95v 1239.495n 1.95v 1239.505n 0.0v 1249.495n 0.0v 1249.505n 0.0v 1259.495n 0.0v 1259.505n 0.0v 1269.495n 0.0v 1269.505n 0.0v 1279.495n 0.0v 1279.505n 0.0v 1289.495n 0.0v 1289.505n 0.0v 1299.495n 0.0v 1299.505n 0.0v 1309.495n 0.0v 1309.505n 0.0v 1319.495n 0.0v 1319.505n 0.0v 1329.495n 0.0v 1329.505n 0.0v 1339.495n 0.0v 1339.505n 1.95v 1349.495n 1.95v 1349.505n 1.95v 1359.495n 1.95v 1359.505n 1.95v 1369.495n 1.95v 1369.505n 1.95v 1379.495n 1.95v 1379.505n 1.95v 1389.495n 1.95v 1389.505n 1.95v 1399.495n 1.95v 1399.505n 1.95v 1409.495n 1.95v 1409.505n 1.95v 1419.495n 1.95v 1419.505n 0.0v 1429.495n 0.0v 1429.505n 0.0v 1439.495n 0.0v 1439.505n 0.0v 1449.495n 0.0v 1449.505n 0.0v 1459.495n 0.0v 1459.505n 0.0v 1469.495n 0.0v 1469.505n 0.0v 1479.495n 0.0v 1479.505n 0.0v 1489.495n 0.0v 1489.505n 0.0v 1499.495n 0.0v 1499.505n 0.0v 1509.495n 0.0v 1509.505n 0.0v 1519.495n 0.0v 1519.505n 0.0v 1529.495n 0.0v 1529.505n 0.0v 1539.495n 0.0v 1539.505n 0.0v 1549.495n 0.0v 1549.505n 0.0v 1559.495n 0.0v 1559.505n 0.0v 1569.495n 0.0v 1569.505n 0.0v 1579.495n 0.0v 1579.505n 0.0v 1589.495n 0.0v 1589.505n 0.0v 1599.495n 0.0v 1599.505n 1.95v 1609.495n 1.95v 1609.505n 1.95v 1619.495n 1.95v 1619.505n 1.95v 1629.495n 1.95v 1629.505n 1.95v 1639.495n 1.95v 1639.505n 1.95v 1649.495n 1.95v 1649.505n 1.95v 1659.495n 1.95v 1659.505n 0.0v 1669.495n 0.0v 1669.505n 0.0v 1679.495n 0.0v 1679.505n 0.0v 1689.495n 0.0v 1689.505n 0.0v 1699.495n 0.0v 1699.505n 0.0v 1709.495n 0.0v 1709.505n 0.0v 1719.495n 0.0v 1719.505n 0.0v 1729.495n 0.0v 1729.505n 0.0v 1739.495n 0.0v 1739.505n 0.0v 1749.495n 0.0v 1749.505n 0.0v 1759.495n 0.0v 1759.505n 0.0v 1769.495n 0.0v 1769.505n 0.0v 1779.495n 0.0v 1779.505n 0.0v 1789.495n 0.0v 1789.505n 0.0v 1799.495n 0.0v 1799.505n 0.0v 1809.495n 0.0v 1809.505n 0.0v 1819.495n 0.0v 1819.505n 0.0v 1829.495n 0.0v 1829.505n 0.0v 1839.495n 0.0v 1839.505n 0.0v 1849.495n 0.0v 1849.505n 0.0v 1859.495n 0.0v 1859.505n 1.95v 1869.495n 1.95v 1869.505n 1.95v 1879.495n 1.95v 1879.505n 1.95v 1889.495n 1.95v 1889.505n 1.95v 1899.495n 1.95v 1899.505n 1.95v 1909.495n 1.95v 1909.505n 1.95v 1919.495n 1.95v 1919.505n 1.95v 1929.495n 1.95v 1929.505n 1.95v 1939.495n 1.95v 1939.505n 1.95v 1949.495n 1.95v 1949.505n 0.0v 1959.495n 0.0v 1959.505n 0.0v 1969.495n 0.0v 1969.505n 0.0v 1979.495n 0.0v 1979.505n 0.0v 1989.495n 0.0v 1989.505n 1.95v 1999.495n 1.95v 1999.505n 1.95v 2009.495n 1.95v 2009.505n 1.95v 2019.495n 1.95v 2019.505n 1.95v 2029.495n 1.95v 2029.505n 1.95v 2039.495n 1.95v 2039.505n 1.95v 2049.495n 1.95v 2049.505n 1.95v )
* (time, data): [(0, 0), (10, 0), (20, 1), (30, 1), (40, 1), (50, 1), (60, 1), (70, 1), (80, 1), (90, 1), (100, 1), (110, 0), (120, 0), (130, 0), (140, 0), (150, 0), (160, 0), (170, 0), (180, 0), (190, 0), (200, 0), (210, 0), (220, 0), (230, 0), (240, 0), (250, 0), (260, 0), (270, 0), (280, 0), (290, 0), (300, 1), (310, 1), (320, 1), (330, 1), (340, 1), (350, 1), (360, 1), (370, 1), (380, 1), (390, 1), (400, 1), (410, 1), (420, 0), (430, 0), (440, 0), (450, 0), (460, 0), (470, 0), (480, 0), (490, 0), (500, 1), (510, 1), (520, 1), (530, 1), (540, 1), (550, 0), (560, 0), (570, 0), (580, 0), (590, 1), (600, 1), (610, 1), (620, 1), (630, 1), (640, 1), (650, 1), (660, 1), (670, 0), (680, 0), (690, 0), (700, 1), (710, 1), (720, 1), (730, 0), (740, 0), (750, 1), (760, 1), (770, 0), (780, 1), (790, 0), (800, 0), (810, 0), (820, 0), (830, 1), (840, 1), (850, 1), (860, 1), (870, 1), (880, 1), (890, 1), (900, 1), (910, 1), (920, 1), (930, 1), (940, 0), (950, 0), (960, 0), (970, 0), (980, 0), (990, 0), (1000, 0), (1010, 0), (1020, 0), (1030, 1), (1040, 1), (1050, 0), (1060, 0), (1070, 0), (1080, 0), (1090, 0), (1100, 0), (1110, 0), (1120, 0), (1130, 0), (1140, 0), (1150, 1), (1160, 1), (1170, 1), (1180, 1), (1190, 1), (1200, 1), (1210, 0), (1220, 0), (1230, 0), (1240, 0), (1250, 0), (1260, 0), (1270, 0), (1280, 0), (1290, 0), (1300, 0), (1310, 0), (1320, 1), (1330, 0), (1340, 0), (1350, 0), (1360, 0), (1370, 0), (1380, 1), (1390, 1), (1400, 1), (1410, 1), (1420, 0), (1430, 0), (1440, 1), (1450, 1), (1460, 1), (1470, 1), (1480, 1), (1490, 1), (1500, 1), (1510, 1), (1520, 1), (1530, 1), (1540, 1), (1550, 1), (1560, 1), (1570, 1), (1580, 1), (1590, 1), (1600, 0), (1610, 1), (1620, 1), (1630, 1), (1640, 1), (1650, 1), (1660, 0), (1670, 0), (1680, 0), (1690, 0), (1700, 0), (1710, 0), (1720, 1), (1730, 1), (1740, 1), (1750, 1), (1760, 1), (1770, 1), (1780, 1), (1790, 1), (1800, 1), (1810, 1), (1820, 1), (1830, 1), (1840, 1), (1850, 0), (1860, 1), (1870, 1), (1880, 1), (1890, 1), (1900, 1), (1910, 1), (1920, 1), (1930, 1), (1940, 1), (1950, 0), (1960, 1), (1970, 1), (1980, 1), (1990, 0), (2000, 0), (2010, 0), (2020, 0), (2030, 0), (2040, 0), (2050, 0)]
Vdin0_26  din0_26  0 PWL (0n 0.0v 9.495n 0.0v 9.505n 0.0v 19.495n 0.0v 19.505n 1.95v 29.495n 1.95v 29.505n 1.95v 39.495n 1.95v 39.505n 1.95v 49.495n 1.95v 49.505n 1.95v 59.495n 1.95v 59.505n 1.95v 69.495n 1.95v 69.505n 1.95v 79.495n 1.95v 79.505n 1.95v 89.495n 1.95v 89.505n 1.95v 99.495n 1.95v 99.505n 1.95v 109.495n 1.95v 109.505n 0.0v 119.495n 0.0v 119.505n 0.0v 129.495n 0.0v 129.505n 0.0v 139.495n 0.0v 139.505n 0.0v 149.495n 0.0v 149.505n 0.0v 159.495n 0.0v 159.505n 0.0v 169.495n 0.0v 169.505n 0.0v 179.495n 0.0v 179.505n 0.0v 189.495n 0.0v 189.505n 0.0v 199.495n 0.0v 199.505n 0.0v 209.495n 0.0v 209.505n 0.0v 219.495n 0.0v 219.505n 0.0v 229.495n 0.0v 229.505n 0.0v 239.495n 0.0v 239.505n 0.0v 249.495n 0.0v 249.505n 0.0v 259.495n 0.0v 259.505n 0.0v 269.495n 0.0v 269.505n 0.0v 279.495n 0.0v 279.505n 0.0v 289.495n 0.0v 289.505n 0.0v 299.495n 0.0v 299.505n 1.95v 309.495n 1.95v 309.505n 1.95v 319.495n 1.95v 319.505n 1.95v 329.495n 1.95v 329.505n 1.95v 339.495n 1.95v 339.505n 1.95v 349.495n 1.95v 349.505n 1.95v 359.495n 1.95v 359.505n 1.95v 369.495n 1.95v 369.505n 1.95v 379.495n 1.95v 379.505n 1.95v 389.495n 1.95v 389.505n 1.95v 399.495n 1.95v 399.505n 1.95v 409.495n 1.95v 409.505n 1.95v 419.495n 1.95v 419.505n 0.0v 429.495n 0.0v 429.505n 0.0v 439.495n 0.0v 439.505n 0.0v 449.495n 0.0v 449.505n 0.0v 459.495n 0.0v 459.505n 0.0v 469.495n 0.0v 469.505n 0.0v 479.495n 0.0v 479.505n 0.0v 489.495n 0.0v 489.505n 0.0v 499.495n 0.0v 499.505n 1.95v 509.495n 1.95v 509.505n 1.95v 519.495n 1.95v 519.505n 1.95v 529.495n 1.95v 529.505n 1.95v 539.495n 1.95v 539.505n 1.95v 549.495n 1.95v 549.505n 0.0v 559.495n 0.0v 559.505n 0.0v 569.495n 0.0v 569.505n 0.0v 579.495n 0.0v 579.505n 0.0v 589.495n 0.0v 589.505n 1.95v 599.495n 1.95v 599.505n 1.95v 609.495n 1.95v 609.505n 1.95v 619.495n 1.95v 619.505n 1.95v 629.495n 1.95v 629.505n 1.95v 639.495n 1.95v 639.505n 1.95v 649.495n 1.95v 649.505n 1.95v 659.495n 1.95v 659.505n 1.95v 669.495n 1.95v 669.505n 0.0v 679.495n 0.0v 679.505n 0.0v 689.495n 0.0v 689.505n 0.0v 699.495n 0.0v 699.505n 1.95v 709.495n 1.95v 709.505n 1.95v 719.495n 1.95v 719.505n 1.95v 729.495n 1.95v 729.505n 0.0v 739.495n 0.0v 739.505n 0.0v 749.495n 0.0v 749.505n 1.95v 759.495n 1.95v 759.505n 1.95v 769.495n 1.95v 769.505n 0.0v 779.495n 0.0v 779.505n 1.95v 789.495n 1.95v 789.505n 0.0v 799.495n 0.0v 799.505n 0.0v 809.495n 0.0v 809.505n 0.0v 819.495n 0.0v 819.505n 0.0v 829.495n 0.0v 829.505n 1.95v 839.495n 1.95v 839.505n 1.95v 849.495n 1.95v 849.505n 1.95v 859.495n 1.95v 859.505n 1.95v 869.495n 1.95v 869.505n 1.95v 879.495n 1.95v 879.505n 1.95v 889.495n 1.95v 889.505n 1.95v 899.495n 1.95v 899.505n 1.95v 909.495n 1.95v 909.505n 1.95v 919.495n 1.95v 919.505n 1.95v 929.495n 1.95v 929.505n 1.95v 939.495n 1.95v 939.505n 0.0v 949.495n 0.0v 949.505n 0.0v 959.495n 0.0v 959.505n 0.0v 969.495n 0.0v 969.505n 0.0v 979.495n 0.0v 979.505n 0.0v 989.495n 0.0v 989.505n 0.0v 999.495n 0.0v 999.505n 0.0v 1009.495n 0.0v 1009.505n 0.0v 1019.495n 0.0v 1019.505n 0.0v 1029.495n 0.0v 1029.505n 1.95v 1039.495n 1.95v 1039.505n 1.95v 1049.495n 1.95v 1049.505n 0.0v 1059.495n 0.0v 1059.505n 0.0v 1069.495n 0.0v 1069.505n 0.0v 1079.495n 0.0v 1079.505n 0.0v 1089.495n 0.0v 1089.505n 0.0v 1099.495n 0.0v 1099.505n 0.0v 1109.495n 0.0v 1109.505n 0.0v 1119.495n 0.0v 1119.505n 0.0v 1129.495n 0.0v 1129.505n 0.0v 1139.495n 0.0v 1139.505n 0.0v 1149.495n 0.0v 1149.505n 1.95v 1159.495n 1.95v 1159.505n 1.95v 1169.495n 1.95v 1169.505n 1.95v 1179.495n 1.95v 1179.505n 1.95v 1189.495n 1.95v 1189.505n 1.95v 1199.495n 1.95v 1199.505n 1.95v 1209.495n 1.95v 1209.505n 0.0v 1219.495n 0.0v 1219.505n 0.0v 1229.495n 0.0v 1229.505n 0.0v 1239.495n 0.0v 1239.505n 0.0v 1249.495n 0.0v 1249.505n 0.0v 1259.495n 0.0v 1259.505n 0.0v 1269.495n 0.0v 1269.505n 0.0v 1279.495n 0.0v 1279.505n 0.0v 1289.495n 0.0v 1289.505n 0.0v 1299.495n 0.0v 1299.505n 0.0v 1309.495n 0.0v 1309.505n 0.0v 1319.495n 0.0v 1319.505n 1.95v 1329.495n 1.95v 1329.505n 0.0v 1339.495n 0.0v 1339.505n 0.0v 1349.495n 0.0v 1349.505n 0.0v 1359.495n 0.0v 1359.505n 0.0v 1369.495n 0.0v 1369.505n 0.0v 1379.495n 0.0v 1379.505n 1.95v 1389.495n 1.95v 1389.505n 1.95v 1399.495n 1.95v 1399.505n 1.95v 1409.495n 1.95v 1409.505n 1.95v 1419.495n 1.95v 1419.505n 0.0v 1429.495n 0.0v 1429.505n 0.0v 1439.495n 0.0v 1439.505n 1.95v 1449.495n 1.95v 1449.505n 1.95v 1459.495n 1.95v 1459.505n 1.95v 1469.495n 1.95v 1469.505n 1.95v 1479.495n 1.95v 1479.505n 1.95v 1489.495n 1.95v 1489.505n 1.95v 1499.495n 1.95v 1499.505n 1.95v 1509.495n 1.95v 1509.505n 1.95v 1519.495n 1.95v 1519.505n 1.95v 1529.495n 1.95v 1529.505n 1.95v 1539.495n 1.95v 1539.505n 1.95v 1549.495n 1.95v 1549.505n 1.95v 1559.495n 1.95v 1559.505n 1.95v 1569.495n 1.95v 1569.505n 1.95v 1579.495n 1.95v 1579.505n 1.95v 1589.495n 1.95v 1589.505n 1.95v 1599.495n 1.95v 1599.505n 0.0v 1609.495n 0.0v 1609.505n 1.95v 1619.495n 1.95v 1619.505n 1.95v 1629.495n 1.95v 1629.505n 1.95v 1639.495n 1.95v 1639.505n 1.95v 1649.495n 1.95v 1649.505n 1.95v 1659.495n 1.95v 1659.505n 0.0v 1669.495n 0.0v 1669.505n 0.0v 1679.495n 0.0v 1679.505n 0.0v 1689.495n 0.0v 1689.505n 0.0v 1699.495n 0.0v 1699.505n 0.0v 1709.495n 0.0v 1709.505n 0.0v 1719.495n 0.0v 1719.505n 1.95v 1729.495n 1.95v 1729.505n 1.95v 1739.495n 1.95v 1739.505n 1.95v 1749.495n 1.95v 1749.505n 1.95v 1759.495n 1.95v 1759.505n 1.95v 1769.495n 1.95v 1769.505n 1.95v 1779.495n 1.95v 1779.505n 1.95v 1789.495n 1.95v 1789.505n 1.95v 1799.495n 1.95v 1799.505n 1.95v 1809.495n 1.95v 1809.505n 1.95v 1819.495n 1.95v 1819.505n 1.95v 1829.495n 1.95v 1829.505n 1.95v 1839.495n 1.95v 1839.505n 1.95v 1849.495n 1.95v 1849.505n 0.0v 1859.495n 0.0v 1859.505n 1.95v 1869.495n 1.95v 1869.505n 1.95v 1879.495n 1.95v 1879.505n 1.95v 1889.495n 1.95v 1889.505n 1.95v 1899.495n 1.95v 1899.505n 1.95v 1909.495n 1.95v 1909.505n 1.95v 1919.495n 1.95v 1919.505n 1.95v 1929.495n 1.95v 1929.505n 1.95v 1939.495n 1.95v 1939.505n 1.95v 1949.495n 1.95v 1949.505n 0.0v 1959.495n 0.0v 1959.505n 1.95v 1969.495n 1.95v 1969.505n 1.95v 1979.495n 1.95v 1979.505n 1.95v 1989.495n 1.95v 1989.505n 0.0v 1999.495n 0.0v 1999.505n 0.0v 2009.495n 0.0v 2009.505n 0.0v 2019.495n 0.0v 2019.505n 0.0v 2029.495n 0.0v 2029.505n 0.0v 2039.495n 0.0v 2039.505n 0.0v 2049.495n 0.0v 2049.505n 0.0v )
* (time, data): [(0, 0), (10, 0), (20, 0), (30, 0), (40, 0), (50, 0), (60, 1), (70, 0), (80, 0), (90, 0), (100, 0), (110, 1), (120, 1), (130, 1), (140, 1), (150, 1), (160, 1), (170, 1), (180, 1), (190, 1), (200, 1), (210, 1), (220, 1), (230, 1), (240, 0), (250, 0), (260, 0), (270, 1), (280, 1), (290, 1), (300, 0), (310, 0), (320, 0), (330, 0), (340, 1), (350, 1), (360, 1), (370, 0), (380, 0), (390, 0), (400, 0), (410, 0), (420, 1), (430, 1), (440, 1), (450, 1), (460, 1), (470, 1), (480, 1), (490, 1), (500, 0), (510, 1), (520, 1), (530, 1), (540, 0), (550, 0), (560, 0), (570, 0), (580, 0), (590, 0), (600, 0), (610, 0), (620, 0), (630, 0), (640, 1), (650, 0), (660, 0), (670, 0), (680, 0), (690, 0), (700, 1), (710, 1), (720, 1), (730, 0), (740, 0), (750, 0), (760, 0), (770, 1), (780, 0), (790, 0), (800, 0), (810, 0), (820, 0), (830, 0), (840, 0), (850, 0), (860, 0), (870, 0), (880, 0), (890, 0), (900, 0), (910, 0), (920, 0), (930, 0), (940, 0), (950, 1), (960, 1), (970, 1), (980, 0), (990, 0), (1000, 0), (1010, 1), (1020, 1), (1030, 0), (1040, 0), (1050, 0), (1060, 0), (1070, 0), (1080, 0), (1090, 0), (1100, 0), (1110, 0), (1120, 0), (1130, 0), (1140, 0), (1150, 0), (1160, 0), (1170, 0), (1180, 0), (1190, 0), (1200, 0), (1210, 1), (1220, 1), (1230, 1), (1240, 0), (1250, 0), (1260, 0), (1270, 0), (1280, 0), (1290, 1), (1300, 1), (1310, 1), (1320, 1), (1330, 0), (1340, 1), (1350, 1), (1360, 1), (1370, 1), (1380, 1), (1390, 0), (1400, 0), (1410, 0), (1420, 0), (1430, 0), (1440, 1), (1450, 1), (1460, 1), (1470, 1), (1480, 1), (1490, 1), (1500, 1), (1510, 1), (1520, 1), (1530, 1), (1540, 1), (1550, 1), (1560, 0), (1570, 0), (1580, 0), (1590, 0), (1600, 1), (1610, 1), (1620, 1), (1630, 1), (1640, 1), (1650, 1), (1660, 1), (1670, 1), (1680, 1), (1690, 0), (1700, 0), (1710, 0), (1720, 0), (1730, 0), (1740, 1), (1750, 1), (1760, 0), (1770, 0), (1780, 0), (1790, 0), (1800, 0), (1810, 1), (1820, 1), (1830, 1), (1840, 0), (1850, 1), (1860, 0), (1870, 0), (1880, 0), (1890, 0), (1900, 0), (1910, 0), (1920, 0), (1930, 0), (1940, 0), (1950, 0), (1960, 0), (1970, 1), (1980, 1), (1990, 0), (2000, 0), (2010, 0), (2020, 0), (2030, 0), (2040, 0), (2050, 0)]
Vdin0_27  din0_27  0 PWL (0n 0.0v 9.495n 0.0v 9.505n 0.0v 19.495n 0.0v 19.505n 0.0v 29.495n 0.0v 29.505n 0.0v 39.495n 0.0v 39.505n 0.0v 49.495n 0.0v 49.505n 0.0v 59.495n 0.0v 59.505n 1.95v 69.495n 1.95v 69.505n 0.0v 79.495n 0.0v 79.505n 0.0v 89.495n 0.0v 89.505n 0.0v 99.495n 0.0v 99.505n 0.0v 109.495n 0.0v 109.505n 1.95v 119.495n 1.95v 119.505n 1.95v 129.495n 1.95v 129.505n 1.95v 139.495n 1.95v 139.505n 1.95v 149.495n 1.95v 149.505n 1.95v 159.495n 1.95v 159.505n 1.95v 169.495n 1.95v 169.505n 1.95v 179.495n 1.95v 179.505n 1.95v 189.495n 1.95v 189.505n 1.95v 199.495n 1.95v 199.505n 1.95v 209.495n 1.95v 209.505n 1.95v 219.495n 1.95v 219.505n 1.95v 229.495n 1.95v 229.505n 1.95v 239.495n 1.95v 239.505n 0.0v 249.495n 0.0v 249.505n 0.0v 259.495n 0.0v 259.505n 0.0v 269.495n 0.0v 269.505n 1.95v 279.495n 1.95v 279.505n 1.95v 289.495n 1.95v 289.505n 1.95v 299.495n 1.95v 299.505n 0.0v 309.495n 0.0v 309.505n 0.0v 319.495n 0.0v 319.505n 0.0v 329.495n 0.0v 329.505n 0.0v 339.495n 0.0v 339.505n 1.95v 349.495n 1.95v 349.505n 1.95v 359.495n 1.95v 359.505n 1.95v 369.495n 1.95v 369.505n 0.0v 379.495n 0.0v 379.505n 0.0v 389.495n 0.0v 389.505n 0.0v 399.495n 0.0v 399.505n 0.0v 409.495n 0.0v 409.505n 0.0v 419.495n 0.0v 419.505n 1.95v 429.495n 1.95v 429.505n 1.95v 439.495n 1.95v 439.505n 1.95v 449.495n 1.95v 449.505n 1.95v 459.495n 1.95v 459.505n 1.95v 469.495n 1.95v 469.505n 1.95v 479.495n 1.95v 479.505n 1.95v 489.495n 1.95v 489.505n 1.95v 499.495n 1.95v 499.505n 0.0v 509.495n 0.0v 509.505n 1.95v 519.495n 1.95v 519.505n 1.95v 529.495n 1.95v 529.505n 1.95v 539.495n 1.95v 539.505n 0.0v 549.495n 0.0v 549.505n 0.0v 559.495n 0.0v 559.505n 0.0v 569.495n 0.0v 569.505n 0.0v 579.495n 0.0v 579.505n 0.0v 589.495n 0.0v 589.505n 0.0v 599.495n 0.0v 599.505n 0.0v 609.495n 0.0v 609.505n 0.0v 619.495n 0.0v 619.505n 0.0v 629.495n 0.0v 629.505n 0.0v 639.495n 0.0v 639.505n 1.95v 649.495n 1.95v 649.505n 0.0v 659.495n 0.0v 659.505n 0.0v 669.495n 0.0v 669.505n 0.0v 679.495n 0.0v 679.505n 0.0v 689.495n 0.0v 689.505n 0.0v 699.495n 0.0v 699.505n 1.95v 709.495n 1.95v 709.505n 1.95v 719.495n 1.95v 719.505n 1.95v 729.495n 1.95v 729.505n 0.0v 739.495n 0.0v 739.505n 0.0v 749.495n 0.0v 749.505n 0.0v 759.495n 0.0v 759.505n 0.0v 769.495n 0.0v 769.505n 1.95v 779.495n 1.95v 779.505n 0.0v 789.495n 0.0v 789.505n 0.0v 799.495n 0.0v 799.505n 0.0v 809.495n 0.0v 809.505n 0.0v 819.495n 0.0v 819.505n 0.0v 829.495n 0.0v 829.505n 0.0v 839.495n 0.0v 839.505n 0.0v 849.495n 0.0v 849.505n 0.0v 859.495n 0.0v 859.505n 0.0v 869.495n 0.0v 869.505n 0.0v 879.495n 0.0v 879.505n 0.0v 889.495n 0.0v 889.505n 0.0v 899.495n 0.0v 899.505n 0.0v 909.495n 0.0v 909.505n 0.0v 919.495n 0.0v 919.505n 0.0v 929.495n 0.0v 929.505n 0.0v 939.495n 0.0v 939.505n 0.0v 949.495n 0.0v 949.505n 1.95v 959.495n 1.95v 959.505n 1.95v 969.495n 1.95v 969.505n 1.95v 979.495n 1.95v 979.505n 0.0v 989.495n 0.0v 989.505n 0.0v 999.495n 0.0v 999.505n 0.0v 1009.495n 0.0v 1009.505n 1.95v 1019.495n 1.95v 1019.505n 1.95v 1029.495n 1.95v 1029.505n 0.0v 1039.495n 0.0v 1039.505n 0.0v 1049.495n 0.0v 1049.505n 0.0v 1059.495n 0.0v 1059.505n 0.0v 1069.495n 0.0v 1069.505n 0.0v 1079.495n 0.0v 1079.505n 0.0v 1089.495n 0.0v 1089.505n 0.0v 1099.495n 0.0v 1099.505n 0.0v 1109.495n 0.0v 1109.505n 0.0v 1119.495n 0.0v 1119.505n 0.0v 1129.495n 0.0v 1129.505n 0.0v 1139.495n 0.0v 1139.505n 0.0v 1149.495n 0.0v 1149.505n 0.0v 1159.495n 0.0v 1159.505n 0.0v 1169.495n 0.0v 1169.505n 0.0v 1179.495n 0.0v 1179.505n 0.0v 1189.495n 0.0v 1189.505n 0.0v 1199.495n 0.0v 1199.505n 0.0v 1209.495n 0.0v 1209.505n 1.95v 1219.495n 1.95v 1219.505n 1.95v 1229.495n 1.95v 1229.505n 1.95v 1239.495n 1.95v 1239.505n 0.0v 1249.495n 0.0v 1249.505n 0.0v 1259.495n 0.0v 1259.505n 0.0v 1269.495n 0.0v 1269.505n 0.0v 1279.495n 0.0v 1279.505n 0.0v 1289.495n 0.0v 1289.505n 1.95v 1299.495n 1.95v 1299.505n 1.95v 1309.495n 1.95v 1309.505n 1.95v 1319.495n 1.95v 1319.505n 1.95v 1329.495n 1.95v 1329.505n 0.0v 1339.495n 0.0v 1339.505n 1.95v 1349.495n 1.95v 1349.505n 1.95v 1359.495n 1.95v 1359.505n 1.95v 1369.495n 1.95v 1369.505n 1.95v 1379.495n 1.95v 1379.505n 1.95v 1389.495n 1.95v 1389.505n 0.0v 1399.495n 0.0v 1399.505n 0.0v 1409.495n 0.0v 1409.505n 0.0v 1419.495n 0.0v 1419.505n 0.0v 1429.495n 0.0v 1429.505n 0.0v 1439.495n 0.0v 1439.505n 1.95v 1449.495n 1.95v 1449.505n 1.95v 1459.495n 1.95v 1459.505n 1.95v 1469.495n 1.95v 1469.505n 1.95v 1479.495n 1.95v 1479.505n 1.95v 1489.495n 1.95v 1489.505n 1.95v 1499.495n 1.95v 1499.505n 1.95v 1509.495n 1.95v 1509.505n 1.95v 1519.495n 1.95v 1519.505n 1.95v 1529.495n 1.95v 1529.505n 1.95v 1539.495n 1.95v 1539.505n 1.95v 1549.495n 1.95v 1549.505n 1.95v 1559.495n 1.95v 1559.505n 0.0v 1569.495n 0.0v 1569.505n 0.0v 1579.495n 0.0v 1579.505n 0.0v 1589.495n 0.0v 1589.505n 0.0v 1599.495n 0.0v 1599.505n 1.95v 1609.495n 1.95v 1609.505n 1.95v 1619.495n 1.95v 1619.505n 1.95v 1629.495n 1.95v 1629.505n 1.95v 1639.495n 1.95v 1639.505n 1.95v 1649.495n 1.95v 1649.505n 1.95v 1659.495n 1.95v 1659.505n 1.95v 1669.495n 1.95v 1669.505n 1.95v 1679.495n 1.95v 1679.505n 1.95v 1689.495n 1.95v 1689.505n 0.0v 1699.495n 0.0v 1699.505n 0.0v 1709.495n 0.0v 1709.505n 0.0v 1719.495n 0.0v 1719.505n 0.0v 1729.495n 0.0v 1729.505n 0.0v 1739.495n 0.0v 1739.505n 1.95v 1749.495n 1.95v 1749.505n 1.95v 1759.495n 1.95v 1759.505n 0.0v 1769.495n 0.0v 1769.505n 0.0v 1779.495n 0.0v 1779.505n 0.0v 1789.495n 0.0v 1789.505n 0.0v 1799.495n 0.0v 1799.505n 0.0v 1809.495n 0.0v 1809.505n 1.95v 1819.495n 1.95v 1819.505n 1.95v 1829.495n 1.95v 1829.505n 1.95v 1839.495n 1.95v 1839.505n 0.0v 1849.495n 0.0v 1849.505n 1.95v 1859.495n 1.95v 1859.505n 0.0v 1869.495n 0.0v 1869.505n 0.0v 1879.495n 0.0v 1879.505n 0.0v 1889.495n 0.0v 1889.505n 0.0v 1899.495n 0.0v 1899.505n 0.0v 1909.495n 0.0v 1909.505n 0.0v 1919.495n 0.0v 1919.505n 0.0v 1929.495n 0.0v 1929.505n 0.0v 1939.495n 0.0v 1939.505n 0.0v 1949.495n 0.0v 1949.505n 0.0v 1959.495n 0.0v 1959.505n 0.0v 1969.495n 0.0v 1969.505n 1.95v 1979.495n 1.95v 1979.505n 1.95v 1989.495n 1.95v 1989.505n 0.0v 1999.495n 0.0v 1999.505n 0.0v 2009.495n 0.0v 2009.505n 0.0v 2019.495n 0.0v 2019.505n 0.0v 2029.495n 0.0v 2029.505n 0.0v 2039.495n 0.0v 2039.505n 0.0v 2049.495n 0.0v 2049.505n 0.0v )
* (time, data): [(0, 0), (10, 1), (20, 0), (30, 1), (40, 1), (50, 1), (60, 0), (70, 1), (80, 1), (90, 1), (100, 1), (110, 1), (120, 1), (130, 1), (140, 1), (150, 1), (160, 1), (170, 1), (180, 1), (190, 1), (200, 1), (210, 1), (220, 1), (230, 1), (240, 1), (250, 1), (260, 1), (270, 1), (280, 1), (290, 1), (300, 0), (310, 0), (320, 0), (330, 0), (340, 0), (350, 0), (360, 0), (370, 1), (380, 1), (390, 1), (400, 1), (410, 1), (420, 1), (430, 1), (440, 1), (450, 1), (460, 1), (470, 1), (480, 1), (490, 1), (500, 1), (510, 0), (520, 0), (530, 0), (540, 1), (550, 0), (560, 0), (570, 0), (580, 0), (590, 1), (600, 1), (610, 1), (620, 1), (630, 1), (640, 0), (650, 0), (660, 0), (670, 1), (680, 1), (690, 1), (700, 1), (710, 1), (720, 1), (730, 1), (740, 1), (750, 1), (760, 1), (770, 1), (780, 1), (790, 0), (800, 0), (810, 0), (820, 0), (830, 1), (840, 1), (850, 1), (860, 1), (870, 1), (880, 1), (890, 1), (900, 1), (910, 1), (920, 1), (930, 1), (940, 0), (950, 1), (960, 1), (970, 1), (980, 1), (990, 1), (1000, 1), (1010, 0), (1020, 0), (1030, 1), (1040, 1), (1050, 0), (1060, 0), (1070, 0), (1080, 0), (1090, 0), (1100, 0), (1110, 1), (1120, 1), (1130, 1), (1140, 1), (1150, 1), (1160, 1), (1170, 1), (1180, 1), (1190, 1), (1200, 1), (1210, 0), (1220, 0), (1230, 0), (1240, 0), (1250, 1), (1260, 1), (1270, 1), (1280, 1), (1290, 0), (1300, 0), (1310, 0), (1320, 0), (1330, 1), (1340, 1), (1350, 1), (1360, 1), (1370, 1), (1380, 0), (1390, 0), (1400, 0), (1410, 0), (1420, 1), (1430, 1), (1440, 0), (1450, 0), (1460, 0), (1470, 0), (1480, 0), (1490, 0), (1500, 0), (1510, 0), (1520, 0), (1530, 0), (1540, 0), (1550, 1), (1560, 0), (1570, 0), (1580, 0), (1590, 0), (1600, 0), (1610, 1), (1620, 1), (1630, 1), (1640, 1), (1650, 1), (1660, 0), (1670, 0), (1680, 1), (1690, 1), (1700, 1), (1710, 1), (1720, 0), (1730, 0), (1740, 1), (1750, 1), (1760, 0), (1770, 0), (1780, 0), (1790, 0), (1800, 0), (1810, 1), (1820, 1), (1830, 1), (1840, 0), (1850, 1), (1860, 1), (1870, 1), (1880, 1), (1890, 1), (1900, 1), (1910, 1), (1920, 1), (1930, 1), (1940, 1), (1950, 1), (1960, 1), (1970, 0), (1980, 0), (1990, 0), (2000, 0), (2010, 0), (2020, 0), (2030, 0), (2040, 0), (2050, 0)]
Vdin0_28  din0_28  0 PWL (0n 0.0v 9.495n 0.0v 9.505n 1.95v 19.495n 1.95v 19.505n 0.0v 29.495n 0.0v 29.505n 1.95v 39.495n 1.95v 39.505n 1.95v 49.495n 1.95v 49.505n 1.95v 59.495n 1.95v 59.505n 0.0v 69.495n 0.0v 69.505n 1.95v 79.495n 1.95v 79.505n 1.95v 89.495n 1.95v 89.505n 1.95v 99.495n 1.95v 99.505n 1.95v 109.495n 1.95v 109.505n 1.95v 119.495n 1.95v 119.505n 1.95v 129.495n 1.95v 129.505n 1.95v 139.495n 1.95v 139.505n 1.95v 149.495n 1.95v 149.505n 1.95v 159.495n 1.95v 159.505n 1.95v 169.495n 1.95v 169.505n 1.95v 179.495n 1.95v 179.505n 1.95v 189.495n 1.95v 189.505n 1.95v 199.495n 1.95v 199.505n 1.95v 209.495n 1.95v 209.505n 1.95v 219.495n 1.95v 219.505n 1.95v 229.495n 1.95v 229.505n 1.95v 239.495n 1.95v 239.505n 1.95v 249.495n 1.95v 249.505n 1.95v 259.495n 1.95v 259.505n 1.95v 269.495n 1.95v 269.505n 1.95v 279.495n 1.95v 279.505n 1.95v 289.495n 1.95v 289.505n 1.95v 299.495n 1.95v 299.505n 0.0v 309.495n 0.0v 309.505n 0.0v 319.495n 0.0v 319.505n 0.0v 329.495n 0.0v 329.505n 0.0v 339.495n 0.0v 339.505n 0.0v 349.495n 0.0v 349.505n 0.0v 359.495n 0.0v 359.505n 0.0v 369.495n 0.0v 369.505n 1.95v 379.495n 1.95v 379.505n 1.95v 389.495n 1.95v 389.505n 1.95v 399.495n 1.95v 399.505n 1.95v 409.495n 1.95v 409.505n 1.95v 419.495n 1.95v 419.505n 1.95v 429.495n 1.95v 429.505n 1.95v 439.495n 1.95v 439.505n 1.95v 449.495n 1.95v 449.505n 1.95v 459.495n 1.95v 459.505n 1.95v 469.495n 1.95v 469.505n 1.95v 479.495n 1.95v 479.505n 1.95v 489.495n 1.95v 489.505n 1.95v 499.495n 1.95v 499.505n 1.95v 509.495n 1.95v 509.505n 0.0v 519.495n 0.0v 519.505n 0.0v 529.495n 0.0v 529.505n 0.0v 539.495n 0.0v 539.505n 1.95v 549.495n 1.95v 549.505n 0.0v 559.495n 0.0v 559.505n 0.0v 569.495n 0.0v 569.505n 0.0v 579.495n 0.0v 579.505n 0.0v 589.495n 0.0v 589.505n 1.95v 599.495n 1.95v 599.505n 1.95v 609.495n 1.95v 609.505n 1.95v 619.495n 1.95v 619.505n 1.95v 629.495n 1.95v 629.505n 1.95v 639.495n 1.95v 639.505n 0.0v 649.495n 0.0v 649.505n 0.0v 659.495n 0.0v 659.505n 0.0v 669.495n 0.0v 669.505n 1.95v 679.495n 1.95v 679.505n 1.95v 689.495n 1.95v 689.505n 1.95v 699.495n 1.95v 699.505n 1.95v 709.495n 1.95v 709.505n 1.95v 719.495n 1.95v 719.505n 1.95v 729.495n 1.95v 729.505n 1.95v 739.495n 1.95v 739.505n 1.95v 749.495n 1.95v 749.505n 1.95v 759.495n 1.95v 759.505n 1.95v 769.495n 1.95v 769.505n 1.95v 779.495n 1.95v 779.505n 1.95v 789.495n 1.95v 789.505n 0.0v 799.495n 0.0v 799.505n 0.0v 809.495n 0.0v 809.505n 0.0v 819.495n 0.0v 819.505n 0.0v 829.495n 0.0v 829.505n 1.95v 839.495n 1.95v 839.505n 1.95v 849.495n 1.95v 849.505n 1.95v 859.495n 1.95v 859.505n 1.95v 869.495n 1.95v 869.505n 1.95v 879.495n 1.95v 879.505n 1.95v 889.495n 1.95v 889.505n 1.95v 899.495n 1.95v 899.505n 1.95v 909.495n 1.95v 909.505n 1.95v 919.495n 1.95v 919.505n 1.95v 929.495n 1.95v 929.505n 1.95v 939.495n 1.95v 939.505n 0.0v 949.495n 0.0v 949.505n 1.95v 959.495n 1.95v 959.505n 1.95v 969.495n 1.95v 969.505n 1.95v 979.495n 1.95v 979.505n 1.95v 989.495n 1.95v 989.505n 1.95v 999.495n 1.95v 999.505n 1.95v 1009.495n 1.95v 1009.505n 0.0v 1019.495n 0.0v 1019.505n 0.0v 1029.495n 0.0v 1029.505n 1.95v 1039.495n 1.95v 1039.505n 1.95v 1049.495n 1.95v 1049.505n 0.0v 1059.495n 0.0v 1059.505n 0.0v 1069.495n 0.0v 1069.505n 0.0v 1079.495n 0.0v 1079.505n 0.0v 1089.495n 0.0v 1089.505n 0.0v 1099.495n 0.0v 1099.505n 0.0v 1109.495n 0.0v 1109.505n 1.95v 1119.495n 1.95v 1119.505n 1.95v 1129.495n 1.95v 1129.505n 1.95v 1139.495n 1.95v 1139.505n 1.95v 1149.495n 1.95v 1149.505n 1.95v 1159.495n 1.95v 1159.505n 1.95v 1169.495n 1.95v 1169.505n 1.95v 1179.495n 1.95v 1179.505n 1.95v 1189.495n 1.95v 1189.505n 1.95v 1199.495n 1.95v 1199.505n 1.95v 1209.495n 1.95v 1209.505n 0.0v 1219.495n 0.0v 1219.505n 0.0v 1229.495n 0.0v 1229.505n 0.0v 1239.495n 0.0v 1239.505n 0.0v 1249.495n 0.0v 1249.505n 1.95v 1259.495n 1.95v 1259.505n 1.95v 1269.495n 1.95v 1269.505n 1.95v 1279.495n 1.95v 1279.505n 1.95v 1289.495n 1.95v 1289.505n 0.0v 1299.495n 0.0v 1299.505n 0.0v 1309.495n 0.0v 1309.505n 0.0v 1319.495n 0.0v 1319.505n 0.0v 1329.495n 0.0v 1329.505n 1.95v 1339.495n 1.95v 1339.505n 1.95v 1349.495n 1.95v 1349.505n 1.95v 1359.495n 1.95v 1359.505n 1.95v 1369.495n 1.95v 1369.505n 1.95v 1379.495n 1.95v 1379.505n 0.0v 1389.495n 0.0v 1389.505n 0.0v 1399.495n 0.0v 1399.505n 0.0v 1409.495n 0.0v 1409.505n 0.0v 1419.495n 0.0v 1419.505n 1.95v 1429.495n 1.95v 1429.505n 1.95v 1439.495n 1.95v 1439.505n 0.0v 1449.495n 0.0v 1449.505n 0.0v 1459.495n 0.0v 1459.505n 0.0v 1469.495n 0.0v 1469.505n 0.0v 1479.495n 0.0v 1479.505n 0.0v 1489.495n 0.0v 1489.505n 0.0v 1499.495n 0.0v 1499.505n 0.0v 1509.495n 0.0v 1509.505n 0.0v 1519.495n 0.0v 1519.505n 0.0v 1529.495n 0.0v 1529.505n 0.0v 1539.495n 0.0v 1539.505n 0.0v 1549.495n 0.0v 1549.505n 1.95v 1559.495n 1.95v 1559.505n 0.0v 1569.495n 0.0v 1569.505n 0.0v 1579.495n 0.0v 1579.505n 0.0v 1589.495n 0.0v 1589.505n 0.0v 1599.495n 0.0v 1599.505n 0.0v 1609.495n 0.0v 1609.505n 1.95v 1619.495n 1.95v 1619.505n 1.95v 1629.495n 1.95v 1629.505n 1.95v 1639.495n 1.95v 1639.505n 1.95v 1649.495n 1.95v 1649.505n 1.95v 1659.495n 1.95v 1659.505n 0.0v 1669.495n 0.0v 1669.505n 0.0v 1679.495n 0.0v 1679.505n 1.95v 1689.495n 1.95v 1689.505n 1.95v 1699.495n 1.95v 1699.505n 1.95v 1709.495n 1.95v 1709.505n 1.95v 1719.495n 1.95v 1719.505n 0.0v 1729.495n 0.0v 1729.505n 0.0v 1739.495n 0.0v 1739.505n 1.95v 1749.495n 1.95v 1749.505n 1.95v 1759.495n 1.95v 1759.505n 0.0v 1769.495n 0.0v 1769.505n 0.0v 1779.495n 0.0v 1779.505n 0.0v 1789.495n 0.0v 1789.505n 0.0v 1799.495n 0.0v 1799.505n 0.0v 1809.495n 0.0v 1809.505n 1.95v 1819.495n 1.95v 1819.505n 1.95v 1829.495n 1.95v 1829.505n 1.95v 1839.495n 1.95v 1839.505n 0.0v 1849.495n 0.0v 1849.505n 1.95v 1859.495n 1.95v 1859.505n 1.95v 1869.495n 1.95v 1869.505n 1.95v 1879.495n 1.95v 1879.505n 1.95v 1889.495n 1.95v 1889.505n 1.95v 1899.495n 1.95v 1899.505n 1.95v 1909.495n 1.95v 1909.505n 1.95v 1919.495n 1.95v 1919.505n 1.95v 1929.495n 1.95v 1929.505n 1.95v 1939.495n 1.95v 1939.505n 1.95v 1949.495n 1.95v 1949.505n 1.95v 1959.495n 1.95v 1959.505n 1.95v 1969.495n 1.95v 1969.505n 0.0v 1979.495n 0.0v 1979.505n 0.0v 1989.495n 0.0v 1989.505n 0.0v 1999.495n 0.0v 1999.505n 0.0v 2009.495n 0.0v 2009.505n 0.0v 2019.495n 0.0v 2019.505n 0.0v 2029.495n 0.0v 2029.505n 0.0v 2039.495n 0.0v 2039.505n 0.0v 2049.495n 0.0v 2049.505n 0.0v )
* (time, data): [(0, 0), (10, 0), (20, 1), (30, 0), (40, 0), (50, 0), (60, 0), (70, 0), (80, 1), (90, 1), (100, 1), (110, 0), (120, 0), (130, 0), (140, 0), (150, 0), (160, 1), (170, 1), (180, 1), (190, 1), (200, 1), (210, 1), (220, 1), (230, 1), (240, 0), (250, 0), (260, 0), (270, 1), (280, 1), (290, 1), (300, 1), (310, 1), (320, 1), (330, 1), (340, 1), (350, 1), (360, 1), (370, 1), (380, 1), (390, 1), (400, 1), (410, 1), (420, 0), (430, 0), (440, 0), (450, 0), (460, 0), (470, 0), (480, 0), (490, 0), (500, 1), (510, 0), (520, 0), (530, 0), (540, 1), (550, 0), (560, 0), (570, 0), (580, 0), (590, 1), (600, 1), (610, 1), (620, 1), (630, 1), (640, 0), (650, 1), (660, 1), (670, 0), (680, 0), (690, 0), (700, 0), (710, 0), (720, 0), (730, 0), (740, 0), (750, 1), (760, 1), (770, 0), (780, 0), (790, 1), (800, 1), (810, 1), (820, 1), (830, 1), (840, 1), (850, 0), (860, 0), (870, 0), (880, 0), (890, 0), (900, 0), (910, 0), (920, 0), (930, 0), (940, 1), (950, 0), (960, 0), (970, 1), (980, 1), (990, 1), (1000, 1), (1010, 0), (1020, 0), (1030, 1), (1040, 1), (1050, 0), (1060, 0), (1070, 0), (1080, 0), (1090, 0), (1100, 0), (1110, 1), (1120, 1), (1130, 1), (1140, 1), (1150, 1), (1160, 1), (1170, 1), (1180, 1), (1190, 1), (1200, 1), (1210, 1), (1220, 1), (1230, 0), (1240, 0), (1250, 1), (1260, 1), (1270, 1), (1280, 1), (1290, 0), (1300, 0), (1310, 0), (1320, 0), (1330, 0), (1340, 1), (1350, 1), (1360, 1), (1370, 1), (1380, 0), (1390, 0), (1400, 0), (1410, 0), (1420, 1), (1430, 1), (1440, 0), (1450, 0), (1460, 0), (1470, 0), (1480, 0), (1490, 0), (1500, 0), (1510, 0), (1520, 0), (1530, 0), (1540, 0), (1550, 1), (1560, 1), (1570, 1), (1580, 1), (1590, 1), (1600, 1), (1610, 1), (1620, 1), (1630, 1), (1640, 1), (1650, 1), (1660, 1), (1670, 1), (1680, 1), (1690, 1), (1700, 1), (1710, 1), (1720, 1), (1730, 1), (1740, 0), (1750, 0), (1760, 0), (1770, 0), (1780, 0), (1790, 0), (1800, 0), (1810, 1), (1820, 1), (1830, 1), (1840, 0), (1850, 1), (1860, 0), (1870, 0), (1880, 0), (1890, 0), (1900, 0), (1910, 0), (1920, 0), (1930, 0), (1940, 0), (1950, 1), (1960, 0), (1970, 0), (1980, 0), (1990, 1), (2000, 1), (2010, 1), (2020, 1), (2030, 1), (2040, 1), (2050, 1)]
Vdin0_29  din0_29  0 PWL (0n 0.0v 9.495n 0.0v 9.505n 0.0v 19.495n 0.0v 19.505n 1.95v 29.495n 1.95v 29.505n 0.0v 39.495n 0.0v 39.505n 0.0v 49.495n 0.0v 49.505n 0.0v 59.495n 0.0v 59.505n 0.0v 69.495n 0.0v 69.505n 0.0v 79.495n 0.0v 79.505n 1.95v 89.495n 1.95v 89.505n 1.95v 99.495n 1.95v 99.505n 1.95v 109.495n 1.95v 109.505n 0.0v 119.495n 0.0v 119.505n 0.0v 129.495n 0.0v 129.505n 0.0v 139.495n 0.0v 139.505n 0.0v 149.495n 0.0v 149.505n 0.0v 159.495n 0.0v 159.505n 1.95v 169.495n 1.95v 169.505n 1.95v 179.495n 1.95v 179.505n 1.95v 189.495n 1.95v 189.505n 1.95v 199.495n 1.95v 199.505n 1.95v 209.495n 1.95v 209.505n 1.95v 219.495n 1.95v 219.505n 1.95v 229.495n 1.95v 229.505n 1.95v 239.495n 1.95v 239.505n 0.0v 249.495n 0.0v 249.505n 0.0v 259.495n 0.0v 259.505n 0.0v 269.495n 0.0v 269.505n 1.95v 279.495n 1.95v 279.505n 1.95v 289.495n 1.95v 289.505n 1.95v 299.495n 1.95v 299.505n 1.95v 309.495n 1.95v 309.505n 1.95v 319.495n 1.95v 319.505n 1.95v 329.495n 1.95v 329.505n 1.95v 339.495n 1.95v 339.505n 1.95v 349.495n 1.95v 349.505n 1.95v 359.495n 1.95v 359.505n 1.95v 369.495n 1.95v 369.505n 1.95v 379.495n 1.95v 379.505n 1.95v 389.495n 1.95v 389.505n 1.95v 399.495n 1.95v 399.505n 1.95v 409.495n 1.95v 409.505n 1.95v 419.495n 1.95v 419.505n 0.0v 429.495n 0.0v 429.505n 0.0v 439.495n 0.0v 439.505n 0.0v 449.495n 0.0v 449.505n 0.0v 459.495n 0.0v 459.505n 0.0v 469.495n 0.0v 469.505n 0.0v 479.495n 0.0v 479.505n 0.0v 489.495n 0.0v 489.505n 0.0v 499.495n 0.0v 499.505n 1.95v 509.495n 1.95v 509.505n 0.0v 519.495n 0.0v 519.505n 0.0v 529.495n 0.0v 529.505n 0.0v 539.495n 0.0v 539.505n 1.95v 549.495n 1.95v 549.505n 0.0v 559.495n 0.0v 559.505n 0.0v 569.495n 0.0v 569.505n 0.0v 579.495n 0.0v 579.505n 0.0v 589.495n 0.0v 589.505n 1.95v 599.495n 1.95v 599.505n 1.95v 609.495n 1.95v 609.505n 1.95v 619.495n 1.95v 619.505n 1.95v 629.495n 1.95v 629.505n 1.95v 639.495n 1.95v 639.505n 0.0v 649.495n 0.0v 649.505n 1.95v 659.495n 1.95v 659.505n 1.95v 669.495n 1.95v 669.505n 0.0v 679.495n 0.0v 679.505n 0.0v 689.495n 0.0v 689.505n 0.0v 699.495n 0.0v 699.505n 0.0v 709.495n 0.0v 709.505n 0.0v 719.495n 0.0v 719.505n 0.0v 729.495n 0.0v 729.505n 0.0v 739.495n 0.0v 739.505n 0.0v 749.495n 0.0v 749.505n 1.95v 759.495n 1.95v 759.505n 1.95v 769.495n 1.95v 769.505n 0.0v 779.495n 0.0v 779.505n 0.0v 789.495n 0.0v 789.505n 1.95v 799.495n 1.95v 799.505n 1.95v 809.495n 1.95v 809.505n 1.95v 819.495n 1.95v 819.505n 1.95v 829.495n 1.95v 829.505n 1.95v 839.495n 1.95v 839.505n 1.95v 849.495n 1.95v 849.505n 0.0v 859.495n 0.0v 859.505n 0.0v 869.495n 0.0v 869.505n 0.0v 879.495n 0.0v 879.505n 0.0v 889.495n 0.0v 889.505n 0.0v 899.495n 0.0v 899.505n 0.0v 909.495n 0.0v 909.505n 0.0v 919.495n 0.0v 919.505n 0.0v 929.495n 0.0v 929.505n 0.0v 939.495n 0.0v 939.505n 1.95v 949.495n 1.95v 949.505n 0.0v 959.495n 0.0v 959.505n 0.0v 969.495n 0.0v 969.505n 1.95v 979.495n 1.95v 979.505n 1.95v 989.495n 1.95v 989.505n 1.95v 999.495n 1.95v 999.505n 1.95v 1009.495n 1.95v 1009.505n 0.0v 1019.495n 0.0v 1019.505n 0.0v 1029.495n 0.0v 1029.505n 1.95v 1039.495n 1.95v 1039.505n 1.95v 1049.495n 1.95v 1049.505n 0.0v 1059.495n 0.0v 1059.505n 0.0v 1069.495n 0.0v 1069.505n 0.0v 1079.495n 0.0v 1079.505n 0.0v 1089.495n 0.0v 1089.505n 0.0v 1099.495n 0.0v 1099.505n 0.0v 1109.495n 0.0v 1109.505n 1.95v 1119.495n 1.95v 1119.505n 1.95v 1129.495n 1.95v 1129.505n 1.95v 1139.495n 1.95v 1139.505n 1.95v 1149.495n 1.95v 1149.505n 1.95v 1159.495n 1.95v 1159.505n 1.95v 1169.495n 1.95v 1169.505n 1.95v 1179.495n 1.95v 1179.505n 1.95v 1189.495n 1.95v 1189.505n 1.95v 1199.495n 1.95v 1199.505n 1.95v 1209.495n 1.95v 1209.505n 1.95v 1219.495n 1.95v 1219.505n 1.95v 1229.495n 1.95v 1229.505n 0.0v 1239.495n 0.0v 1239.505n 0.0v 1249.495n 0.0v 1249.505n 1.95v 1259.495n 1.95v 1259.505n 1.95v 1269.495n 1.95v 1269.505n 1.95v 1279.495n 1.95v 1279.505n 1.95v 1289.495n 1.95v 1289.505n 0.0v 1299.495n 0.0v 1299.505n 0.0v 1309.495n 0.0v 1309.505n 0.0v 1319.495n 0.0v 1319.505n 0.0v 1329.495n 0.0v 1329.505n 0.0v 1339.495n 0.0v 1339.505n 1.95v 1349.495n 1.95v 1349.505n 1.95v 1359.495n 1.95v 1359.505n 1.95v 1369.495n 1.95v 1369.505n 1.95v 1379.495n 1.95v 1379.505n 0.0v 1389.495n 0.0v 1389.505n 0.0v 1399.495n 0.0v 1399.505n 0.0v 1409.495n 0.0v 1409.505n 0.0v 1419.495n 0.0v 1419.505n 1.95v 1429.495n 1.95v 1429.505n 1.95v 1439.495n 1.95v 1439.505n 0.0v 1449.495n 0.0v 1449.505n 0.0v 1459.495n 0.0v 1459.505n 0.0v 1469.495n 0.0v 1469.505n 0.0v 1479.495n 0.0v 1479.505n 0.0v 1489.495n 0.0v 1489.505n 0.0v 1499.495n 0.0v 1499.505n 0.0v 1509.495n 0.0v 1509.505n 0.0v 1519.495n 0.0v 1519.505n 0.0v 1529.495n 0.0v 1529.505n 0.0v 1539.495n 0.0v 1539.505n 0.0v 1549.495n 0.0v 1549.505n 1.95v 1559.495n 1.95v 1559.505n 1.95v 1569.495n 1.95v 1569.505n 1.95v 1579.495n 1.95v 1579.505n 1.95v 1589.495n 1.95v 1589.505n 1.95v 1599.495n 1.95v 1599.505n 1.95v 1609.495n 1.95v 1609.505n 1.95v 1619.495n 1.95v 1619.505n 1.95v 1629.495n 1.95v 1629.505n 1.95v 1639.495n 1.95v 1639.505n 1.95v 1649.495n 1.95v 1649.505n 1.95v 1659.495n 1.95v 1659.505n 1.95v 1669.495n 1.95v 1669.505n 1.95v 1679.495n 1.95v 1679.505n 1.95v 1689.495n 1.95v 1689.505n 1.95v 1699.495n 1.95v 1699.505n 1.95v 1709.495n 1.95v 1709.505n 1.95v 1719.495n 1.95v 1719.505n 1.95v 1729.495n 1.95v 1729.505n 1.95v 1739.495n 1.95v 1739.505n 0.0v 1749.495n 0.0v 1749.505n 0.0v 1759.495n 0.0v 1759.505n 0.0v 1769.495n 0.0v 1769.505n 0.0v 1779.495n 0.0v 1779.505n 0.0v 1789.495n 0.0v 1789.505n 0.0v 1799.495n 0.0v 1799.505n 0.0v 1809.495n 0.0v 1809.505n 1.95v 1819.495n 1.95v 1819.505n 1.95v 1829.495n 1.95v 1829.505n 1.95v 1839.495n 1.95v 1839.505n 0.0v 1849.495n 0.0v 1849.505n 1.95v 1859.495n 1.95v 1859.505n 0.0v 1869.495n 0.0v 1869.505n 0.0v 1879.495n 0.0v 1879.505n 0.0v 1889.495n 0.0v 1889.505n 0.0v 1899.495n 0.0v 1899.505n 0.0v 1909.495n 0.0v 1909.505n 0.0v 1919.495n 0.0v 1919.505n 0.0v 1929.495n 0.0v 1929.505n 0.0v 1939.495n 0.0v 1939.505n 0.0v 1949.495n 0.0v 1949.505n 1.95v 1959.495n 1.95v 1959.505n 0.0v 1969.495n 0.0v 1969.505n 0.0v 1979.495n 0.0v 1979.505n 0.0v 1989.495n 0.0v 1989.505n 1.95v 1999.495n 1.95v 1999.505n 1.95v 2009.495n 1.95v 2009.505n 1.95v 2019.495n 1.95v 2019.505n 1.95v 2029.495n 1.95v 2029.505n 1.95v 2039.495n 1.95v 2039.505n 1.95v 2049.495n 1.95v 2049.505n 1.95v )
* (time, data): [(0, 0), (10, 1), (20, 1), (30, 1), (40, 1), (50, 1), (60, 0), (70, 0), (80, 1), (90, 1), (100, 1), (110, 1), (120, 1), (130, 1), (140, 1), (150, 1), (160, 1), (170, 1), (180, 1), (190, 1), (200, 1), (210, 1), (220, 1), (230, 1), (240, 1), (250, 1), (260, 1), (270, 0), (280, 0), (290, 0), (300, 1), (310, 1), (320, 1), (330, 1), (340, 1), (350, 1), (360, 1), (370, 0), (380, 0), (390, 0), (400, 1), (410, 1), (420, 0), (430, 0), (440, 0), (450, 0), (460, 0), (470, 0), (480, 0), (490, 0), (500, 1), (510, 0), (520, 0), (530, 0), (540, 0), (550, 1), (560, 1), (570, 1), (580, 1), (590, 0), (600, 0), (610, 0), (620, 0), (630, 0), (640, 0), (650, 1), (660, 1), (670, 0), (680, 0), (690, 0), (700, 1), (710, 1), (720, 1), (730, 0), (740, 0), (750, 0), (760, 0), (770, 0), (780, 0), (790, 1), (800, 1), (810, 1), (820, 1), (830, 1), (840, 1), (850, 1), (860, 1), (870, 1), (880, 1), (890, 1), (900, 1), (910, 1), (920, 1), (930, 1), (940, 1), (950, 1), (960, 1), (970, 1), (980, 0), (990, 1), (1000, 1), (1010, 0), (1020, 0), (1030, 1), (1040, 1), (1050, 1), (1060, 1), (1070, 1), (1080, 1), (1090, 1), (1100, 1), (1110, 1), (1120, 1), (1130, 1), (1140, 1), (1150, 0), (1160, 0), (1170, 0), (1180, 0), (1190, 0), (1200, 0), (1210, 1), (1220, 1), (1230, 1), (1240, 0), (1250, 0), (1260, 0), (1270, 0), (1280, 0), (1290, 1), (1300, 1), (1310, 1), (1320, 1), (1330, 1), (1340, 0), (1350, 0), (1360, 0), (1370, 0), (1380, 0), (1390, 1), (1400, 1), (1410, 1), (1420, 0), (1430, 0), (1440, 1), (1450, 1), (1460, 1), (1470, 1), (1480, 1), (1490, 1), (1500, 1), (1510, 1), (1520, 1), (1530, 1), (1540, 1), (1550, 1), (1560, 1), (1570, 1), (1580, 0), (1590, 0), (1600, 0), (1610, 0), (1620, 0), (1630, 0), (1640, 0), (1650, 0), (1660, 1), (1670, 1), (1680, 1), (1690, 0), (1700, 0), (1710, 0), (1720, 0), (1730, 0), (1740, 0), (1750, 0), (1760, 1), (1770, 1), (1780, 1), (1790, 1), (1800, 1), (1810, 0), (1820, 0), (1830, 0), (1840, 0), (1850, 1), (1860, 1), (1870, 1), (1880, 1), (1890, 1), (1900, 1), (1910, 1), (1920, 1), (1930, 1), (1940, 1), (1950, 0), (1960, 1), (1970, 0), (1980, 0), (1990, 1), (2000, 1), (2010, 1), (2020, 1), (2030, 1), (2040, 1), (2050, 1)]
Vdin0_30  din0_30  0 PWL (0n 0.0v 9.495n 0.0v 9.505n 1.95v 19.495n 1.95v 19.505n 1.95v 29.495n 1.95v 29.505n 1.95v 39.495n 1.95v 39.505n 1.95v 49.495n 1.95v 49.505n 1.95v 59.495n 1.95v 59.505n 0.0v 69.495n 0.0v 69.505n 0.0v 79.495n 0.0v 79.505n 1.95v 89.495n 1.95v 89.505n 1.95v 99.495n 1.95v 99.505n 1.95v 109.495n 1.95v 109.505n 1.95v 119.495n 1.95v 119.505n 1.95v 129.495n 1.95v 129.505n 1.95v 139.495n 1.95v 139.505n 1.95v 149.495n 1.95v 149.505n 1.95v 159.495n 1.95v 159.505n 1.95v 169.495n 1.95v 169.505n 1.95v 179.495n 1.95v 179.505n 1.95v 189.495n 1.95v 189.505n 1.95v 199.495n 1.95v 199.505n 1.95v 209.495n 1.95v 209.505n 1.95v 219.495n 1.95v 219.505n 1.95v 229.495n 1.95v 229.505n 1.95v 239.495n 1.95v 239.505n 1.95v 249.495n 1.95v 249.505n 1.95v 259.495n 1.95v 259.505n 1.95v 269.495n 1.95v 269.505n 0.0v 279.495n 0.0v 279.505n 0.0v 289.495n 0.0v 289.505n 0.0v 299.495n 0.0v 299.505n 1.95v 309.495n 1.95v 309.505n 1.95v 319.495n 1.95v 319.505n 1.95v 329.495n 1.95v 329.505n 1.95v 339.495n 1.95v 339.505n 1.95v 349.495n 1.95v 349.505n 1.95v 359.495n 1.95v 359.505n 1.95v 369.495n 1.95v 369.505n 0.0v 379.495n 0.0v 379.505n 0.0v 389.495n 0.0v 389.505n 0.0v 399.495n 0.0v 399.505n 1.95v 409.495n 1.95v 409.505n 1.95v 419.495n 1.95v 419.505n 0.0v 429.495n 0.0v 429.505n 0.0v 439.495n 0.0v 439.505n 0.0v 449.495n 0.0v 449.505n 0.0v 459.495n 0.0v 459.505n 0.0v 469.495n 0.0v 469.505n 0.0v 479.495n 0.0v 479.505n 0.0v 489.495n 0.0v 489.505n 0.0v 499.495n 0.0v 499.505n 1.95v 509.495n 1.95v 509.505n 0.0v 519.495n 0.0v 519.505n 0.0v 529.495n 0.0v 529.505n 0.0v 539.495n 0.0v 539.505n 0.0v 549.495n 0.0v 549.505n 1.95v 559.495n 1.95v 559.505n 1.95v 569.495n 1.95v 569.505n 1.95v 579.495n 1.95v 579.505n 1.95v 589.495n 1.95v 589.505n 0.0v 599.495n 0.0v 599.505n 0.0v 609.495n 0.0v 609.505n 0.0v 619.495n 0.0v 619.505n 0.0v 629.495n 0.0v 629.505n 0.0v 639.495n 0.0v 639.505n 0.0v 649.495n 0.0v 649.505n 1.95v 659.495n 1.95v 659.505n 1.95v 669.495n 1.95v 669.505n 0.0v 679.495n 0.0v 679.505n 0.0v 689.495n 0.0v 689.505n 0.0v 699.495n 0.0v 699.505n 1.95v 709.495n 1.95v 709.505n 1.95v 719.495n 1.95v 719.505n 1.95v 729.495n 1.95v 729.505n 0.0v 739.495n 0.0v 739.505n 0.0v 749.495n 0.0v 749.505n 0.0v 759.495n 0.0v 759.505n 0.0v 769.495n 0.0v 769.505n 0.0v 779.495n 0.0v 779.505n 0.0v 789.495n 0.0v 789.505n 1.95v 799.495n 1.95v 799.505n 1.95v 809.495n 1.95v 809.505n 1.95v 819.495n 1.95v 819.505n 1.95v 829.495n 1.95v 829.505n 1.95v 839.495n 1.95v 839.505n 1.95v 849.495n 1.95v 849.505n 1.95v 859.495n 1.95v 859.505n 1.95v 869.495n 1.95v 869.505n 1.95v 879.495n 1.95v 879.505n 1.95v 889.495n 1.95v 889.505n 1.95v 899.495n 1.95v 899.505n 1.95v 909.495n 1.95v 909.505n 1.95v 919.495n 1.95v 919.505n 1.95v 929.495n 1.95v 929.505n 1.95v 939.495n 1.95v 939.505n 1.95v 949.495n 1.95v 949.505n 1.95v 959.495n 1.95v 959.505n 1.95v 969.495n 1.95v 969.505n 1.95v 979.495n 1.95v 979.505n 0.0v 989.495n 0.0v 989.505n 1.95v 999.495n 1.95v 999.505n 1.95v 1009.495n 1.95v 1009.505n 0.0v 1019.495n 0.0v 1019.505n 0.0v 1029.495n 0.0v 1029.505n 1.95v 1039.495n 1.95v 1039.505n 1.95v 1049.495n 1.95v 1049.505n 1.95v 1059.495n 1.95v 1059.505n 1.95v 1069.495n 1.95v 1069.505n 1.95v 1079.495n 1.95v 1079.505n 1.95v 1089.495n 1.95v 1089.505n 1.95v 1099.495n 1.95v 1099.505n 1.95v 1109.495n 1.95v 1109.505n 1.95v 1119.495n 1.95v 1119.505n 1.95v 1129.495n 1.95v 1129.505n 1.95v 1139.495n 1.95v 1139.505n 1.95v 1149.495n 1.95v 1149.505n 0.0v 1159.495n 0.0v 1159.505n 0.0v 1169.495n 0.0v 1169.505n 0.0v 1179.495n 0.0v 1179.505n 0.0v 1189.495n 0.0v 1189.505n 0.0v 1199.495n 0.0v 1199.505n 0.0v 1209.495n 0.0v 1209.505n 1.95v 1219.495n 1.95v 1219.505n 1.95v 1229.495n 1.95v 1229.505n 1.95v 1239.495n 1.95v 1239.505n 0.0v 1249.495n 0.0v 1249.505n 0.0v 1259.495n 0.0v 1259.505n 0.0v 1269.495n 0.0v 1269.505n 0.0v 1279.495n 0.0v 1279.505n 0.0v 1289.495n 0.0v 1289.505n 1.95v 1299.495n 1.95v 1299.505n 1.95v 1309.495n 1.95v 1309.505n 1.95v 1319.495n 1.95v 1319.505n 1.95v 1329.495n 1.95v 1329.505n 1.95v 1339.495n 1.95v 1339.505n 0.0v 1349.495n 0.0v 1349.505n 0.0v 1359.495n 0.0v 1359.505n 0.0v 1369.495n 0.0v 1369.505n 0.0v 1379.495n 0.0v 1379.505n 0.0v 1389.495n 0.0v 1389.505n 1.95v 1399.495n 1.95v 1399.505n 1.95v 1409.495n 1.95v 1409.505n 1.95v 1419.495n 1.95v 1419.505n 0.0v 1429.495n 0.0v 1429.505n 0.0v 1439.495n 0.0v 1439.505n 1.95v 1449.495n 1.95v 1449.505n 1.95v 1459.495n 1.95v 1459.505n 1.95v 1469.495n 1.95v 1469.505n 1.95v 1479.495n 1.95v 1479.505n 1.95v 1489.495n 1.95v 1489.505n 1.95v 1499.495n 1.95v 1499.505n 1.95v 1509.495n 1.95v 1509.505n 1.95v 1519.495n 1.95v 1519.505n 1.95v 1529.495n 1.95v 1529.505n 1.95v 1539.495n 1.95v 1539.505n 1.95v 1549.495n 1.95v 1549.505n 1.95v 1559.495n 1.95v 1559.505n 1.95v 1569.495n 1.95v 1569.505n 1.95v 1579.495n 1.95v 1579.505n 0.0v 1589.495n 0.0v 1589.505n 0.0v 1599.495n 0.0v 1599.505n 0.0v 1609.495n 0.0v 1609.505n 0.0v 1619.495n 0.0v 1619.505n 0.0v 1629.495n 0.0v 1629.505n 0.0v 1639.495n 0.0v 1639.505n 0.0v 1649.495n 0.0v 1649.505n 0.0v 1659.495n 0.0v 1659.505n 1.95v 1669.495n 1.95v 1669.505n 1.95v 1679.495n 1.95v 1679.505n 1.95v 1689.495n 1.95v 1689.505n 0.0v 1699.495n 0.0v 1699.505n 0.0v 1709.495n 0.0v 1709.505n 0.0v 1719.495n 0.0v 1719.505n 0.0v 1729.495n 0.0v 1729.505n 0.0v 1739.495n 0.0v 1739.505n 0.0v 1749.495n 0.0v 1749.505n 0.0v 1759.495n 0.0v 1759.505n 1.95v 1769.495n 1.95v 1769.505n 1.95v 1779.495n 1.95v 1779.505n 1.95v 1789.495n 1.95v 1789.505n 1.95v 1799.495n 1.95v 1799.505n 1.95v 1809.495n 1.95v 1809.505n 0.0v 1819.495n 0.0v 1819.505n 0.0v 1829.495n 0.0v 1829.505n 0.0v 1839.495n 0.0v 1839.505n 0.0v 1849.495n 0.0v 1849.505n 1.95v 1859.495n 1.95v 1859.505n 1.95v 1869.495n 1.95v 1869.505n 1.95v 1879.495n 1.95v 1879.505n 1.95v 1889.495n 1.95v 1889.505n 1.95v 1899.495n 1.95v 1899.505n 1.95v 1909.495n 1.95v 1909.505n 1.95v 1919.495n 1.95v 1919.505n 1.95v 1929.495n 1.95v 1929.505n 1.95v 1939.495n 1.95v 1939.505n 1.95v 1949.495n 1.95v 1949.505n 0.0v 1959.495n 0.0v 1959.505n 1.95v 1969.495n 1.95v 1969.505n 0.0v 1979.495n 0.0v 1979.505n 0.0v 1989.495n 0.0v 1989.505n 1.95v 1999.495n 1.95v 1999.505n 1.95v 2009.495n 1.95v 2009.505n 1.95v 2019.495n 1.95v 2019.505n 1.95v 2029.495n 1.95v 2029.505n 1.95v 2039.495n 1.95v 2039.505n 1.95v 2049.495n 1.95v 2049.505n 1.95v )
* (time, data): [(0, 0), (10, 1), (20, 0), (30, 1), (40, 1), (50, 1), (60, 0), (70, 0), (80, 0), (90, 0), (100, 0), (110, 0), (120, 0), (130, 0), (140, 0), (150, 0), (160, 1), (170, 1), (180, 1), (190, 1), (200, 1), (210, 1), (220, 1), (230, 1), (240, 1), (250, 1), (260, 1), (270, 1), (280, 1), (290, 1), (300, 0), (310, 0), (320, 0), (330, 0), (340, 0), (350, 0), (360, 0), (370, 1), (380, 1), (390, 1), (400, 1), (410, 1), (420, 1), (430, 1), (440, 1), (450, 1), (460, 1), (470, 1), (480, 1), (490, 1), (500, 0), (510, 1), (520, 1), (530, 1), (540, 1), (550, 1), (560, 1), (570, 1), (580, 1), (590, 0), (600, 0), (610, 0), (620, 0), (630, 0), (640, 0), (650, 1), (660, 1), (670, 0), (680, 0), (690, 0), (700, 0), (710, 0), (720, 0), (730, 0), (740, 0), (750, 1), (760, 1), (770, 1), (780, 0), (790, 0), (800, 0), (810, 0), (820, 0), (830, 0), (840, 0), (850, 1), (860, 1), (870, 1), (880, 1), (890, 1), (900, 1), (910, 1), (920, 1), (930, 1), (940, 0), (950, 1), (960, 1), (970, 0), (980, 1), (990, 0), (1000, 0), (1010, 1), (1020, 1), (1030, 0), (1040, 0), (1050, 0), (1060, 0), (1070, 0), (1080, 0), (1090, 0), (1100, 0), (1110, 1), (1120, 1), (1130, 1), (1140, 1), (1150, 0), (1160, 0), (1170, 0), (1180, 0), (1190, 0), (1200, 0), (1210, 1), (1220, 1), (1230, 0), (1240, 0), (1250, 0), (1260, 0), (1270, 0), (1280, 0), (1290, 1), (1300, 1), (1310, 1), (1320, 0), (1330, 0), (1340, 1), (1350, 1), (1360, 1), (1370, 1), (1380, 0), (1390, 0), (1400, 0), (1410, 0), (1420, 1), (1430, 1), (1440, 1), (1450, 1), (1460, 1), (1470, 1), (1480, 1), (1490, 1), (1500, 1), (1510, 1), (1520, 1), (1530, 1), (1540, 1), (1550, 0), (1560, 0), (1570, 0), (1580, 0), (1590, 0), (1600, 1), (1610, 1), (1620, 1), (1630, 1), (1640, 1), (1650, 1), (1660, 1), (1670, 1), (1680, 0), (1690, 0), (1700, 0), (1710, 0), (1720, 1), (1730, 0), (1740, 1), (1750, 1), (1760, 0), (1770, 0), (1780, 0), (1790, 0), (1800, 0), (1810, 1), (1820, 1), (1830, 1), (1840, 0), (1850, 1), (1860, 1), (1870, 1), (1880, 1), (1890, 1), (1900, 1), (1910, 1), (1920, 1), (1930, 1), (1940, 1), (1950, 0), (1960, 1), (1970, 0), (1980, 0), (1990, 0), (2000, 0), (2010, 0), (2020, 0), (2030, 0), (2040, 0), (2050, 0)]
Vdin0_31  din0_31  0 PWL (0n 0.0v 9.495n 0.0v 9.505n 1.95v 19.495n 1.95v 19.505n 0.0v 29.495n 0.0v 29.505n 1.95v 39.495n 1.95v 39.505n 1.95v 49.495n 1.95v 49.505n 1.95v 59.495n 1.95v 59.505n 0.0v 69.495n 0.0v 69.505n 0.0v 79.495n 0.0v 79.505n 0.0v 89.495n 0.0v 89.505n 0.0v 99.495n 0.0v 99.505n 0.0v 109.495n 0.0v 109.505n 0.0v 119.495n 0.0v 119.505n 0.0v 129.495n 0.0v 129.505n 0.0v 139.495n 0.0v 139.505n 0.0v 149.495n 0.0v 149.505n 0.0v 159.495n 0.0v 159.505n 1.95v 169.495n 1.95v 169.505n 1.95v 179.495n 1.95v 179.505n 1.95v 189.495n 1.95v 189.505n 1.95v 199.495n 1.95v 199.505n 1.95v 209.495n 1.95v 209.505n 1.95v 219.495n 1.95v 219.505n 1.95v 229.495n 1.95v 229.505n 1.95v 239.495n 1.95v 239.505n 1.95v 249.495n 1.95v 249.505n 1.95v 259.495n 1.95v 259.505n 1.95v 269.495n 1.95v 269.505n 1.95v 279.495n 1.95v 279.505n 1.95v 289.495n 1.95v 289.505n 1.95v 299.495n 1.95v 299.505n 0.0v 309.495n 0.0v 309.505n 0.0v 319.495n 0.0v 319.505n 0.0v 329.495n 0.0v 329.505n 0.0v 339.495n 0.0v 339.505n 0.0v 349.495n 0.0v 349.505n 0.0v 359.495n 0.0v 359.505n 0.0v 369.495n 0.0v 369.505n 1.95v 379.495n 1.95v 379.505n 1.95v 389.495n 1.95v 389.505n 1.95v 399.495n 1.95v 399.505n 1.95v 409.495n 1.95v 409.505n 1.95v 419.495n 1.95v 419.505n 1.95v 429.495n 1.95v 429.505n 1.95v 439.495n 1.95v 439.505n 1.95v 449.495n 1.95v 449.505n 1.95v 459.495n 1.95v 459.505n 1.95v 469.495n 1.95v 469.505n 1.95v 479.495n 1.95v 479.505n 1.95v 489.495n 1.95v 489.505n 1.95v 499.495n 1.95v 499.505n 0.0v 509.495n 0.0v 509.505n 1.95v 519.495n 1.95v 519.505n 1.95v 529.495n 1.95v 529.505n 1.95v 539.495n 1.95v 539.505n 1.95v 549.495n 1.95v 549.505n 1.95v 559.495n 1.95v 559.505n 1.95v 569.495n 1.95v 569.505n 1.95v 579.495n 1.95v 579.505n 1.95v 589.495n 1.95v 589.505n 0.0v 599.495n 0.0v 599.505n 0.0v 609.495n 0.0v 609.505n 0.0v 619.495n 0.0v 619.505n 0.0v 629.495n 0.0v 629.505n 0.0v 639.495n 0.0v 639.505n 0.0v 649.495n 0.0v 649.505n 1.95v 659.495n 1.95v 659.505n 1.95v 669.495n 1.95v 669.505n 0.0v 679.495n 0.0v 679.505n 0.0v 689.495n 0.0v 689.505n 0.0v 699.495n 0.0v 699.505n 0.0v 709.495n 0.0v 709.505n 0.0v 719.495n 0.0v 719.505n 0.0v 729.495n 0.0v 729.505n 0.0v 739.495n 0.0v 739.505n 0.0v 749.495n 0.0v 749.505n 1.95v 759.495n 1.95v 759.505n 1.95v 769.495n 1.95v 769.505n 1.95v 779.495n 1.95v 779.505n 0.0v 789.495n 0.0v 789.505n 0.0v 799.495n 0.0v 799.505n 0.0v 809.495n 0.0v 809.505n 0.0v 819.495n 0.0v 819.505n 0.0v 829.495n 0.0v 829.505n 0.0v 839.495n 0.0v 839.505n 0.0v 849.495n 0.0v 849.505n 1.95v 859.495n 1.95v 859.505n 1.95v 869.495n 1.95v 869.505n 1.95v 879.495n 1.95v 879.505n 1.95v 889.495n 1.95v 889.505n 1.95v 899.495n 1.95v 899.505n 1.95v 909.495n 1.95v 909.505n 1.95v 919.495n 1.95v 919.505n 1.95v 929.495n 1.95v 929.505n 1.95v 939.495n 1.95v 939.505n 0.0v 949.495n 0.0v 949.505n 1.95v 959.495n 1.95v 959.505n 1.95v 969.495n 1.95v 969.505n 0.0v 979.495n 0.0v 979.505n 1.95v 989.495n 1.95v 989.505n 0.0v 999.495n 0.0v 999.505n 0.0v 1009.495n 0.0v 1009.505n 1.95v 1019.495n 1.95v 1019.505n 1.95v 1029.495n 1.95v 1029.505n 0.0v 1039.495n 0.0v 1039.505n 0.0v 1049.495n 0.0v 1049.505n 0.0v 1059.495n 0.0v 1059.505n 0.0v 1069.495n 0.0v 1069.505n 0.0v 1079.495n 0.0v 1079.505n 0.0v 1089.495n 0.0v 1089.505n 0.0v 1099.495n 0.0v 1099.505n 0.0v 1109.495n 0.0v 1109.505n 1.95v 1119.495n 1.95v 1119.505n 1.95v 1129.495n 1.95v 1129.505n 1.95v 1139.495n 1.95v 1139.505n 1.95v 1149.495n 1.95v 1149.505n 0.0v 1159.495n 0.0v 1159.505n 0.0v 1169.495n 0.0v 1169.505n 0.0v 1179.495n 0.0v 1179.505n 0.0v 1189.495n 0.0v 1189.505n 0.0v 1199.495n 0.0v 1199.505n 0.0v 1209.495n 0.0v 1209.505n 1.95v 1219.495n 1.95v 1219.505n 1.95v 1229.495n 1.95v 1229.505n 0.0v 1239.495n 0.0v 1239.505n 0.0v 1249.495n 0.0v 1249.505n 0.0v 1259.495n 0.0v 1259.505n 0.0v 1269.495n 0.0v 1269.505n 0.0v 1279.495n 0.0v 1279.505n 0.0v 1289.495n 0.0v 1289.505n 1.95v 1299.495n 1.95v 1299.505n 1.95v 1309.495n 1.95v 1309.505n 1.95v 1319.495n 1.95v 1319.505n 0.0v 1329.495n 0.0v 1329.505n 0.0v 1339.495n 0.0v 1339.505n 1.95v 1349.495n 1.95v 1349.505n 1.95v 1359.495n 1.95v 1359.505n 1.95v 1369.495n 1.95v 1369.505n 1.95v 1379.495n 1.95v 1379.505n 0.0v 1389.495n 0.0v 1389.505n 0.0v 1399.495n 0.0v 1399.505n 0.0v 1409.495n 0.0v 1409.505n 0.0v 1419.495n 0.0v 1419.505n 1.95v 1429.495n 1.95v 1429.505n 1.95v 1439.495n 1.95v 1439.505n 1.95v 1449.495n 1.95v 1449.505n 1.95v 1459.495n 1.95v 1459.505n 1.95v 1469.495n 1.95v 1469.505n 1.95v 1479.495n 1.95v 1479.505n 1.95v 1489.495n 1.95v 1489.505n 1.95v 1499.495n 1.95v 1499.505n 1.95v 1509.495n 1.95v 1509.505n 1.95v 1519.495n 1.95v 1519.505n 1.95v 1529.495n 1.95v 1529.505n 1.95v 1539.495n 1.95v 1539.505n 1.95v 1549.495n 1.95v 1549.505n 0.0v 1559.495n 0.0v 1559.505n 0.0v 1569.495n 0.0v 1569.505n 0.0v 1579.495n 0.0v 1579.505n 0.0v 1589.495n 0.0v 1589.505n 0.0v 1599.495n 0.0v 1599.505n 1.95v 1609.495n 1.95v 1609.505n 1.95v 1619.495n 1.95v 1619.505n 1.95v 1629.495n 1.95v 1629.505n 1.95v 1639.495n 1.95v 1639.505n 1.95v 1649.495n 1.95v 1649.505n 1.95v 1659.495n 1.95v 1659.505n 1.95v 1669.495n 1.95v 1669.505n 1.95v 1679.495n 1.95v 1679.505n 0.0v 1689.495n 0.0v 1689.505n 0.0v 1699.495n 0.0v 1699.505n 0.0v 1709.495n 0.0v 1709.505n 0.0v 1719.495n 0.0v 1719.505n 1.95v 1729.495n 1.95v 1729.505n 0.0v 1739.495n 0.0v 1739.505n 1.95v 1749.495n 1.95v 1749.505n 1.95v 1759.495n 1.95v 1759.505n 0.0v 1769.495n 0.0v 1769.505n 0.0v 1779.495n 0.0v 1779.505n 0.0v 1789.495n 0.0v 1789.505n 0.0v 1799.495n 0.0v 1799.505n 0.0v 1809.495n 0.0v 1809.505n 1.95v 1819.495n 1.95v 1819.505n 1.95v 1829.495n 1.95v 1829.505n 1.95v 1839.495n 1.95v 1839.505n 0.0v 1849.495n 0.0v 1849.505n 1.95v 1859.495n 1.95v 1859.505n 1.95v 1869.495n 1.95v 1869.505n 1.95v 1879.495n 1.95v 1879.505n 1.95v 1889.495n 1.95v 1889.505n 1.95v 1899.495n 1.95v 1899.505n 1.95v 1909.495n 1.95v 1909.505n 1.95v 1919.495n 1.95v 1919.505n 1.95v 1929.495n 1.95v 1929.505n 1.95v 1939.495n 1.95v 1939.505n 1.95v 1949.495n 1.95v 1949.505n 0.0v 1959.495n 0.0v 1959.505n 1.95v 1969.495n 1.95v 1969.505n 0.0v 1979.495n 0.0v 1979.505n 0.0v 1989.495n 0.0v 1989.505n 0.0v 1999.495n 0.0v 1999.505n 0.0v 2009.495n 0.0v 2009.505n 0.0v 2019.495n 0.0v 2019.505n 0.0v 2029.495n 0.0v 2029.505n 0.0v 2039.495n 0.0v 2039.505n 0.0v 2049.495n 0.0v 2049.505n 0.0v )
* (time, data): [(0, 0), (10, 1), (20, 0), (30, 0), (40, 1), (50, 0), (60, 1), (70, 1), (80, 1), (90, 1), (100, 1), (110, 0), (120, 1), (130, 1), (140, 0), (150, 0), (160, 0), (170, 0), (180, 0), (190, 1), (200, 0), (210, 1), (220, 1), (230, 1), (240, 0), (250, 0), (260, 0), (270, 0), (280, 1), (290, 0), (300, 1), (310, 1), (320, 1), (330, 1), (340, 1), (350, 0), (360, 0), (370, 0), (380, 0), (390, 0), (400, 1), (410, 1), (420, 0), (430, 0), (440, 1), (450, 1), (460, 0), (470, 0), (480, 0), (490, 0), (500, 1), (510, 0), (520, 1), (530, 1), (540, 0), (550, 1), (560, 0), (570, 0), (580, 0), (590, 1), (600, 1), (610, 0), (620, 0), (630, 0), (640, 1), (650, 0), (660, 1), (670, 1), (680, 1), (690, 0), (700, 1), (710, 1), (720, 1), (730, 1), (740, 0), (750, 1), (760, 0), (770, 0), (780, 0), (790, 0), (800, 0), (810, 1), (820, 0), (830, 0), (840, 0), (850, 0), (860, 1), (870, 1), (880, 1), (890, 1), (900, 1), (910, 1), (920, 1), (930, 0), (940, 1), (950, 0), (960, 0), (970, 0), (980, 1), (990, 0), (1000, 1), (1010, 0), (1020, 1), (1030, 0), (1040, 0), (1050, 1), (1060, 1), (1070, 1), (1080, 1), (1090, 0), (1100, 0), (1110, 0), (1120, 0), (1130, 1), (1140, 0), (1150, 0), (1160, 1), (1170, 0), (1180, 0), (1190, 1), (1200, 1), (1210, 1), (1220, 1), (1230, 1), (1240, 1), (1250, 1), (1260, 1), (1270, 0), (1280, 0), (1290, 1), (1300, 1), (1310, 1), (1320, 0), (1330, 0), (1340, 1), (1350, 1), (1360, 1), (1370, 0), (1380, 0), (1390, 0), (1400, 0), (1410, 1), (1420, 0), (1430, 0), (1440, 0), (1450, 0), (1460, 1), (1470, 1), (1480, 0), (1490, 1), (1500, 0), (1510, 1), (1520, 1), (1530, 0), (1540, 0), (1550, 0), (1560, 0), (1570, 0), (1580, 0), (1590, 0), (1600, 0), (1610, 0), (1620, 1), (1630, 0), (1640, 0), (1650, 0), (1660, 0), (1670, 0), (1680, 0), (1690, 1), (1700, 0), (1710, 0), (1720, 0), (1730, 1), (1740, 0), (1750, 0), (1760, 0), (1770, 0), (1780, 0), (1790, 0), (1800, 0), (1810, 0), (1820, 1), (1830, 1), (1840, 1), (1850, 1), (1860, 0), (1870, 0), (1880, 0), (1890, 1), (1900, 0), (1910, 0), (1920, 0), (1930, 0), (1940, 1), (1950, 0), (1960, 1), (1970, 0), (1980, 0), (1990, 1), (2000, 1), (2010, 0), (2020, 1), (2030, 0), (2040, 1), (2050, 1)]
Va0_0  a0_0  0 PWL (0n 0.0v 9.495n 0.0v 9.505n 1.95v 19.495n 1.95v 19.505n 0.0v 29.495n 0.0v 29.505n 0.0v 39.495n 0.0v 39.505n 1.95v 49.495n 1.95v 49.505n 0.0v 59.495n 0.0v 59.505n 1.95v 69.495n 1.95v 69.505n 1.95v 79.495n 1.95v 79.505n 1.95v 89.495n 1.95v 89.505n 1.95v 99.495n 1.95v 99.505n 1.95v 109.495n 1.95v 109.505n 0.0v 119.495n 0.0v 119.505n 1.95v 129.495n 1.95v 129.505n 1.95v 139.495n 1.95v 139.505n 0.0v 149.495n 0.0v 149.505n 0.0v 159.495n 0.0v 159.505n 0.0v 169.495n 0.0v 169.505n 0.0v 179.495n 0.0v 179.505n 0.0v 189.495n 0.0v 189.505n 1.95v 199.495n 1.95v 199.505n 0.0v 209.495n 0.0v 209.505n 1.95v 219.495n 1.95v 219.505n 1.95v 229.495n 1.95v 229.505n 1.95v 239.495n 1.95v 239.505n 0.0v 249.495n 0.0v 249.505n 0.0v 259.495n 0.0v 259.505n 0.0v 269.495n 0.0v 269.505n 0.0v 279.495n 0.0v 279.505n 1.95v 289.495n 1.95v 289.505n 0.0v 299.495n 0.0v 299.505n 1.95v 309.495n 1.95v 309.505n 1.95v 319.495n 1.95v 319.505n 1.95v 329.495n 1.95v 329.505n 1.95v 339.495n 1.95v 339.505n 1.95v 349.495n 1.95v 349.505n 0.0v 359.495n 0.0v 359.505n 0.0v 369.495n 0.0v 369.505n 0.0v 379.495n 0.0v 379.505n 0.0v 389.495n 0.0v 389.505n 0.0v 399.495n 0.0v 399.505n 1.95v 409.495n 1.95v 409.505n 1.95v 419.495n 1.95v 419.505n 0.0v 429.495n 0.0v 429.505n 0.0v 439.495n 0.0v 439.505n 1.95v 449.495n 1.95v 449.505n 1.95v 459.495n 1.95v 459.505n 0.0v 469.495n 0.0v 469.505n 0.0v 479.495n 0.0v 479.505n 0.0v 489.495n 0.0v 489.505n 0.0v 499.495n 0.0v 499.505n 1.95v 509.495n 1.95v 509.505n 0.0v 519.495n 0.0v 519.505n 1.95v 529.495n 1.95v 529.505n 1.95v 539.495n 1.95v 539.505n 0.0v 549.495n 0.0v 549.505n 1.95v 559.495n 1.95v 559.505n 0.0v 569.495n 0.0v 569.505n 0.0v 579.495n 0.0v 579.505n 0.0v 589.495n 0.0v 589.505n 1.95v 599.495n 1.95v 599.505n 1.95v 609.495n 1.95v 609.505n 0.0v 619.495n 0.0v 619.505n 0.0v 629.495n 0.0v 629.505n 0.0v 639.495n 0.0v 639.505n 1.95v 649.495n 1.95v 649.505n 0.0v 659.495n 0.0v 659.505n 1.95v 669.495n 1.95v 669.505n 1.95v 679.495n 1.95v 679.505n 1.95v 689.495n 1.95v 689.505n 0.0v 699.495n 0.0v 699.505n 1.95v 709.495n 1.95v 709.505n 1.95v 719.495n 1.95v 719.505n 1.95v 729.495n 1.95v 729.505n 1.95v 739.495n 1.95v 739.505n 0.0v 749.495n 0.0v 749.505n 1.95v 759.495n 1.95v 759.505n 0.0v 769.495n 0.0v 769.505n 0.0v 779.495n 0.0v 779.505n 0.0v 789.495n 0.0v 789.505n 0.0v 799.495n 0.0v 799.505n 0.0v 809.495n 0.0v 809.505n 1.95v 819.495n 1.95v 819.505n 0.0v 829.495n 0.0v 829.505n 0.0v 839.495n 0.0v 839.505n 0.0v 849.495n 0.0v 849.505n 0.0v 859.495n 0.0v 859.505n 1.95v 869.495n 1.95v 869.505n 1.95v 879.495n 1.95v 879.505n 1.95v 889.495n 1.95v 889.505n 1.95v 899.495n 1.95v 899.505n 1.95v 909.495n 1.95v 909.505n 1.95v 919.495n 1.95v 919.505n 1.95v 929.495n 1.95v 929.505n 0.0v 939.495n 0.0v 939.505n 1.95v 949.495n 1.95v 949.505n 0.0v 959.495n 0.0v 959.505n 0.0v 969.495n 0.0v 969.505n 0.0v 979.495n 0.0v 979.505n 1.95v 989.495n 1.95v 989.505n 0.0v 999.495n 0.0v 999.505n 1.95v 1009.495n 1.95v 1009.505n 0.0v 1019.495n 0.0v 1019.505n 1.95v 1029.495n 1.95v 1029.505n 0.0v 1039.495n 0.0v 1039.505n 0.0v 1049.495n 0.0v 1049.505n 1.95v 1059.495n 1.95v 1059.505n 1.95v 1069.495n 1.95v 1069.505n 1.95v 1079.495n 1.95v 1079.505n 1.95v 1089.495n 1.95v 1089.505n 0.0v 1099.495n 0.0v 1099.505n 0.0v 1109.495n 0.0v 1109.505n 0.0v 1119.495n 0.0v 1119.505n 0.0v 1129.495n 0.0v 1129.505n 1.95v 1139.495n 1.95v 1139.505n 0.0v 1149.495n 0.0v 1149.505n 0.0v 1159.495n 0.0v 1159.505n 1.95v 1169.495n 1.95v 1169.505n 0.0v 1179.495n 0.0v 1179.505n 0.0v 1189.495n 0.0v 1189.505n 1.95v 1199.495n 1.95v 1199.505n 1.95v 1209.495n 1.95v 1209.505n 1.95v 1219.495n 1.95v 1219.505n 1.95v 1229.495n 1.95v 1229.505n 1.95v 1239.495n 1.95v 1239.505n 1.95v 1249.495n 1.95v 1249.505n 1.95v 1259.495n 1.95v 1259.505n 1.95v 1269.495n 1.95v 1269.505n 0.0v 1279.495n 0.0v 1279.505n 0.0v 1289.495n 0.0v 1289.505n 1.95v 1299.495n 1.95v 1299.505n 1.95v 1309.495n 1.95v 1309.505n 1.95v 1319.495n 1.95v 1319.505n 0.0v 1329.495n 0.0v 1329.505n 0.0v 1339.495n 0.0v 1339.505n 1.95v 1349.495n 1.95v 1349.505n 1.95v 1359.495n 1.95v 1359.505n 1.95v 1369.495n 1.95v 1369.505n 0.0v 1379.495n 0.0v 1379.505n 0.0v 1389.495n 0.0v 1389.505n 0.0v 1399.495n 0.0v 1399.505n 0.0v 1409.495n 0.0v 1409.505n 1.95v 1419.495n 1.95v 1419.505n 0.0v 1429.495n 0.0v 1429.505n 0.0v 1439.495n 0.0v 1439.505n 0.0v 1449.495n 0.0v 1449.505n 0.0v 1459.495n 0.0v 1459.505n 1.95v 1469.495n 1.95v 1469.505n 1.95v 1479.495n 1.95v 1479.505n 0.0v 1489.495n 0.0v 1489.505n 1.95v 1499.495n 1.95v 1499.505n 0.0v 1509.495n 0.0v 1509.505n 1.95v 1519.495n 1.95v 1519.505n 1.95v 1529.495n 1.95v 1529.505n 0.0v 1539.495n 0.0v 1539.505n 0.0v 1549.495n 0.0v 1549.505n 0.0v 1559.495n 0.0v 1559.505n 0.0v 1569.495n 0.0v 1569.505n 0.0v 1579.495n 0.0v 1579.505n 0.0v 1589.495n 0.0v 1589.505n 0.0v 1599.495n 0.0v 1599.505n 0.0v 1609.495n 0.0v 1609.505n 0.0v 1619.495n 0.0v 1619.505n 1.95v 1629.495n 1.95v 1629.505n 0.0v 1639.495n 0.0v 1639.505n 0.0v 1649.495n 0.0v 1649.505n 0.0v 1659.495n 0.0v 1659.505n 0.0v 1669.495n 0.0v 1669.505n 0.0v 1679.495n 0.0v 1679.505n 0.0v 1689.495n 0.0v 1689.505n 1.95v 1699.495n 1.95v 1699.505n 0.0v 1709.495n 0.0v 1709.505n 0.0v 1719.495n 0.0v 1719.505n 0.0v 1729.495n 0.0v 1729.505n 1.95v 1739.495n 1.95v 1739.505n 0.0v 1749.495n 0.0v 1749.505n 0.0v 1759.495n 0.0v 1759.505n 0.0v 1769.495n 0.0v 1769.505n 0.0v 1779.495n 0.0v 1779.505n 0.0v 1789.495n 0.0v 1789.505n 0.0v 1799.495n 0.0v 1799.505n 0.0v 1809.495n 0.0v 1809.505n 0.0v 1819.495n 0.0v 1819.505n 1.95v 1829.495n 1.95v 1829.505n 1.95v 1839.495n 1.95v 1839.505n 1.95v 1849.495n 1.95v 1849.505n 1.95v 1859.495n 1.95v 1859.505n 0.0v 1869.495n 0.0v 1869.505n 0.0v 1879.495n 0.0v 1879.505n 0.0v 1889.495n 0.0v 1889.505n 1.95v 1899.495n 1.95v 1899.505n 0.0v 1909.495n 0.0v 1909.505n 0.0v 1919.495n 0.0v 1919.505n 0.0v 1929.495n 0.0v 1929.505n 0.0v 1939.495n 0.0v 1939.505n 1.95v 1949.495n 1.95v 1949.505n 0.0v 1959.495n 0.0v 1959.505n 1.95v 1969.495n 1.95v 1969.505n 0.0v 1979.495n 0.0v 1979.505n 0.0v 1989.495n 0.0v 1989.505n 1.95v 1999.495n 1.95v 1999.505n 1.95v 2009.495n 1.95v 2009.505n 0.0v 2019.495n 0.0v 2019.505n 1.95v 2029.495n 1.95v 2029.505n 0.0v 2039.495n 0.0v 2039.505n 1.95v 2049.495n 1.95v 2049.505n 1.95v )
* (time, data): [(0, 0), (10, 0), (20, 0), (30, 0), (40, 0), (50, 0), (60, 0), (70, 0), (80, 0), (90, 0), (100, 0), (110, 0), (120, 0), (130, 0), (140, 0), (150, 0), (160, 0), (170, 0), (180, 0), (190, 0), (200, 0), (210, 0), (220, 0), (230, 0), (240, 0), (250, 0), (260, 0), (270, 0), (280, 0), (290, 0), (300, 0), (310, 0), (320, 0), (330, 0), (340, 0), (350, 0), (360, 0), (370, 0), (380, 0), (390, 0), (400, 0), (410, 0), (420, 1), (430, 1), (440, 0), (450, 0), (460, 0), (470, 1), (480, 1), (490, 0), (500, 0), (510, 0), (520, 0), (530, 0), (540, 1), (550, 0), (560, 1), (570, 1), (580, 1), (590, 0), (600, 0), (610, 1), (620, 1), (630, 1), (640, 0), (650, 0), (660, 0), (670, 0), (680, 0), (690, 1), (700, 0), (710, 0), (720, 0), (730, 0), (740, 0), (750, 0), (760, 0), (770, 0), (780, 1), (790, 0), (800, 0), (810, 0), (820, 1), (830, 0), (840, 0), (850, 0), (860, 0), (870, 0), (880, 0), (890, 0), (900, 0), (910, 0), (920, 0), (930, 0), (940, 0), (950, 1), (960, 1), (970, 1), (980, 0), (990, 1), (1000, 0), (1010, 1), (1020, 0), (1030, 1), (1040, 1), (1050, 0), (1060, 0), (1070, 0), (1080, 0), (1090, 0), (1100, 0), (1110, 0), (1120, 0), (1130, 0), (1140, 0), (1150, 0), (1160, 0), (1170, 1), (1180, 1), (1190, 0), (1200, 0), (1210, 0), (1220, 0), (1230, 0), (1240, 0), (1250, 0), (1260, 0), (1270, 1), (1280, 1), (1290, 0), (1300, 0), (1310, 0), (1320, 1), (1330, 0), (1340, 0), (1350, 0), (1360, 0), (1370, 1), (1380, 0), (1390, 1), (1400, 0), (1410, 0), (1420, 1), (1430, 1), (1440, 1), (1450, 0), (1460, 0), (1470, 0), (1480, 1), (1490, 0), (1500, 1), (1510, 0), (1520, 0), (1530, 0), (1540, 0), (1550, 0), (1560, 1), (1570, 1), (1580, 0), (1590, 1), (1600, 0), (1610, 1), (1620, 0), (1630, 0), (1640, 0), (1650, 1), (1660, 1), (1670, 1), (1680, 1), (1690, 0), (1700, 1), (1710, 1), (1720, 0), (1730, 0), (1740, 0), (1750, 0), (1760, 1), (1770, 1), (1780, 1), (1790, 1), (1800, 0), (1810, 0), (1820, 0), (1830, 0), (1840, 0), (1850, 0), (1860, 1), (1870, 1), (1880, 1), (1890, 0), (1900, 1), (1910, 1), (1920, 0), (1930, 0), (1940, 0), (1950, 1), (1960, 0), (1970, 0), (1980, 0), (1990, 0), (2000, 0), (2010, 1), (2020, 0), (2030, 1), (2040, 0), (2050, 0)]
Va0_1  a0_1  0 PWL (0n 0.0v 9.495n 0.0v 9.505n 0.0v 19.495n 0.0v 19.505n 0.0v 29.495n 0.0v 29.505n 0.0v 39.495n 0.0v 39.505n 0.0v 49.495n 0.0v 49.505n 0.0v 59.495n 0.0v 59.505n 0.0v 69.495n 0.0v 69.505n 0.0v 79.495n 0.0v 79.505n 0.0v 89.495n 0.0v 89.505n 0.0v 99.495n 0.0v 99.505n 0.0v 109.495n 0.0v 109.505n 0.0v 119.495n 0.0v 119.505n 0.0v 129.495n 0.0v 129.505n 0.0v 139.495n 0.0v 139.505n 0.0v 149.495n 0.0v 149.505n 0.0v 159.495n 0.0v 159.505n 0.0v 169.495n 0.0v 169.505n 0.0v 179.495n 0.0v 179.505n 0.0v 189.495n 0.0v 189.505n 0.0v 199.495n 0.0v 199.505n 0.0v 209.495n 0.0v 209.505n 0.0v 219.495n 0.0v 219.505n 0.0v 229.495n 0.0v 229.505n 0.0v 239.495n 0.0v 239.505n 0.0v 249.495n 0.0v 249.505n 0.0v 259.495n 0.0v 259.505n 0.0v 269.495n 0.0v 269.505n 0.0v 279.495n 0.0v 279.505n 0.0v 289.495n 0.0v 289.505n 0.0v 299.495n 0.0v 299.505n 0.0v 309.495n 0.0v 309.505n 0.0v 319.495n 0.0v 319.505n 0.0v 329.495n 0.0v 329.505n 0.0v 339.495n 0.0v 339.505n 0.0v 349.495n 0.0v 349.505n 0.0v 359.495n 0.0v 359.505n 0.0v 369.495n 0.0v 369.505n 0.0v 379.495n 0.0v 379.505n 0.0v 389.495n 0.0v 389.505n 0.0v 399.495n 0.0v 399.505n 0.0v 409.495n 0.0v 409.505n 0.0v 419.495n 0.0v 419.505n 1.95v 429.495n 1.95v 429.505n 1.95v 439.495n 1.95v 439.505n 0.0v 449.495n 0.0v 449.505n 0.0v 459.495n 0.0v 459.505n 0.0v 469.495n 0.0v 469.505n 1.95v 479.495n 1.95v 479.505n 1.95v 489.495n 1.95v 489.505n 0.0v 499.495n 0.0v 499.505n 0.0v 509.495n 0.0v 509.505n 0.0v 519.495n 0.0v 519.505n 0.0v 529.495n 0.0v 529.505n 0.0v 539.495n 0.0v 539.505n 1.95v 549.495n 1.95v 549.505n 0.0v 559.495n 0.0v 559.505n 1.95v 569.495n 1.95v 569.505n 1.95v 579.495n 1.95v 579.505n 1.95v 589.495n 1.95v 589.505n 0.0v 599.495n 0.0v 599.505n 0.0v 609.495n 0.0v 609.505n 1.95v 619.495n 1.95v 619.505n 1.95v 629.495n 1.95v 629.505n 1.95v 639.495n 1.95v 639.505n 0.0v 649.495n 0.0v 649.505n 0.0v 659.495n 0.0v 659.505n 0.0v 669.495n 0.0v 669.505n 0.0v 679.495n 0.0v 679.505n 0.0v 689.495n 0.0v 689.505n 1.95v 699.495n 1.95v 699.505n 0.0v 709.495n 0.0v 709.505n 0.0v 719.495n 0.0v 719.505n 0.0v 729.495n 0.0v 729.505n 0.0v 739.495n 0.0v 739.505n 0.0v 749.495n 0.0v 749.505n 0.0v 759.495n 0.0v 759.505n 0.0v 769.495n 0.0v 769.505n 0.0v 779.495n 0.0v 779.505n 1.95v 789.495n 1.95v 789.505n 0.0v 799.495n 0.0v 799.505n 0.0v 809.495n 0.0v 809.505n 0.0v 819.495n 0.0v 819.505n 1.95v 829.495n 1.95v 829.505n 0.0v 839.495n 0.0v 839.505n 0.0v 849.495n 0.0v 849.505n 0.0v 859.495n 0.0v 859.505n 0.0v 869.495n 0.0v 869.505n 0.0v 879.495n 0.0v 879.505n 0.0v 889.495n 0.0v 889.505n 0.0v 899.495n 0.0v 899.505n 0.0v 909.495n 0.0v 909.505n 0.0v 919.495n 0.0v 919.505n 0.0v 929.495n 0.0v 929.505n 0.0v 939.495n 0.0v 939.505n 0.0v 949.495n 0.0v 949.505n 1.95v 959.495n 1.95v 959.505n 1.95v 969.495n 1.95v 969.505n 1.95v 979.495n 1.95v 979.505n 0.0v 989.495n 0.0v 989.505n 1.95v 999.495n 1.95v 999.505n 0.0v 1009.495n 0.0v 1009.505n 1.95v 1019.495n 1.95v 1019.505n 0.0v 1029.495n 0.0v 1029.505n 1.95v 1039.495n 1.95v 1039.505n 1.95v 1049.495n 1.95v 1049.505n 0.0v 1059.495n 0.0v 1059.505n 0.0v 1069.495n 0.0v 1069.505n 0.0v 1079.495n 0.0v 1079.505n 0.0v 1089.495n 0.0v 1089.505n 0.0v 1099.495n 0.0v 1099.505n 0.0v 1109.495n 0.0v 1109.505n 0.0v 1119.495n 0.0v 1119.505n 0.0v 1129.495n 0.0v 1129.505n 0.0v 1139.495n 0.0v 1139.505n 0.0v 1149.495n 0.0v 1149.505n 0.0v 1159.495n 0.0v 1159.505n 0.0v 1169.495n 0.0v 1169.505n 1.95v 1179.495n 1.95v 1179.505n 1.95v 1189.495n 1.95v 1189.505n 0.0v 1199.495n 0.0v 1199.505n 0.0v 1209.495n 0.0v 1209.505n 0.0v 1219.495n 0.0v 1219.505n 0.0v 1229.495n 0.0v 1229.505n 0.0v 1239.495n 0.0v 1239.505n 0.0v 1249.495n 0.0v 1249.505n 0.0v 1259.495n 0.0v 1259.505n 0.0v 1269.495n 0.0v 1269.505n 1.95v 1279.495n 1.95v 1279.505n 1.95v 1289.495n 1.95v 1289.505n 0.0v 1299.495n 0.0v 1299.505n 0.0v 1309.495n 0.0v 1309.505n 0.0v 1319.495n 0.0v 1319.505n 1.95v 1329.495n 1.95v 1329.505n 0.0v 1339.495n 0.0v 1339.505n 0.0v 1349.495n 0.0v 1349.505n 0.0v 1359.495n 0.0v 1359.505n 0.0v 1369.495n 0.0v 1369.505n 1.95v 1379.495n 1.95v 1379.505n 0.0v 1389.495n 0.0v 1389.505n 1.95v 1399.495n 1.95v 1399.505n 0.0v 1409.495n 0.0v 1409.505n 0.0v 1419.495n 0.0v 1419.505n 1.95v 1429.495n 1.95v 1429.505n 1.95v 1439.495n 1.95v 1439.505n 1.95v 1449.495n 1.95v 1449.505n 0.0v 1459.495n 0.0v 1459.505n 0.0v 1469.495n 0.0v 1469.505n 0.0v 1479.495n 0.0v 1479.505n 1.95v 1489.495n 1.95v 1489.505n 0.0v 1499.495n 0.0v 1499.505n 1.95v 1509.495n 1.95v 1509.505n 0.0v 1519.495n 0.0v 1519.505n 0.0v 1529.495n 0.0v 1529.505n 0.0v 1539.495n 0.0v 1539.505n 0.0v 1549.495n 0.0v 1549.505n 0.0v 1559.495n 0.0v 1559.505n 1.95v 1569.495n 1.95v 1569.505n 1.95v 1579.495n 1.95v 1579.505n 0.0v 1589.495n 0.0v 1589.505n 1.95v 1599.495n 1.95v 1599.505n 0.0v 1609.495n 0.0v 1609.505n 1.95v 1619.495n 1.95v 1619.505n 0.0v 1629.495n 0.0v 1629.505n 0.0v 1639.495n 0.0v 1639.505n 0.0v 1649.495n 0.0v 1649.505n 1.95v 1659.495n 1.95v 1659.505n 1.95v 1669.495n 1.95v 1669.505n 1.95v 1679.495n 1.95v 1679.505n 1.95v 1689.495n 1.95v 1689.505n 0.0v 1699.495n 0.0v 1699.505n 1.95v 1709.495n 1.95v 1709.505n 1.95v 1719.495n 1.95v 1719.505n 0.0v 1729.495n 0.0v 1729.505n 0.0v 1739.495n 0.0v 1739.505n 0.0v 1749.495n 0.0v 1749.505n 0.0v 1759.495n 0.0v 1759.505n 1.95v 1769.495n 1.95v 1769.505n 1.95v 1779.495n 1.95v 1779.505n 1.95v 1789.495n 1.95v 1789.505n 1.95v 1799.495n 1.95v 1799.505n 0.0v 1809.495n 0.0v 1809.505n 0.0v 1819.495n 0.0v 1819.505n 0.0v 1829.495n 0.0v 1829.505n 0.0v 1839.495n 0.0v 1839.505n 0.0v 1849.495n 0.0v 1849.505n 0.0v 1859.495n 0.0v 1859.505n 1.95v 1869.495n 1.95v 1869.505n 1.95v 1879.495n 1.95v 1879.505n 1.95v 1889.495n 1.95v 1889.505n 0.0v 1899.495n 0.0v 1899.505n 1.95v 1909.495n 1.95v 1909.505n 1.95v 1919.495n 1.95v 1919.505n 0.0v 1929.495n 0.0v 1929.505n 0.0v 1939.495n 0.0v 1939.505n 0.0v 1949.495n 0.0v 1949.505n 1.95v 1959.495n 1.95v 1959.505n 0.0v 1969.495n 0.0v 1969.505n 0.0v 1979.495n 0.0v 1979.505n 0.0v 1989.495n 0.0v 1989.505n 0.0v 1999.495n 0.0v 1999.505n 0.0v 2009.495n 0.0v 2009.505n 1.95v 2019.495n 1.95v 2019.505n 0.0v 2029.495n 0.0v 2029.505n 1.95v 2039.495n 1.95v 2039.505n 0.0v 2049.495n 0.0v 2049.505n 0.0v )
* (time, data): [(0, 0), (10, 0), (20, 0), (30, 0), (40, 0), (50, 0), (60, 0), (70, 0), (80, 0), (90, 0), (100, 0), (110, 0), (120, 0), (130, 0), (140, 0), (150, 0), (160, 0), (170, 0), (180, 0), (190, 0), (200, 0), (210, 0), (220, 0), (230, 0), (240, 0), (250, 0), (260, 0), (270, 0), (280, 0), (290, 0), (300, 0), (310, 0), (320, 0), (330, 0), (340, 0), (350, 0), (360, 0), (370, 0), (380, 0), (390, 0), (400, 1), (410, 1), (420, 1), (430, 1), (440, 1), (450, 1), (460, 0), (470, 1), (480, 1), (490, 0), (500, 0), (510, 0), (520, 0), (530, 0), (540, 1), (550, 1), (560, 1), (570, 1), (580, 1), (590, 0), (600, 1), (610, 1), (620, 1), (630, 1), (640, 1), (650, 0), (660, 1), (670, 0), (680, 0), (690, 1), (700, 0), (710, 0), (720, 0), (730, 1), (740, 0), (750, 1), (760, 0), (770, 0), (780, 1), (790, 0), (800, 0), (810, 1), (820, 1), (830, 0), (840, 0), (850, 0), (860, 0), (870, 0), (880, 1), (890, 0), (900, 0), (910, 0), (920, 0), (930, 0), (940, 0), (950, 1), (960, 1), (970, 1), (980, 0), (990, 1), (1000, 1), (1010, 1), (1020, 1), (1030, 1), (1040, 1), (1050, 1), (1060, 1), (1070, 0), (1080, 0), (1090, 0), (1100, 0), (1110, 0), (1120, 0), (1130, 1), (1140, 0), (1150, 0), (1160, 1), (1170, 1), (1180, 1), (1190, 1), (1200, 1), (1210, 1), (1220, 1), (1230, 1), (1240, 0), (1250, 1), (1260, 1), (1270, 1), (1280, 1), (1290, 1), (1300, 1), (1310, 1), (1320, 1), (1330, 0), (1340, 0), (1350, 1), (1360, 1), (1370, 1), (1380, 0), (1390, 1), (1400, 0), (1410, 1), (1420, 1), (1430, 1), (1440, 1), (1450, 0), (1460, 1), (1470, 1), (1480, 1), (1490, 1), (1500, 1), (1510, 1), (1520, 1), (1530, 0), (1540, 0), (1550, 0), (1560, 1), (1570, 1), (1580, 0), (1590, 1), (1600, 0), (1610, 1), (1620, 0), (1630, 0), (1640, 0), (1650, 1), (1660, 1), (1670, 1), (1680, 1), (1690, 1), (1700, 1), (1710, 1), (1720, 0), (1730, 1), (1740, 0), (1750, 0), (1760, 1), (1770, 1), (1780, 1), (1790, 1), (1800, 0), (1810, 0), (1820, 0), (1830, 0), (1840, 1), (1850, 0), (1860, 1), (1870, 1), (1880, 1), (1890, 0), (1900, 1), (1910, 1), (1920, 0), (1930, 0), (1940, 1), (1950, 1), (1960, 0), (1970, 0), (1980, 0), (1990, 0), (2000, 1), (2010, 1), (2020, 1), (2030, 1), (2040, 1), (2050, 1)]
Va0_2  a0_2  0 PWL (0n 0.0v 9.495n 0.0v 9.505n 0.0v 19.495n 0.0v 19.505n 0.0v 29.495n 0.0v 29.505n 0.0v 39.495n 0.0v 39.505n 0.0v 49.495n 0.0v 49.505n 0.0v 59.495n 0.0v 59.505n 0.0v 69.495n 0.0v 69.505n 0.0v 79.495n 0.0v 79.505n 0.0v 89.495n 0.0v 89.505n 0.0v 99.495n 0.0v 99.505n 0.0v 109.495n 0.0v 109.505n 0.0v 119.495n 0.0v 119.505n 0.0v 129.495n 0.0v 129.505n 0.0v 139.495n 0.0v 139.505n 0.0v 149.495n 0.0v 149.505n 0.0v 159.495n 0.0v 159.505n 0.0v 169.495n 0.0v 169.505n 0.0v 179.495n 0.0v 179.505n 0.0v 189.495n 0.0v 189.505n 0.0v 199.495n 0.0v 199.505n 0.0v 209.495n 0.0v 209.505n 0.0v 219.495n 0.0v 219.505n 0.0v 229.495n 0.0v 229.505n 0.0v 239.495n 0.0v 239.505n 0.0v 249.495n 0.0v 249.505n 0.0v 259.495n 0.0v 259.505n 0.0v 269.495n 0.0v 269.505n 0.0v 279.495n 0.0v 279.505n 0.0v 289.495n 0.0v 289.505n 0.0v 299.495n 0.0v 299.505n 0.0v 309.495n 0.0v 309.505n 0.0v 319.495n 0.0v 319.505n 0.0v 329.495n 0.0v 329.505n 0.0v 339.495n 0.0v 339.505n 0.0v 349.495n 0.0v 349.505n 0.0v 359.495n 0.0v 359.505n 0.0v 369.495n 0.0v 369.505n 0.0v 379.495n 0.0v 379.505n 0.0v 389.495n 0.0v 389.505n 0.0v 399.495n 0.0v 399.505n 1.95v 409.495n 1.95v 409.505n 1.95v 419.495n 1.95v 419.505n 1.95v 429.495n 1.95v 429.505n 1.95v 439.495n 1.95v 439.505n 1.95v 449.495n 1.95v 449.505n 1.95v 459.495n 1.95v 459.505n 0.0v 469.495n 0.0v 469.505n 1.95v 479.495n 1.95v 479.505n 1.95v 489.495n 1.95v 489.505n 0.0v 499.495n 0.0v 499.505n 0.0v 509.495n 0.0v 509.505n 0.0v 519.495n 0.0v 519.505n 0.0v 529.495n 0.0v 529.505n 0.0v 539.495n 0.0v 539.505n 1.95v 549.495n 1.95v 549.505n 1.95v 559.495n 1.95v 559.505n 1.95v 569.495n 1.95v 569.505n 1.95v 579.495n 1.95v 579.505n 1.95v 589.495n 1.95v 589.505n 0.0v 599.495n 0.0v 599.505n 1.95v 609.495n 1.95v 609.505n 1.95v 619.495n 1.95v 619.505n 1.95v 629.495n 1.95v 629.505n 1.95v 639.495n 1.95v 639.505n 1.95v 649.495n 1.95v 649.505n 0.0v 659.495n 0.0v 659.505n 1.95v 669.495n 1.95v 669.505n 0.0v 679.495n 0.0v 679.505n 0.0v 689.495n 0.0v 689.505n 1.95v 699.495n 1.95v 699.505n 0.0v 709.495n 0.0v 709.505n 0.0v 719.495n 0.0v 719.505n 0.0v 729.495n 0.0v 729.505n 1.95v 739.495n 1.95v 739.505n 0.0v 749.495n 0.0v 749.505n 1.95v 759.495n 1.95v 759.505n 0.0v 769.495n 0.0v 769.505n 0.0v 779.495n 0.0v 779.505n 1.95v 789.495n 1.95v 789.505n 0.0v 799.495n 0.0v 799.505n 0.0v 809.495n 0.0v 809.505n 1.95v 819.495n 1.95v 819.505n 1.95v 829.495n 1.95v 829.505n 0.0v 839.495n 0.0v 839.505n 0.0v 849.495n 0.0v 849.505n 0.0v 859.495n 0.0v 859.505n 0.0v 869.495n 0.0v 869.505n 0.0v 879.495n 0.0v 879.505n 1.95v 889.495n 1.95v 889.505n 0.0v 899.495n 0.0v 899.505n 0.0v 909.495n 0.0v 909.505n 0.0v 919.495n 0.0v 919.505n 0.0v 929.495n 0.0v 929.505n 0.0v 939.495n 0.0v 939.505n 0.0v 949.495n 0.0v 949.505n 1.95v 959.495n 1.95v 959.505n 1.95v 969.495n 1.95v 969.505n 1.95v 979.495n 1.95v 979.505n 0.0v 989.495n 0.0v 989.505n 1.95v 999.495n 1.95v 999.505n 1.95v 1009.495n 1.95v 1009.505n 1.95v 1019.495n 1.95v 1019.505n 1.95v 1029.495n 1.95v 1029.505n 1.95v 1039.495n 1.95v 1039.505n 1.95v 1049.495n 1.95v 1049.505n 1.95v 1059.495n 1.95v 1059.505n 1.95v 1069.495n 1.95v 1069.505n 0.0v 1079.495n 0.0v 1079.505n 0.0v 1089.495n 0.0v 1089.505n 0.0v 1099.495n 0.0v 1099.505n 0.0v 1109.495n 0.0v 1109.505n 0.0v 1119.495n 0.0v 1119.505n 0.0v 1129.495n 0.0v 1129.505n 1.95v 1139.495n 1.95v 1139.505n 0.0v 1149.495n 0.0v 1149.505n 0.0v 1159.495n 0.0v 1159.505n 1.95v 1169.495n 1.95v 1169.505n 1.95v 1179.495n 1.95v 1179.505n 1.95v 1189.495n 1.95v 1189.505n 1.95v 1199.495n 1.95v 1199.505n 1.95v 1209.495n 1.95v 1209.505n 1.95v 1219.495n 1.95v 1219.505n 1.95v 1229.495n 1.95v 1229.505n 1.95v 1239.495n 1.95v 1239.505n 0.0v 1249.495n 0.0v 1249.505n 1.95v 1259.495n 1.95v 1259.505n 1.95v 1269.495n 1.95v 1269.505n 1.95v 1279.495n 1.95v 1279.505n 1.95v 1289.495n 1.95v 1289.505n 1.95v 1299.495n 1.95v 1299.505n 1.95v 1309.495n 1.95v 1309.505n 1.95v 1319.495n 1.95v 1319.505n 1.95v 1329.495n 1.95v 1329.505n 0.0v 1339.495n 0.0v 1339.505n 0.0v 1349.495n 0.0v 1349.505n 1.95v 1359.495n 1.95v 1359.505n 1.95v 1369.495n 1.95v 1369.505n 1.95v 1379.495n 1.95v 1379.505n 0.0v 1389.495n 0.0v 1389.505n 1.95v 1399.495n 1.95v 1399.505n 0.0v 1409.495n 0.0v 1409.505n 1.95v 1419.495n 1.95v 1419.505n 1.95v 1429.495n 1.95v 1429.505n 1.95v 1439.495n 1.95v 1439.505n 1.95v 1449.495n 1.95v 1449.505n 0.0v 1459.495n 0.0v 1459.505n 1.95v 1469.495n 1.95v 1469.505n 1.95v 1479.495n 1.95v 1479.505n 1.95v 1489.495n 1.95v 1489.505n 1.95v 1499.495n 1.95v 1499.505n 1.95v 1509.495n 1.95v 1509.505n 1.95v 1519.495n 1.95v 1519.505n 1.95v 1529.495n 1.95v 1529.505n 0.0v 1539.495n 0.0v 1539.505n 0.0v 1549.495n 0.0v 1549.505n 0.0v 1559.495n 0.0v 1559.505n 1.95v 1569.495n 1.95v 1569.505n 1.95v 1579.495n 1.95v 1579.505n 0.0v 1589.495n 0.0v 1589.505n 1.95v 1599.495n 1.95v 1599.505n 0.0v 1609.495n 0.0v 1609.505n 1.95v 1619.495n 1.95v 1619.505n 0.0v 1629.495n 0.0v 1629.505n 0.0v 1639.495n 0.0v 1639.505n 0.0v 1649.495n 0.0v 1649.505n 1.95v 1659.495n 1.95v 1659.505n 1.95v 1669.495n 1.95v 1669.505n 1.95v 1679.495n 1.95v 1679.505n 1.95v 1689.495n 1.95v 1689.505n 1.95v 1699.495n 1.95v 1699.505n 1.95v 1709.495n 1.95v 1709.505n 1.95v 1719.495n 1.95v 1719.505n 0.0v 1729.495n 0.0v 1729.505n 1.95v 1739.495n 1.95v 1739.505n 0.0v 1749.495n 0.0v 1749.505n 0.0v 1759.495n 0.0v 1759.505n 1.95v 1769.495n 1.95v 1769.505n 1.95v 1779.495n 1.95v 1779.505n 1.95v 1789.495n 1.95v 1789.505n 1.95v 1799.495n 1.95v 1799.505n 0.0v 1809.495n 0.0v 1809.505n 0.0v 1819.495n 0.0v 1819.505n 0.0v 1829.495n 0.0v 1829.505n 0.0v 1839.495n 0.0v 1839.505n 1.95v 1849.495n 1.95v 1849.505n 0.0v 1859.495n 0.0v 1859.505n 1.95v 1869.495n 1.95v 1869.505n 1.95v 1879.495n 1.95v 1879.505n 1.95v 1889.495n 1.95v 1889.505n 0.0v 1899.495n 0.0v 1899.505n 1.95v 1909.495n 1.95v 1909.505n 1.95v 1919.495n 1.95v 1919.505n 0.0v 1929.495n 0.0v 1929.505n 0.0v 1939.495n 0.0v 1939.505n 1.95v 1949.495n 1.95v 1949.505n 1.95v 1959.495n 1.95v 1959.505n 0.0v 1969.495n 0.0v 1969.505n 0.0v 1979.495n 0.0v 1979.505n 0.0v 1989.495n 0.0v 1989.505n 0.0v 1999.495n 0.0v 1999.505n 1.95v 2009.495n 1.95v 2009.505n 1.95v 2019.495n 1.95v 2019.505n 1.95v 2029.495n 1.95v 2029.505n 1.95v 2039.495n 1.95v 2039.505n 1.95v 2049.495n 1.95v 2049.505n 1.95v )
* (time, data): [(0, 0), (10, 0), (20, 0), (30, 0), (40, 0), (50, 0), (60, 0), (70, 0), (80, 0), (90, 0), (100, 0), (110, 0), (120, 0), (130, 0), (140, 0), (150, 0), (160, 0), (170, 0), (180, 0), (190, 0), (200, 0), (210, 0), (220, 0), (230, 0), (240, 0), (250, 0), (260, 0), (270, 0), (280, 0), (290, 0), (300, 0), (310, 0), (320, 0), (330, 0), (340, 0), (350, 0), (360, 0), (370, 0), (380, 0), (390, 0), (400, 1), (410, 1), (420, 1), (430, 1), (440, 1), (450, 1), (460, 0), (470, 1), (480, 1), (490, 0), (500, 0), (510, 0), (520, 0), (530, 0), (540, 1), (550, 1), (560, 1), (570, 1), (580, 1), (590, 0), (600, 1), (610, 1), (620, 1), (630, 1), (640, 1), (650, 0), (660, 1), (670, 0), (680, 0), (690, 1), (700, 0), (710, 0), (720, 0), (730, 1), (740, 0), (750, 1), (760, 0), (770, 0), (780, 1), (790, 0), (800, 0), (810, 1), (820, 1), (830, 0), (840, 0), (850, 0), (860, 0), (870, 0), (880, 1), (890, 0), (900, 0), (910, 0), (920, 0), (930, 0), (940, 0), (950, 1), (960, 1), (970, 1), (980, 0), (990, 1), (1000, 1), (1010, 1), (1020, 1), (1030, 1), (1040, 1), (1050, 1), (1060, 1), (1070, 0), (1080, 0), (1090, 0), (1100, 0), (1110, 0), (1120, 0), (1130, 1), (1140, 0), (1150, 0), (1160, 1), (1170, 1), (1180, 1), (1190, 1), (1200, 1), (1210, 1), (1220, 1), (1230, 1), (1240, 0), (1250, 1), (1260, 1), (1270, 1), (1280, 1), (1290, 1), (1300, 1), (1310, 1), (1320, 1), (1330, 0), (1340, 0), (1350, 1), (1360, 1), (1370, 1), (1380, 0), (1390, 1), (1400, 0), (1410, 1), (1420, 1), (1430, 1), (1440, 1), (1450, 0), (1460, 1), (1470, 1), (1480, 1), (1490, 1), (1500, 1), (1510, 1), (1520, 1), (1530, 0), (1540, 0), (1550, 0), (1560, 1), (1570, 1), (1580, 0), (1590, 1), (1600, 0), (1610, 1), (1620, 0), (1630, 0), (1640, 0), (1650, 1), (1660, 1), (1670, 1), (1680, 1), (1690, 1), (1700, 1), (1710, 1), (1720, 0), (1730, 1), (1740, 0), (1750, 0), (1760, 1), (1770, 1), (1780, 1), (1790, 1), (1800, 0), (1810, 0), (1820, 0), (1830, 0), (1840, 1), (1850, 0), (1860, 1), (1870, 1), (1880, 1), (1890, 0), (1900, 1), (1910, 1), (1920, 0), (1930, 0), (1940, 1), (1950, 1), (1960, 0), (1970, 0), (1980, 0), (1990, 0), (2000, 1), (2010, 1), (2020, 1), (2030, 1), (2040, 1), (2050, 1)]
Va0_3  a0_3  0 PWL (0n 0.0v 9.495n 0.0v 9.505n 0.0v 19.495n 0.0v 19.505n 0.0v 29.495n 0.0v 29.505n 0.0v 39.495n 0.0v 39.505n 0.0v 49.495n 0.0v 49.505n 0.0v 59.495n 0.0v 59.505n 0.0v 69.495n 0.0v 69.505n 0.0v 79.495n 0.0v 79.505n 0.0v 89.495n 0.0v 89.505n 0.0v 99.495n 0.0v 99.505n 0.0v 109.495n 0.0v 109.505n 0.0v 119.495n 0.0v 119.505n 0.0v 129.495n 0.0v 129.505n 0.0v 139.495n 0.0v 139.505n 0.0v 149.495n 0.0v 149.505n 0.0v 159.495n 0.0v 159.505n 0.0v 169.495n 0.0v 169.505n 0.0v 179.495n 0.0v 179.505n 0.0v 189.495n 0.0v 189.505n 0.0v 199.495n 0.0v 199.505n 0.0v 209.495n 0.0v 209.505n 0.0v 219.495n 0.0v 219.505n 0.0v 229.495n 0.0v 229.505n 0.0v 239.495n 0.0v 239.505n 0.0v 249.495n 0.0v 249.505n 0.0v 259.495n 0.0v 259.505n 0.0v 269.495n 0.0v 269.505n 0.0v 279.495n 0.0v 279.505n 0.0v 289.495n 0.0v 289.505n 0.0v 299.495n 0.0v 299.505n 0.0v 309.495n 0.0v 309.505n 0.0v 319.495n 0.0v 319.505n 0.0v 329.495n 0.0v 329.505n 0.0v 339.495n 0.0v 339.505n 0.0v 349.495n 0.0v 349.505n 0.0v 359.495n 0.0v 359.505n 0.0v 369.495n 0.0v 369.505n 0.0v 379.495n 0.0v 379.505n 0.0v 389.495n 0.0v 389.505n 0.0v 399.495n 0.0v 399.505n 1.95v 409.495n 1.95v 409.505n 1.95v 419.495n 1.95v 419.505n 1.95v 429.495n 1.95v 429.505n 1.95v 439.495n 1.95v 439.505n 1.95v 449.495n 1.95v 449.505n 1.95v 459.495n 1.95v 459.505n 0.0v 469.495n 0.0v 469.505n 1.95v 479.495n 1.95v 479.505n 1.95v 489.495n 1.95v 489.505n 0.0v 499.495n 0.0v 499.505n 0.0v 509.495n 0.0v 509.505n 0.0v 519.495n 0.0v 519.505n 0.0v 529.495n 0.0v 529.505n 0.0v 539.495n 0.0v 539.505n 1.95v 549.495n 1.95v 549.505n 1.95v 559.495n 1.95v 559.505n 1.95v 569.495n 1.95v 569.505n 1.95v 579.495n 1.95v 579.505n 1.95v 589.495n 1.95v 589.505n 0.0v 599.495n 0.0v 599.505n 1.95v 609.495n 1.95v 609.505n 1.95v 619.495n 1.95v 619.505n 1.95v 629.495n 1.95v 629.505n 1.95v 639.495n 1.95v 639.505n 1.95v 649.495n 1.95v 649.505n 0.0v 659.495n 0.0v 659.505n 1.95v 669.495n 1.95v 669.505n 0.0v 679.495n 0.0v 679.505n 0.0v 689.495n 0.0v 689.505n 1.95v 699.495n 1.95v 699.505n 0.0v 709.495n 0.0v 709.505n 0.0v 719.495n 0.0v 719.505n 0.0v 729.495n 0.0v 729.505n 1.95v 739.495n 1.95v 739.505n 0.0v 749.495n 0.0v 749.505n 1.95v 759.495n 1.95v 759.505n 0.0v 769.495n 0.0v 769.505n 0.0v 779.495n 0.0v 779.505n 1.95v 789.495n 1.95v 789.505n 0.0v 799.495n 0.0v 799.505n 0.0v 809.495n 0.0v 809.505n 1.95v 819.495n 1.95v 819.505n 1.95v 829.495n 1.95v 829.505n 0.0v 839.495n 0.0v 839.505n 0.0v 849.495n 0.0v 849.505n 0.0v 859.495n 0.0v 859.505n 0.0v 869.495n 0.0v 869.505n 0.0v 879.495n 0.0v 879.505n 1.95v 889.495n 1.95v 889.505n 0.0v 899.495n 0.0v 899.505n 0.0v 909.495n 0.0v 909.505n 0.0v 919.495n 0.0v 919.505n 0.0v 929.495n 0.0v 929.505n 0.0v 939.495n 0.0v 939.505n 0.0v 949.495n 0.0v 949.505n 1.95v 959.495n 1.95v 959.505n 1.95v 969.495n 1.95v 969.505n 1.95v 979.495n 1.95v 979.505n 0.0v 989.495n 0.0v 989.505n 1.95v 999.495n 1.95v 999.505n 1.95v 1009.495n 1.95v 1009.505n 1.95v 1019.495n 1.95v 1019.505n 1.95v 1029.495n 1.95v 1029.505n 1.95v 1039.495n 1.95v 1039.505n 1.95v 1049.495n 1.95v 1049.505n 1.95v 1059.495n 1.95v 1059.505n 1.95v 1069.495n 1.95v 1069.505n 0.0v 1079.495n 0.0v 1079.505n 0.0v 1089.495n 0.0v 1089.505n 0.0v 1099.495n 0.0v 1099.505n 0.0v 1109.495n 0.0v 1109.505n 0.0v 1119.495n 0.0v 1119.505n 0.0v 1129.495n 0.0v 1129.505n 1.95v 1139.495n 1.95v 1139.505n 0.0v 1149.495n 0.0v 1149.505n 0.0v 1159.495n 0.0v 1159.505n 1.95v 1169.495n 1.95v 1169.505n 1.95v 1179.495n 1.95v 1179.505n 1.95v 1189.495n 1.95v 1189.505n 1.95v 1199.495n 1.95v 1199.505n 1.95v 1209.495n 1.95v 1209.505n 1.95v 1219.495n 1.95v 1219.505n 1.95v 1229.495n 1.95v 1229.505n 1.95v 1239.495n 1.95v 1239.505n 0.0v 1249.495n 0.0v 1249.505n 1.95v 1259.495n 1.95v 1259.505n 1.95v 1269.495n 1.95v 1269.505n 1.95v 1279.495n 1.95v 1279.505n 1.95v 1289.495n 1.95v 1289.505n 1.95v 1299.495n 1.95v 1299.505n 1.95v 1309.495n 1.95v 1309.505n 1.95v 1319.495n 1.95v 1319.505n 1.95v 1329.495n 1.95v 1329.505n 0.0v 1339.495n 0.0v 1339.505n 0.0v 1349.495n 0.0v 1349.505n 1.95v 1359.495n 1.95v 1359.505n 1.95v 1369.495n 1.95v 1369.505n 1.95v 1379.495n 1.95v 1379.505n 0.0v 1389.495n 0.0v 1389.505n 1.95v 1399.495n 1.95v 1399.505n 0.0v 1409.495n 0.0v 1409.505n 1.95v 1419.495n 1.95v 1419.505n 1.95v 1429.495n 1.95v 1429.505n 1.95v 1439.495n 1.95v 1439.505n 1.95v 1449.495n 1.95v 1449.505n 0.0v 1459.495n 0.0v 1459.505n 1.95v 1469.495n 1.95v 1469.505n 1.95v 1479.495n 1.95v 1479.505n 1.95v 1489.495n 1.95v 1489.505n 1.95v 1499.495n 1.95v 1499.505n 1.95v 1509.495n 1.95v 1509.505n 1.95v 1519.495n 1.95v 1519.505n 1.95v 1529.495n 1.95v 1529.505n 0.0v 1539.495n 0.0v 1539.505n 0.0v 1549.495n 0.0v 1549.505n 0.0v 1559.495n 0.0v 1559.505n 1.95v 1569.495n 1.95v 1569.505n 1.95v 1579.495n 1.95v 1579.505n 0.0v 1589.495n 0.0v 1589.505n 1.95v 1599.495n 1.95v 1599.505n 0.0v 1609.495n 0.0v 1609.505n 1.95v 1619.495n 1.95v 1619.505n 0.0v 1629.495n 0.0v 1629.505n 0.0v 1639.495n 0.0v 1639.505n 0.0v 1649.495n 0.0v 1649.505n 1.95v 1659.495n 1.95v 1659.505n 1.95v 1669.495n 1.95v 1669.505n 1.95v 1679.495n 1.95v 1679.505n 1.95v 1689.495n 1.95v 1689.505n 1.95v 1699.495n 1.95v 1699.505n 1.95v 1709.495n 1.95v 1709.505n 1.95v 1719.495n 1.95v 1719.505n 0.0v 1729.495n 0.0v 1729.505n 1.95v 1739.495n 1.95v 1739.505n 0.0v 1749.495n 0.0v 1749.505n 0.0v 1759.495n 0.0v 1759.505n 1.95v 1769.495n 1.95v 1769.505n 1.95v 1779.495n 1.95v 1779.505n 1.95v 1789.495n 1.95v 1789.505n 1.95v 1799.495n 1.95v 1799.505n 0.0v 1809.495n 0.0v 1809.505n 0.0v 1819.495n 0.0v 1819.505n 0.0v 1829.495n 0.0v 1829.505n 0.0v 1839.495n 0.0v 1839.505n 1.95v 1849.495n 1.95v 1849.505n 0.0v 1859.495n 0.0v 1859.505n 1.95v 1869.495n 1.95v 1869.505n 1.95v 1879.495n 1.95v 1879.505n 1.95v 1889.495n 1.95v 1889.505n 0.0v 1899.495n 0.0v 1899.505n 1.95v 1909.495n 1.95v 1909.505n 1.95v 1919.495n 1.95v 1919.505n 0.0v 1929.495n 0.0v 1929.505n 0.0v 1939.495n 0.0v 1939.505n 1.95v 1949.495n 1.95v 1949.505n 1.95v 1959.495n 1.95v 1959.505n 0.0v 1969.495n 0.0v 1969.505n 0.0v 1979.495n 0.0v 1979.505n 0.0v 1989.495n 0.0v 1989.505n 0.0v 1999.495n 0.0v 1999.505n 1.95v 2009.495n 1.95v 2009.505n 1.95v 2019.495n 1.95v 2019.505n 1.95v 2029.495n 1.95v 2029.505n 1.95v 2039.495n 1.95v 2039.505n 1.95v 2049.495n 1.95v 2049.505n 1.95v )
* (time, data): [(0, 0), (10, 0), (20, 0), (30, 0), (40, 0), (50, 0), (60, 0), (70, 0), (80, 0), (90, 0), (100, 0), (110, 0), (120, 0), (130, 0), (140, 0), (150, 0), (160, 0), (170, 0), (180, 0), (190, 0), (200, 0), (210, 0), (220, 0), (230, 0), (240, 0), (250, 0), (260, 0), (270, 0), (280, 0), (290, 0), (300, 0), (310, 0), (320, 0), (330, 0), (340, 0), (350, 0), (360, 0), (370, 0), (380, 0), (390, 0), (400, 1), (410, 1), (420, 1), (430, 1), (440, 1), (450, 1), (460, 0), (470, 1), (480, 1), (490, 0), (500, 0), (510, 0), (520, 0), (530, 0), (540, 1), (550, 1), (560, 1), (570, 1), (580, 1), (590, 0), (600, 1), (610, 1), (620, 1), (630, 1), (640, 1), (650, 0), (660, 1), (670, 0), (680, 0), (690, 1), (700, 0), (710, 0), (720, 0), (730, 1), (740, 0), (750, 1), (760, 0), (770, 0), (780, 1), (790, 0), (800, 0), (810, 1), (820, 1), (830, 0), (840, 0), (850, 0), (860, 0), (870, 0), (880, 1), (890, 0), (900, 0), (910, 0), (920, 0), (930, 0), (940, 0), (950, 1), (960, 1), (970, 1), (980, 0), (990, 1), (1000, 1), (1010, 1), (1020, 1), (1030, 1), (1040, 1), (1050, 1), (1060, 1), (1070, 0), (1080, 0), (1090, 0), (1100, 0), (1110, 0), (1120, 0), (1130, 1), (1140, 0), (1150, 0), (1160, 1), (1170, 1), (1180, 1), (1190, 1), (1200, 1), (1210, 1), (1220, 1), (1230, 1), (1240, 0), (1250, 1), (1260, 1), (1270, 1), (1280, 1), (1290, 1), (1300, 1), (1310, 1), (1320, 1), (1330, 0), (1340, 0), (1350, 1), (1360, 1), (1370, 1), (1380, 0), (1390, 1), (1400, 0), (1410, 1), (1420, 1), (1430, 1), (1440, 1), (1450, 0), (1460, 1), (1470, 1), (1480, 1), (1490, 1), (1500, 1), (1510, 1), (1520, 1), (1530, 0), (1540, 0), (1550, 0), (1560, 1), (1570, 1), (1580, 0), (1590, 1), (1600, 0), (1610, 1), (1620, 0), (1630, 0), (1640, 0), (1650, 1), (1660, 1), (1670, 1), (1680, 1), (1690, 1), (1700, 1), (1710, 1), (1720, 0), (1730, 1), (1740, 0), (1750, 0), (1760, 1), (1770, 1), (1780, 1), (1790, 1), (1800, 0), (1810, 0), (1820, 0), (1830, 0), (1840, 1), (1850, 0), (1860, 1), (1870, 1), (1880, 1), (1890, 0), (1900, 1), (1910, 1), (1920, 0), (1930, 0), (1940, 1), (1950, 1), (1960, 0), (1970, 0), (1980, 0), (1990, 0), (2000, 1), (2010, 1), (2020, 1), (2030, 1), (2040, 1), (2050, 1)]
Va0_4  a0_4  0 PWL (0n 0.0v 9.495n 0.0v 9.505n 0.0v 19.495n 0.0v 19.505n 0.0v 29.495n 0.0v 29.505n 0.0v 39.495n 0.0v 39.505n 0.0v 49.495n 0.0v 49.505n 0.0v 59.495n 0.0v 59.505n 0.0v 69.495n 0.0v 69.505n 0.0v 79.495n 0.0v 79.505n 0.0v 89.495n 0.0v 89.505n 0.0v 99.495n 0.0v 99.505n 0.0v 109.495n 0.0v 109.505n 0.0v 119.495n 0.0v 119.505n 0.0v 129.495n 0.0v 129.505n 0.0v 139.495n 0.0v 139.505n 0.0v 149.495n 0.0v 149.505n 0.0v 159.495n 0.0v 159.505n 0.0v 169.495n 0.0v 169.505n 0.0v 179.495n 0.0v 179.505n 0.0v 189.495n 0.0v 189.505n 0.0v 199.495n 0.0v 199.505n 0.0v 209.495n 0.0v 209.505n 0.0v 219.495n 0.0v 219.505n 0.0v 229.495n 0.0v 229.505n 0.0v 239.495n 0.0v 239.505n 0.0v 249.495n 0.0v 249.505n 0.0v 259.495n 0.0v 259.505n 0.0v 269.495n 0.0v 269.505n 0.0v 279.495n 0.0v 279.505n 0.0v 289.495n 0.0v 289.505n 0.0v 299.495n 0.0v 299.505n 0.0v 309.495n 0.0v 309.505n 0.0v 319.495n 0.0v 319.505n 0.0v 329.495n 0.0v 329.505n 0.0v 339.495n 0.0v 339.505n 0.0v 349.495n 0.0v 349.505n 0.0v 359.495n 0.0v 359.505n 0.0v 369.495n 0.0v 369.505n 0.0v 379.495n 0.0v 379.505n 0.0v 389.495n 0.0v 389.505n 0.0v 399.495n 0.0v 399.505n 1.95v 409.495n 1.95v 409.505n 1.95v 419.495n 1.95v 419.505n 1.95v 429.495n 1.95v 429.505n 1.95v 439.495n 1.95v 439.505n 1.95v 449.495n 1.95v 449.505n 1.95v 459.495n 1.95v 459.505n 0.0v 469.495n 0.0v 469.505n 1.95v 479.495n 1.95v 479.505n 1.95v 489.495n 1.95v 489.505n 0.0v 499.495n 0.0v 499.505n 0.0v 509.495n 0.0v 509.505n 0.0v 519.495n 0.0v 519.505n 0.0v 529.495n 0.0v 529.505n 0.0v 539.495n 0.0v 539.505n 1.95v 549.495n 1.95v 549.505n 1.95v 559.495n 1.95v 559.505n 1.95v 569.495n 1.95v 569.505n 1.95v 579.495n 1.95v 579.505n 1.95v 589.495n 1.95v 589.505n 0.0v 599.495n 0.0v 599.505n 1.95v 609.495n 1.95v 609.505n 1.95v 619.495n 1.95v 619.505n 1.95v 629.495n 1.95v 629.505n 1.95v 639.495n 1.95v 639.505n 1.95v 649.495n 1.95v 649.505n 0.0v 659.495n 0.0v 659.505n 1.95v 669.495n 1.95v 669.505n 0.0v 679.495n 0.0v 679.505n 0.0v 689.495n 0.0v 689.505n 1.95v 699.495n 1.95v 699.505n 0.0v 709.495n 0.0v 709.505n 0.0v 719.495n 0.0v 719.505n 0.0v 729.495n 0.0v 729.505n 1.95v 739.495n 1.95v 739.505n 0.0v 749.495n 0.0v 749.505n 1.95v 759.495n 1.95v 759.505n 0.0v 769.495n 0.0v 769.505n 0.0v 779.495n 0.0v 779.505n 1.95v 789.495n 1.95v 789.505n 0.0v 799.495n 0.0v 799.505n 0.0v 809.495n 0.0v 809.505n 1.95v 819.495n 1.95v 819.505n 1.95v 829.495n 1.95v 829.505n 0.0v 839.495n 0.0v 839.505n 0.0v 849.495n 0.0v 849.505n 0.0v 859.495n 0.0v 859.505n 0.0v 869.495n 0.0v 869.505n 0.0v 879.495n 0.0v 879.505n 1.95v 889.495n 1.95v 889.505n 0.0v 899.495n 0.0v 899.505n 0.0v 909.495n 0.0v 909.505n 0.0v 919.495n 0.0v 919.505n 0.0v 929.495n 0.0v 929.505n 0.0v 939.495n 0.0v 939.505n 0.0v 949.495n 0.0v 949.505n 1.95v 959.495n 1.95v 959.505n 1.95v 969.495n 1.95v 969.505n 1.95v 979.495n 1.95v 979.505n 0.0v 989.495n 0.0v 989.505n 1.95v 999.495n 1.95v 999.505n 1.95v 1009.495n 1.95v 1009.505n 1.95v 1019.495n 1.95v 1019.505n 1.95v 1029.495n 1.95v 1029.505n 1.95v 1039.495n 1.95v 1039.505n 1.95v 1049.495n 1.95v 1049.505n 1.95v 1059.495n 1.95v 1059.505n 1.95v 1069.495n 1.95v 1069.505n 0.0v 1079.495n 0.0v 1079.505n 0.0v 1089.495n 0.0v 1089.505n 0.0v 1099.495n 0.0v 1099.505n 0.0v 1109.495n 0.0v 1109.505n 0.0v 1119.495n 0.0v 1119.505n 0.0v 1129.495n 0.0v 1129.505n 1.95v 1139.495n 1.95v 1139.505n 0.0v 1149.495n 0.0v 1149.505n 0.0v 1159.495n 0.0v 1159.505n 1.95v 1169.495n 1.95v 1169.505n 1.95v 1179.495n 1.95v 1179.505n 1.95v 1189.495n 1.95v 1189.505n 1.95v 1199.495n 1.95v 1199.505n 1.95v 1209.495n 1.95v 1209.505n 1.95v 1219.495n 1.95v 1219.505n 1.95v 1229.495n 1.95v 1229.505n 1.95v 1239.495n 1.95v 1239.505n 0.0v 1249.495n 0.0v 1249.505n 1.95v 1259.495n 1.95v 1259.505n 1.95v 1269.495n 1.95v 1269.505n 1.95v 1279.495n 1.95v 1279.505n 1.95v 1289.495n 1.95v 1289.505n 1.95v 1299.495n 1.95v 1299.505n 1.95v 1309.495n 1.95v 1309.505n 1.95v 1319.495n 1.95v 1319.505n 1.95v 1329.495n 1.95v 1329.505n 0.0v 1339.495n 0.0v 1339.505n 0.0v 1349.495n 0.0v 1349.505n 1.95v 1359.495n 1.95v 1359.505n 1.95v 1369.495n 1.95v 1369.505n 1.95v 1379.495n 1.95v 1379.505n 0.0v 1389.495n 0.0v 1389.505n 1.95v 1399.495n 1.95v 1399.505n 0.0v 1409.495n 0.0v 1409.505n 1.95v 1419.495n 1.95v 1419.505n 1.95v 1429.495n 1.95v 1429.505n 1.95v 1439.495n 1.95v 1439.505n 1.95v 1449.495n 1.95v 1449.505n 0.0v 1459.495n 0.0v 1459.505n 1.95v 1469.495n 1.95v 1469.505n 1.95v 1479.495n 1.95v 1479.505n 1.95v 1489.495n 1.95v 1489.505n 1.95v 1499.495n 1.95v 1499.505n 1.95v 1509.495n 1.95v 1509.505n 1.95v 1519.495n 1.95v 1519.505n 1.95v 1529.495n 1.95v 1529.505n 0.0v 1539.495n 0.0v 1539.505n 0.0v 1549.495n 0.0v 1549.505n 0.0v 1559.495n 0.0v 1559.505n 1.95v 1569.495n 1.95v 1569.505n 1.95v 1579.495n 1.95v 1579.505n 0.0v 1589.495n 0.0v 1589.505n 1.95v 1599.495n 1.95v 1599.505n 0.0v 1609.495n 0.0v 1609.505n 1.95v 1619.495n 1.95v 1619.505n 0.0v 1629.495n 0.0v 1629.505n 0.0v 1639.495n 0.0v 1639.505n 0.0v 1649.495n 0.0v 1649.505n 1.95v 1659.495n 1.95v 1659.505n 1.95v 1669.495n 1.95v 1669.505n 1.95v 1679.495n 1.95v 1679.505n 1.95v 1689.495n 1.95v 1689.505n 1.95v 1699.495n 1.95v 1699.505n 1.95v 1709.495n 1.95v 1709.505n 1.95v 1719.495n 1.95v 1719.505n 0.0v 1729.495n 0.0v 1729.505n 1.95v 1739.495n 1.95v 1739.505n 0.0v 1749.495n 0.0v 1749.505n 0.0v 1759.495n 0.0v 1759.505n 1.95v 1769.495n 1.95v 1769.505n 1.95v 1779.495n 1.95v 1779.505n 1.95v 1789.495n 1.95v 1789.505n 1.95v 1799.495n 1.95v 1799.505n 0.0v 1809.495n 0.0v 1809.505n 0.0v 1819.495n 0.0v 1819.505n 0.0v 1829.495n 0.0v 1829.505n 0.0v 1839.495n 0.0v 1839.505n 1.95v 1849.495n 1.95v 1849.505n 0.0v 1859.495n 0.0v 1859.505n 1.95v 1869.495n 1.95v 1869.505n 1.95v 1879.495n 1.95v 1879.505n 1.95v 1889.495n 1.95v 1889.505n 0.0v 1899.495n 0.0v 1899.505n 1.95v 1909.495n 1.95v 1909.505n 1.95v 1919.495n 1.95v 1919.505n 0.0v 1929.495n 0.0v 1929.505n 0.0v 1939.495n 0.0v 1939.505n 1.95v 1949.495n 1.95v 1949.505n 1.95v 1959.495n 1.95v 1959.505n 0.0v 1969.495n 0.0v 1969.505n 0.0v 1979.495n 0.0v 1979.505n 0.0v 1989.495n 0.0v 1989.505n 0.0v 1999.495n 0.0v 1999.505n 1.95v 2009.495n 1.95v 2009.505n 1.95v 2019.495n 1.95v 2019.505n 1.95v 2029.495n 1.95v 2029.505n 1.95v 2039.495n 1.95v 2039.505n 1.95v 2049.495n 1.95v 2049.505n 1.95v )
* (time, data): [(0, 0), (10, 0), (20, 0), (30, 0), (40, 0), (50, 0), (60, 0), (70, 0), (80, 0), (90, 0), (100, 0), (110, 0), (120, 0), (130, 0), (140, 0), (150, 0), (160, 0), (170, 0), (180, 0), (190, 0), (200, 0), (210, 0), (220, 0), (230, 0), (240, 0), (250, 0), (260, 0), (270, 0), (280, 0), (290, 0), (300, 0), (310, 0), (320, 0), (330, 0), (340, 0), (350, 0), (360, 0), (370, 0), (380, 0), (390, 0), (400, 1), (410, 1), (420, 1), (430, 1), (440, 1), (450, 1), (460, 0), (470, 1), (480, 1), (490, 0), (500, 0), (510, 0), (520, 0), (530, 0), (540, 1), (550, 1), (560, 1), (570, 1), (580, 1), (590, 0), (600, 1), (610, 1), (620, 1), (630, 1), (640, 1), (650, 0), (660, 1), (670, 0), (680, 0), (690, 1), (700, 0), (710, 0), (720, 0), (730, 1), (740, 0), (750, 1), (760, 0), (770, 0), (780, 1), (790, 0), (800, 0), (810, 1), (820, 1), (830, 0), (840, 0), (850, 0), (860, 0), (870, 0), (880, 1), (890, 0), (900, 0), (910, 0), (920, 0), (930, 0), (940, 0), (950, 1), (960, 1), (970, 1), (980, 0), (990, 1), (1000, 1), (1010, 1), (1020, 1), (1030, 1), (1040, 1), (1050, 1), (1060, 1), (1070, 0), (1080, 0), (1090, 0), (1100, 0), (1110, 0), (1120, 0), (1130, 1), (1140, 0), (1150, 0), (1160, 1), (1170, 1), (1180, 1), (1190, 1), (1200, 1), (1210, 1), (1220, 1), (1230, 1), (1240, 0), (1250, 1), (1260, 1), (1270, 1), (1280, 1), (1290, 1), (1300, 1), (1310, 1), (1320, 1), (1330, 0), (1340, 0), (1350, 1), (1360, 1), (1370, 1), (1380, 0), (1390, 1), (1400, 0), (1410, 1), (1420, 1), (1430, 1), (1440, 1), (1450, 0), (1460, 1), (1470, 1), (1480, 1), (1490, 1), (1500, 1), (1510, 1), (1520, 1), (1530, 0), (1540, 0), (1550, 0), (1560, 1), (1570, 1), (1580, 0), (1590, 1), (1600, 0), (1610, 1), (1620, 0), (1630, 0), (1640, 0), (1650, 1), (1660, 1), (1670, 1), (1680, 1), (1690, 1), (1700, 1), (1710, 1), (1720, 0), (1730, 1), (1740, 0), (1750, 0), (1760, 1), (1770, 1), (1780, 1), (1790, 1), (1800, 0), (1810, 0), (1820, 0), (1830, 0), (1840, 1), (1850, 0), (1860, 1), (1870, 1), (1880, 1), (1890, 0), (1900, 1), (1910, 1), (1920, 0), (1930, 0), (1940, 1), (1950, 1), (1960, 0), (1970, 0), (1980, 0), (1990, 0), (2000, 1), (2010, 1), (2020, 1), (2030, 1), (2040, 1), (2050, 1)]
Va0_5  a0_5  0 PWL (0n 0.0v 9.495n 0.0v 9.505n 0.0v 19.495n 0.0v 19.505n 0.0v 29.495n 0.0v 29.505n 0.0v 39.495n 0.0v 39.505n 0.0v 49.495n 0.0v 49.505n 0.0v 59.495n 0.0v 59.505n 0.0v 69.495n 0.0v 69.505n 0.0v 79.495n 0.0v 79.505n 0.0v 89.495n 0.0v 89.505n 0.0v 99.495n 0.0v 99.505n 0.0v 109.495n 0.0v 109.505n 0.0v 119.495n 0.0v 119.505n 0.0v 129.495n 0.0v 129.505n 0.0v 139.495n 0.0v 139.505n 0.0v 149.495n 0.0v 149.505n 0.0v 159.495n 0.0v 159.505n 0.0v 169.495n 0.0v 169.505n 0.0v 179.495n 0.0v 179.505n 0.0v 189.495n 0.0v 189.505n 0.0v 199.495n 0.0v 199.505n 0.0v 209.495n 0.0v 209.505n 0.0v 219.495n 0.0v 219.505n 0.0v 229.495n 0.0v 229.505n 0.0v 239.495n 0.0v 239.505n 0.0v 249.495n 0.0v 249.505n 0.0v 259.495n 0.0v 259.505n 0.0v 269.495n 0.0v 269.505n 0.0v 279.495n 0.0v 279.505n 0.0v 289.495n 0.0v 289.505n 0.0v 299.495n 0.0v 299.505n 0.0v 309.495n 0.0v 309.505n 0.0v 319.495n 0.0v 319.505n 0.0v 329.495n 0.0v 329.505n 0.0v 339.495n 0.0v 339.505n 0.0v 349.495n 0.0v 349.505n 0.0v 359.495n 0.0v 359.505n 0.0v 369.495n 0.0v 369.505n 0.0v 379.495n 0.0v 379.505n 0.0v 389.495n 0.0v 389.505n 0.0v 399.495n 0.0v 399.505n 1.95v 409.495n 1.95v 409.505n 1.95v 419.495n 1.95v 419.505n 1.95v 429.495n 1.95v 429.505n 1.95v 439.495n 1.95v 439.505n 1.95v 449.495n 1.95v 449.505n 1.95v 459.495n 1.95v 459.505n 0.0v 469.495n 0.0v 469.505n 1.95v 479.495n 1.95v 479.505n 1.95v 489.495n 1.95v 489.505n 0.0v 499.495n 0.0v 499.505n 0.0v 509.495n 0.0v 509.505n 0.0v 519.495n 0.0v 519.505n 0.0v 529.495n 0.0v 529.505n 0.0v 539.495n 0.0v 539.505n 1.95v 549.495n 1.95v 549.505n 1.95v 559.495n 1.95v 559.505n 1.95v 569.495n 1.95v 569.505n 1.95v 579.495n 1.95v 579.505n 1.95v 589.495n 1.95v 589.505n 0.0v 599.495n 0.0v 599.505n 1.95v 609.495n 1.95v 609.505n 1.95v 619.495n 1.95v 619.505n 1.95v 629.495n 1.95v 629.505n 1.95v 639.495n 1.95v 639.505n 1.95v 649.495n 1.95v 649.505n 0.0v 659.495n 0.0v 659.505n 1.95v 669.495n 1.95v 669.505n 0.0v 679.495n 0.0v 679.505n 0.0v 689.495n 0.0v 689.505n 1.95v 699.495n 1.95v 699.505n 0.0v 709.495n 0.0v 709.505n 0.0v 719.495n 0.0v 719.505n 0.0v 729.495n 0.0v 729.505n 1.95v 739.495n 1.95v 739.505n 0.0v 749.495n 0.0v 749.505n 1.95v 759.495n 1.95v 759.505n 0.0v 769.495n 0.0v 769.505n 0.0v 779.495n 0.0v 779.505n 1.95v 789.495n 1.95v 789.505n 0.0v 799.495n 0.0v 799.505n 0.0v 809.495n 0.0v 809.505n 1.95v 819.495n 1.95v 819.505n 1.95v 829.495n 1.95v 829.505n 0.0v 839.495n 0.0v 839.505n 0.0v 849.495n 0.0v 849.505n 0.0v 859.495n 0.0v 859.505n 0.0v 869.495n 0.0v 869.505n 0.0v 879.495n 0.0v 879.505n 1.95v 889.495n 1.95v 889.505n 0.0v 899.495n 0.0v 899.505n 0.0v 909.495n 0.0v 909.505n 0.0v 919.495n 0.0v 919.505n 0.0v 929.495n 0.0v 929.505n 0.0v 939.495n 0.0v 939.505n 0.0v 949.495n 0.0v 949.505n 1.95v 959.495n 1.95v 959.505n 1.95v 969.495n 1.95v 969.505n 1.95v 979.495n 1.95v 979.505n 0.0v 989.495n 0.0v 989.505n 1.95v 999.495n 1.95v 999.505n 1.95v 1009.495n 1.95v 1009.505n 1.95v 1019.495n 1.95v 1019.505n 1.95v 1029.495n 1.95v 1029.505n 1.95v 1039.495n 1.95v 1039.505n 1.95v 1049.495n 1.95v 1049.505n 1.95v 1059.495n 1.95v 1059.505n 1.95v 1069.495n 1.95v 1069.505n 0.0v 1079.495n 0.0v 1079.505n 0.0v 1089.495n 0.0v 1089.505n 0.0v 1099.495n 0.0v 1099.505n 0.0v 1109.495n 0.0v 1109.505n 0.0v 1119.495n 0.0v 1119.505n 0.0v 1129.495n 0.0v 1129.505n 1.95v 1139.495n 1.95v 1139.505n 0.0v 1149.495n 0.0v 1149.505n 0.0v 1159.495n 0.0v 1159.505n 1.95v 1169.495n 1.95v 1169.505n 1.95v 1179.495n 1.95v 1179.505n 1.95v 1189.495n 1.95v 1189.505n 1.95v 1199.495n 1.95v 1199.505n 1.95v 1209.495n 1.95v 1209.505n 1.95v 1219.495n 1.95v 1219.505n 1.95v 1229.495n 1.95v 1229.505n 1.95v 1239.495n 1.95v 1239.505n 0.0v 1249.495n 0.0v 1249.505n 1.95v 1259.495n 1.95v 1259.505n 1.95v 1269.495n 1.95v 1269.505n 1.95v 1279.495n 1.95v 1279.505n 1.95v 1289.495n 1.95v 1289.505n 1.95v 1299.495n 1.95v 1299.505n 1.95v 1309.495n 1.95v 1309.505n 1.95v 1319.495n 1.95v 1319.505n 1.95v 1329.495n 1.95v 1329.505n 0.0v 1339.495n 0.0v 1339.505n 0.0v 1349.495n 0.0v 1349.505n 1.95v 1359.495n 1.95v 1359.505n 1.95v 1369.495n 1.95v 1369.505n 1.95v 1379.495n 1.95v 1379.505n 0.0v 1389.495n 0.0v 1389.505n 1.95v 1399.495n 1.95v 1399.505n 0.0v 1409.495n 0.0v 1409.505n 1.95v 1419.495n 1.95v 1419.505n 1.95v 1429.495n 1.95v 1429.505n 1.95v 1439.495n 1.95v 1439.505n 1.95v 1449.495n 1.95v 1449.505n 0.0v 1459.495n 0.0v 1459.505n 1.95v 1469.495n 1.95v 1469.505n 1.95v 1479.495n 1.95v 1479.505n 1.95v 1489.495n 1.95v 1489.505n 1.95v 1499.495n 1.95v 1499.505n 1.95v 1509.495n 1.95v 1509.505n 1.95v 1519.495n 1.95v 1519.505n 1.95v 1529.495n 1.95v 1529.505n 0.0v 1539.495n 0.0v 1539.505n 0.0v 1549.495n 0.0v 1549.505n 0.0v 1559.495n 0.0v 1559.505n 1.95v 1569.495n 1.95v 1569.505n 1.95v 1579.495n 1.95v 1579.505n 0.0v 1589.495n 0.0v 1589.505n 1.95v 1599.495n 1.95v 1599.505n 0.0v 1609.495n 0.0v 1609.505n 1.95v 1619.495n 1.95v 1619.505n 0.0v 1629.495n 0.0v 1629.505n 0.0v 1639.495n 0.0v 1639.505n 0.0v 1649.495n 0.0v 1649.505n 1.95v 1659.495n 1.95v 1659.505n 1.95v 1669.495n 1.95v 1669.505n 1.95v 1679.495n 1.95v 1679.505n 1.95v 1689.495n 1.95v 1689.505n 1.95v 1699.495n 1.95v 1699.505n 1.95v 1709.495n 1.95v 1709.505n 1.95v 1719.495n 1.95v 1719.505n 0.0v 1729.495n 0.0v 1729.505n 1.95v 1739.495n 1.95v 1739.505n 0.0v 1749.495n 0.0v 1749.505n 0.0v 1759.495n 0.0v 1759.505n 1.95v 1769.495n 1.95v 1769.505n 1.95v 1779.495n 1.95v 1779.505n 1.95v 1789.495n 1.95v 1789.505n 1.95v 1799.495n 1.95v 1799.505n 0.0v 1809.495n 0.0v 1809.505n 0.0v 1819.495n 0.0v 1819.505n 0.0v 1829.495n 0.0v 1829.505n 0.0v 1839.495n 0.0v 1839.505n 1.95v 1849.495n 1.95v 1849.505n 0.0v 1859.495n 0.0v 1859.505n 1.95v 1869.495n 1.95v 1869.505n 1.95v 1879.495n 1.95v 1879.505n 1.95v 1889.495n 1.95v 1889.505n 0.0v 1899.495n 0.0v 1899.505n 1.95v 1909.495n 1.95v 1909.505n 1.95v 1919.495n 1.95v 1919.505n 0.0v 1929.495n 0.0v 1929.505n 0.0v 1939.495n 0.0v 1939.505n 1.95v 1949.495n 1.95v 1949.505n 1.95v 1959.495n 1.95v 1959.505n 0.0v 1969.495n 0.0v 1969.505n 0.0v 1979.495n 0.0v 1979.505n 0.0v 1989.495n 0.0v 1989.505n 0.0v 1999.495n 0.0v 1999.505n 1.95v 2009.495n 1.95v 2009.505n 1.95v 2019.495n 1.95v 2019.505n 1.95v 2029.495n 1.95v 2029.505n 1.95v 2039.495n 1.95v 2039.505n 1.95v 2049.495n 1.95v 2049.505n 1.95v )
* (time, data): [(0, 0), (10, 0), (20, 0), (30, 0), (40, 1), (50, 1), (60, 1), (70, 1), (80, 1), (90, 1), (100, 1), (110, 1), (120, 1), (130, 0), (140, 1), (150, 1), (160, 1), (170, 0), (180, 1), (190, 1), (200, 1), (210, 0), (220, 0), (230, 0), (240, 0), (250, 0), (260, 0), (270, 0), (280, 0), (290, 0), (300, 0), (310, 0), (320, 0), (330, 0), (340, 0), (350, 0), (360, 0), (370, 1), (380, 0), (390, 0), (400, 0), (410, 0), (420, 1), (430, 1), (440, 1), (450, 1), (460, 1), (470, 1), (480, 1), (490, 1), (500, 1), (510, 1), (520, 1), (530, 1), (540, 1), (550, 1), (560, 1), (570, 1), (580, 0), (590, 0), (600, 1), (610, 1), (620, 1), (630, 1), (640, 1), (650, 1), (660, 1), (670, 1), (680, 1), (690, 1), (700, 0), (710, 0), (720, 0), (730, 0), (740, 1), (750, 1), (760, 1), (770, 1), (780, 1), (790, 1), (800, 1), (810, 1), (820, 0), (830, 0), (840, 0), (850, 1), (860, 1), (870, 0), (880, 1), (890, 1), (900, 1), (910, 1), (920, 1), (930, 0), (940, 0), (950, 0), (960, 1), (970, 1), (980, 1), (990, 1), (1000, 1), (1010, 1), (1020, 1), (1030, 1), (1040, 1), (1050, 0), (1060, 0), (1070, 1), (1080, 1), (1090, 1), (1100, 1), (1110, 0), (1120, 1), (1130, 1), (1140, 1), (1150, 0), (1160, 0), (1170, 0), (1180, 0), (1190, 0), (1200, 1), (1210, 1), (1220, 1), (1230, 0), (1240, 1), (1250, 1), (1260, 1), (1270, 1), (1280, 1), (1290, 1), (1300, 0), (1310, 0), (1320, 1), (1330, 1), (1340, 1), (1350, 1), (1360, 1), (1370, 1), (1380, 1), (1390, 1), (1400, 1), (1410, 0), (1420, 1), (1430, 1), (1440, 1), (1450, 1), (1460, 1), (1470, 0), (1480, 0), (1490, 0), (1500, 0), (1510, 0), (1520, 0), (1530, 1), (1540, 1), (1550, 1), (1560, 1), (1570, 1), (1580, 1), (1590, 1), (1600, 1), (1610, 1), (1620, 1), (1630, 1), (1640, 1), (1650, 1), (1660, 1), (1670, 1), (1680, 1), (1690, 1), (1700, 1), (1710, 1), (1720, 1), (1730, 0), (1740, 0), (1750, 0), (1760, 0), (1770, 1), (1780, 1), (1790, 0), (1800, 1), (1810, 1), (1820, 0), (1830, 1), (1840, 1), (1850, 0), (1860, 0), (1870, 0), (1880, 0), (1890, 0), (1900, 0), (1910, 0), (1920, 1), (1930, 1), (1940, 1), (1950, 1), (1960, 1), (1970, 1), (1980, 1), (1990, 1), (2000, 1), (2010, 1), (2020, 0), (2030, 0), (2040, 1), (2050, 1)]
Va1_0  a1_0  0 PWL (0n 0.0v 9.495n 0.0v 9.505n 0.0v 19.495n 0.0v 19.505n 0.0v 29.495n 0.0v 29.505n 0.0v 39.495n 0.0v 39.505n 1.95v 49.495n 1.95v 49.505n 1.95v 59.495n 1.95v 59.505n 1.95v 69.495n 1.95v 69.505n 1.95v 79.495n 1.95v 79.505n 1.95v 89.495n 1.95v 89.505n 1.95v 99.495n 1.95v 99.505n 1.95v 109.495n 1.95v 109.505n 1.95v 119.495n 1.95v 119.505n 1.95v 129.495n 1.95v 129.505n 0.0v 139.495n 0.0v 139.505n 1.95v 149.495n 1.95v 149.505n 1.95v 159.495n 1.95v 159.505n 1.95v 169.495n 1.95v 169.505n 0.0v 179.495n 0.0v 179.505n 1.95v 189.495n 1.95v 189.505n 1.95v 199.495n 1.95v 199.505n 1.95v 209.495n 1.95v 209.505n 0.0v 219.495n 0.0v 219.505n 0.0v 229.495n 0.0v 229.505n 0.0v 239.495n 0.0v 239.505n 0.0v 249.495n 0.0v 249.505n 0.0v 259.495n 0.0v 259.505n 0.0v 269.495n 0.0v 269.505n 0.0v 279.495n 0.0v 279.505n 0.0v 289.495n 0.0v 289.505n 0.0v 299.495n 0.0v 299.505n 0.0v 309.495n 0.0v 309.505n 0.0v 319.495n 0.0v 319.505n 0.0v 329.495n 0.0v 329.505n 0.0v 339.495n 0.0v 339.505n 0.0v 349.495n 0.0v 349.505n 0.0v 359.495n 0.0v 359.505n 0.0v 369.495n 0.0v 369.505n 1.95v 379.495n 1.95v 379.505n 0.0v 389.495n 0.0v 389.505n 0.0v 399.495n 0.0v 399.505n 0.0v 409.495n 0.0v 409.505n 0.0v 419.495n 0.0v 419.505n 1.95v 429.495n 1.95v 429.505n 1.95v 439.495n 1.95v 439.505n 1.95v 449.495n 1.95v 449.505n 1.95v 459.495n 1.95v 459.505n 1.95v 469.495n 1.95v 469.505n 1.95v 479.495n 1.95v 479.505n 1.95v 489.495n 1.95v 489.505n 1.95v 499.495n 1.95v 499.505n 1.95v 509.495n 1.95v 509.505n 1.95v 519.495n 1.95v 519.505n 1.95v 529.495n 1.95v 529.505n 1.95v 539.495n 1.95v 539.505n 1.95v 549.495n 1.95v 549.505n 1.95v 559.495n 1.95v 559.505n 1.95v 569.495n 1.95v 569.505n 1.95v 579.495n 1.95v 579.505n 0.0v 589.495n 0.0v 589.505n 0.0v 599.495n 0.0v 599.505n 1.95v 609.495n 1.95v 609.505n 1.95v 619.495n 1.95v 619.505n 1.95v 629.495n 1.95v 629.505n 1.95v 639.495n 1.95v 639.505n 1.95v 649.495n 1.95v 649.505n 1.95v 659.495n 1.95v 659.505n 1.95v 669.495n 1.95v 669.505n 1.95v 679.495n 1.95v 679.505n 1.95v 689.495n 1.95v 689.505n 1.95v 699.495n 1.95v 699.505n 0.0v 709.495n 0.0v 709.505n 0.0v 719.495n 0.0v 719.505n 0.0v 729.495n 0.0v 729.505n 0.0v 739.495n 0.0v 739.505n 1.95v 749.495n 1.95v 749.505n 1.95v 759.495n 1.95v 759.505n 1.95v 769.495n 1.95v 769.505n 1.95v 779.495n 1.95v 779.505n 1.95v 789.495n 1.95v 789.505n 1.95v 799.495n 1.95v 799.505n 1.95v 809.495n 1.95v 809.505n 1.95v 819.495n 1.95v 819.505n 0.0v 829.495n 0.0v 829.505n 0.0v 839.495n 0.0v 839.505n 0.0v 849.495n 0.0v 849.505n 1.95v 859.495n 1.95v 859.505n 1.95v 869.495n 1.95v 869.505n 0.0v 879.495n 0.0v 879.505n 1.95v 889.495n 1.95v 889.505n 1.95v 899.495n 1.95v 899.505n 1.95v 909.495n 1.95v 909.505n 1.95v 919.495n 1.95v 919.505n 1.95v 929.495n 1.95v 929.505n 0.0v 939.495n 0.0v 939.505n 0.0v 949.495n 0.0v 949.505n 0.0v 959.495n 0.0v 959.505n 1.95v 969.495n 1.95v 969.505n 1.95v 979.495n 1.95v 979.505n 1.95v 989.495n 1.95v 989.505n 1.95v 999.495n 1.95v 999.505n 1.95v 1009.495n 1.95v 1009.505n 1.95v 1019.495n 1.95v 1019.505n 1.95v 1029.495n 1.95v 1029.505n 1.95v 1039.495n 1.95v 1039.505n 1.95v 1049.495n 1.95v 1049.505n 0.0v 1059.495n 0.0v 1059.505n 0.0v 1069.495n 0.0v 1069.505n 1.95v 1079.495n 1.95v 1079.505n 1.95v 1089.495n 1.95v 1089.505n 1.95v 1099.495n 1.95v 1099.505n 1.95v 1109.495n 1.95v 1109.505n 0.0v 1119.495n 0.0v 1119.505n 1.95v 1129.495n 1.95v 1129.505n 1.95v 1139.495n 1.95v 1139.505n 1.95v 1149.495n 1.95v 1149.505n 0.0v 1159.495n 0.0v 1159.505n 0.0v 1169.495n 0.0v 1169.505n 0.0v 1179.495n 0.0v 1179.505n 0.0v 1189.495n 0.0v 1189.505n 0.0v 1199.495n 0.0v 1199.505n 1.95v 1209.495n 1.95v 1209.505n 1.95v 1219.495n 1.95v 1219.505n 1.95v 1229.495n 1.95v 1229.505n 0.0v 1239.495n 0.0v 1239.505n 1.95v 1249.495n 1.95v 1249.505n 1.95v 1259.495n 1.95v 1259.505n 1.95v 1269.495n 1.95v 1269.505n 1.95v 1279.495n 1.95v 1279.505n 1.95v 1289.495n 1.95v 1289.505n 1.95v 1299.495n 1.95v 1299.505n 0.0v 1309.495n 0.0v 1309.505n 0.0v 1319.495n 0.0v 1319.505n 1.95v 1329.495n 1.95v 1329.505n 1.95v 1339.495n 1.95v 1339.505n 1.95v 1349.495n 1.95v 1349.505n 1.95v 1359.495n 1.95v 1359.505n 1.95v 1369.495n 1.95v 1369.505n 1.95v 1379.495n 1.95v 1379.505n 1.95v 1389.495n 1.95v 1389.505n 1.95v 1399.495n 1.95v 1399.505n 1.95v 1409.495n 1.95v 1409.505n 0.0v 1419.495n 0.0v 1419.505n 1.95v 1429.495n 1.95v 1429.505n 1.95v 1439.495n 1.95v 1439.505n 1.95v 1449.495n 1.95v 1449.505n 1.95v 1459.495n 1.95v 1459.505n 1.95v 1469.495n 1.95v 1469.505n 0.0v 1479.495n 0.0v 1479.505n 0.0v 1489.495n 0.0v 1489.505n 0.0v 1499.495n 0.0v 1499.505n 0.0v 1509.495n 0.0v 1509.505n 0.0v 1519.495n 0.0v 1519.505n 0.0v 1529.495n 0.0v 1529.505n 1.95v 1539.495n 1.95v 1539.505n 1.95v 1549.495n 1.95v 1549.505n 1.95v 1559.495n 1.95v 1559.505n 1.95v 1569.495n 1.95v 1569.505n 1.95v 1579.495n 1.95v 1579.505n 1.95v 1589.495n 1.95v 1589.505n 1.95v 1599.495n 1.95v 1599.505n 1.95v 1609.495n 1.95v 1609.505n 1.95v 1619.495n 1.95v 1619.505n 1.95v 1629.495n 1.95v 1629.505n 1.95v 1639.495n 1.95v 1639.505n 1.95v 1649.495n 1.95v 1649.505n 1.95v 1659.495n 1.95v 1659.505n 1.95v 1669.495n 1.95v 1669.505n 1.95v 1679.495n 1.95v 1679.505n 1.95v 1689.495n 1.95v 1689.505n 1.95v 1699.495n 1.95v 1699.505n 1.95v 1709.495n 1.95v 1709.505n 1.95v 1719.495n 1.95v 1719.505n 1.95v 1729.495n 1.95v 1729.505n 0.0v 1739.495n 0.0v 1739.505n 0.0v 1749.495n 0.0v 1749.505n 0.0v 1759.495n 0.0v 1759.505n 0.0v 1769.495n 0.0v 1769.505n 1.95v 1779.495n 1.95v 1779.505n 1.95v 1789.495n 1.95v 1789.505n 0.0v 1799.495n 0.0v 1799.505n 1.95v 1809.495n 1.95v 1809.505n 1.95v 1819.495n 1.95v 1819.505n 0.0v 1829.495n 0.0v 1829.505n 1.95v 1839.495n 1.95v 1839.505n 1.95v 1849.495n 1.95v 1849.505n 0.0v 1859.495n 0.0v 1859.505n 0.0v 1869.495n 0.0v 1869.505n 0.0v 1879.495n 0.0v 1879.505n 0.0v 1889.495n 0.0v 1889.505n 0.0v 1899.495n 0.0v 1899.505n 0.0v 1909.495n 0.0v 1909.505n 0.0v 1919.495n 0.0v 1919.505n 1.95v 1929.495n 1.95v 1929.505n 1.95v 1939.495n 1.95v 1939.505n 1.95v 1949.495n 1.95v 1949.505n 1.95v 1959.495n 1.95v 1959.505n 1.95v 1969.495n 1.95v 1969.505n 1.95v 1979.495n 1.95v 1979.505n 1.95v 1989.495n 1.95v 1989.505n 1.95v 1999.495n 1.95v 1999.505n 1.95v 2009.495n 1.95v 2009.505n 1.95v 2019.495n 1.95v 2019.505n 0.0v 2029.495n 0.0v 2029.505n 0.0v 2039.495n 0.0v 2039.505n 1.95v 2049.495n 1.95v 2049.505n 1.95v )
* (time, data): [(0, 0), (10, 0), (20, 0), (30, 0), (40, 0), (50, 0), (60, 0), (70, 0), (80, 0), (90, 0), (100, 0), (110, 0), (120, 0), (130, 0), (140, 0), (150, 0), (160, 0), (170, 0), (180, 0), (190, 0), (200, 0), (210, 0), (220, 0), (230, 0), (240, 0), (250, 0), (260, 0), (270, 0), (280, 0), (290, 0), (300, 0), (310, 0), (320, 0), (330, 0), (340, 0), (350, 0), (360, 0), (370, 0), (380, 0), (390, 0), (400, 0), (410, 0), (420, 0), (430, 0), (440, 0), (450, 0), (460, 0), (470, 0), (480, 0), (490, 0), (500, 0), (510, 0), (520, 0), (530, 0), (540, 0), (550, 0), (560, 0), (570, 0), (580, 1), (590, 1), (600, 0), (610, 0), (620, 0), (630, 0), (640, 0), (650, 0), (660, 0), (670, 0), (680, 0), (690, 0), (700, 1), (710, 1), (720, 1), (730, 1), (740, 0), (750, 0), (760, 0), (770, 0), (780, 0), (790, 0), (800, 0), (810, 0), (820, 1), (830, 1), (840, 1), (850, 0), (860, 0), (870, 0), (880, 0), (890, 0), (900, 0), (910, 0), (920, 0), (930, 0), (940, 0), (950, 0), (960, 0), (970, 0), (980, 0), (990, 0), (1000, 0), (1010, 0), (1020, 0), (1030, 0), (1040, 0), (1050, 1), (1060, 1), (1070, 0), (1080, 0), (1090, 0), (1100, 0), (1110, 1), (1120, 0), (1130, 0), (1140, 0), (1150, 1), (1160, 1), (1170, 0), (1180, 1), (1190, 1), (1200, 0), (1210, 0), (1220, 0), (1230, 1), (1240, 0), (1250, 0), (1260, 0), (1270, 0), (1280, 0), (1290, 0), (1300, 1), (1310, 1), (1320, 0), (1330, 0), (1340, 0), (1350, 0), (1360, 0), (1370, 0), (1380, 0), (1390, 0), (1400, 0), (1410, 1), (1420, 0), (1430, 0), (1440, 0), (1450, 0), (1460, 0), (1470, 0), (1480, 0), (1490, 0), (1500, 0), (1510, 0), (1520, 0), (1530, 0), (1540, 0), (1550, 0), (1560, 0), (1570, 0), (1580, 0), (1590, 0), (1600, 0), (1610, 0), (1620, 0), (1630, 0), (1640, 0), (1650, 0), (1660, 0), (1670, 0), (1680, 0), (1690, 0), (1700, 0), (1710, 0), (1720, 0), (1730, 0), (1740, 0), (1750, 1), (1760, 1), (1770, 0), (1780, 0), (1790, 1), (1800, 0), (1810, 0), (1820, 1), (1830, 0), (1840, 0), (1850, 1), (1860, 1), (1870, 1), (1880, 1), (1890, 0), (1900, 0), (1910, 0), (1920, 0), (1930, 0), (1940, 0), (1950, 0), (1960, 0), (1970, 0), (1980, 0), (1990, 0), (2000, 0), (2010, 0), (2020, 0), (2030, 0), (2040, 0), (2050, 0)]
Va1_1  a1_1  0 PWL (0n 0.0v 9.495n 0.0v 9.505n 0.0v 19.495n 0.0v 19.505n 0.0v 29.495n 0.0v 29.505n 0.0v 39.495n 0.0v 39.505n 0.0v 49.495n 0.0v 49.505n 0.0v 59.495n 0.0v 59.505n 0.0v 69.495n 0.0v 69.505n 0.0v 79.495n 0.0v 79.505n 0.0v 89.495n 0.0v 89.505n 0.0v 99.495n 0.0v 99.505n 0.0v 109.495n 0.0v 109.505n 0.0v 119.495n 0.0v 119.505n 0.0v 129.495n 0.0v 129.505n 0.0v 139.495n 0.0v 139.505n 0.0v 149.495n 0.0v 149.505n 0.0v 159.495n 0.0v 159.505n 0.0v 169.495n 0.0v 169.505n 0.0v 179.495n 0.0v 179.505n 0.0v 189.495n 0.0v 189.505n 0.0v 199.495n 0.0v 199.505n 0.0v 209.495n 0.0v 209.505n 0.0v 219.495n 0.0v 219.505n 0.0v 229.495n 0.0v 229.505n 0.0v 239.495n 0.0v 239.505n 0.0v 249.495n 0.0v 249.505n 0.0v 259.495n 0.0v 259.505n 0.0v 269.495n 0.0v 269.505n 0.0v 279.495n 0.0v 279.505n 0.0v 289.495n 0.0v 289.505n 0.0v 299.495n 0.0v 299.505n 0.0v 309.495n 0.0v 309.505n 0.0v 319.495n 0.0v 319.505n 0.0v 329.495n 0.0v 329.505n 0.0v 339.495n 0.0v 339.505n 0.0v 349.495n 0.0v 349.505n 0.0v 359.495n 0.0v 359.505n 0.0v 369.495n 0.0v 369.505n 0.0v 379.495n 0.0v 379.505n 0.0v 389.495n 0.0v 389.505n 0.0v 399.495n 0.0v 399.505n 0.0v 409.495n 0.0v 409.505n 0.0v 419.495n 0.0v 419.505n 0.0v 429.495n 0.0v 429.505n 0.0v 439.495n 0.0v 439.505n 0.0v 449.495n 0.0v 449.505n 0.0v 459.495n 0.0v 459.505n 0.0v 469.495n 0.0v 469.505n 0.0v 479.495n 0.0v 479.505n 0.0v 489.495n 0.0v 489.505n 0.0v 499.495n 0.0v 499.505n 0.0v 509.495n 0.0v 509.505n 0.0v 519.495n 0.0v 519.505n 0.0v 529.495n 0.0v 529.505n 0.0v 539.495n 0.0v 539.505n 0.0v 549.495n 0.0v 549.505n 0.0v 559.495n 0.0v 559.505n 0.0v 569.495n 0.0v 569.505n 0.0v 579.495n 0.0v 579.505n 1.95v 589.495n 1.95v 589.505n 1.95v 599.495n 1.95v 599.505n 0.0v 609.495n 0.0v 609.505n 0.0v 619.495n 0.0v 619.505n 0.0v 629.495n 0.0v 629.505n 0.0v 639.495n 0.0v 639.505n 0.0v 649.495n 0.0v 649.505n 0.0v 659.495n 0.0v 659.505n 0.0v 669.495n 0.0v 669.505n 0.0v 679.495n 0.0v 679.505n 0.0v 689.495n 0.0v 689.505n 0.0v 699.495n 0.0v 699.505n 1.95v 709.495n 1.95v 709.505n 1.95v 719.495n 1.95v 719.505n 1.95v 729.495n 1.95v 729.505n 1.95v 739.495n 1.95v 739.505n 0.0v 749.495n 0.0v 749.505n 0.0v 759.495n 0.0v 759.505n 0.0v 769.495n 0.0v 769.505n 0.0v 779.495n 0.0v 779.505n 0.0v 789.495n 0.0v 789.505n 0.0v 799.495n 0.0v 799.505n 0.0v 809.495n 0.0v 809.505n 0.0v 819.495n 0.0v 819.505n 1.95v 829.495n 1.95v 829.505n 1.95v 839.495n 1.95v 839.505n 1.95v 849.495n 1.95v 849.505n 0.0v 859.495n 0.0v 859.505n 0.0v 869.495n 0.0v 869.505n 0.0v 879.495n 0.0v 879.505n 0.0v 889.495n 0.0v 889.505n 0.0v 899.495n 0.0v 899.505n 0.0v 909.495n 0.0v 909.505n 0.0v 919.495n 0.0v 919.505n 0.0v 929.495n 0.0v 929.505n 0.0v 939.495n 0.0v 939.505n 0.0v 949.495n 0.0v 949.505n 0.0v 959.495n 0.0v 959.505n 0.0v 969.495n 0.0v 969.505n 0.0v 979.495n 0.0v 979.505n 0.0v 989.495n 0.0v 989.505n 0.0v 999.495n 0.0v 999.505n 0.0v 1009.495n 0.0v 1009.505n 0.0v 1019.495n 0.0v 1019.505n 0.0v 1029.495n 0.0v 1029.505n 0.0v 1039.495n 0.0v 1039.505n 0.0v 1049.495n 0.0v 1049.505n 1.95v 1059.495n 1.95v 1059.505n 1.95v 1069.495n 1.95v 1069.505n 0.0v 1079.495n 0.0v 1079.505n 0.0v 1089.495n 0.0v 1089.505n 0.0v 1099.495n 0.0v 1099.505n 0.0v 1109.495n 0.0v 1109.505n 1.95v 1119.495n 1.95v 1119.505n 0.0v 1129.495n 0.0v 1129.505n 0.0v 1139.495n 0.0v 1139.505n 0.0v 1149.495n 0.0v 1149.505n 1.95v 1159.495n 1.95v 1159.505n 1.95v 1169.495n 1.95v 1169.505n 0.0v 1179.495n 0.0v 1179.505n 1.95v 1189.495n 1.95v 1189.505n 1.95v 1199.495n 1.95v 1199.505n 0.0v 1209.495n 0.0v 1209.505n 0.0v 1219.495n 0.0v 1219.505n 0.0v 1229.495n 0.0v 1229.505n 1.95v 1239.495n 1.95v 1239.505n 0.0v 1249.495n 0.0v 1249.505n 0.0v 1259.495n 0.0v 1259.505n 0.0v 1269.495n 0.0v 1269.505n 0.0v 1279.495n 0.0v 1279.505n 0.0v 1289.495n 0.0v 1289.505n 0.0v 1299.495n 0.0v 1299.505n 1.95v 1309.495n 1.95v 1309.505n 1.95v 1319.495n 1.95v 1319.505n 0.0v 1329.495n 0.0v 1329.505n 0.0v 1339.495n 0.0v 1339.505n 0.0v 1349.495n 0.0v 1349.505n 0.0v 1359.495n 0.0v 1359.505n 0.0v 1369.495n 0.0v 1369.505n 0.0v 1379.495n 0.0v 1379.505n 0.0v 1389.495n 0.0v 1389.505n 0.0v 1399.495n 0.0v 1399.505n 0.0v 1409.495n 0.0v 1409.505n 1.95v 1419.495n 1.95v 1419.505n 0.0v 1429.495n 0.0v 1429.505n 0.0v 1439.495n 0.0v 1439.505n 0.0v 1449.495n 0.0v 1449.505n 0.0v 1459.495n 0.0v 1459.505n 0.0v 1469.495n 0.0v 1469.505n 0.0v 1479.495n 0.0v 1479.505n 0.0v 1489.495n 0.0v 1489.505n 0.0v 1499.495n 0.0v 1499.505n 0.0v 1509.495n 0.0v 1509.505n 0.0v 1519.495n 0.0v 1519.505n 0.0v 1529.495n 0.0v 1529.505n 0.0v 1539.495n 0.0v 1539.505n 0.0v 1549.495n 0.0v 1549.505n 0.0v 1559.495n 0.0v 1559.505n 0.0v 1569.495n 0.0v 1569.505n 0.0v 1579.495n 0.0v 1579.505n 0.0v 1589.495n 0.0v 1589.505n 0.0v 1599.495n 0.0v 1599.505n 0.0v 1609.495n 0.0v 1609.505n 0.0v 1619.495n 0.0v 1619.505n 0.0v 1629.495n 0.0v 1629.505n 0.0v 1639.495n 0.0v 1639.505n 0.0v 1649.495n 0.0v 1649.505n 0.0v 1659.495n 0.0v 1659.505n 0.0v 1669.495n 0.0v 1669.505n 0.0v 1679.495n 0.0v 1679.505n 0.0v 1689.495n 0.0v 1689.505n 0.0v 1699.495n 0.0v 1699.505n 0.0v 1709.495n 0.0v 1709.505n 0.0v 1719.495n 0.0v 1719.505n 0.0v 1729.495n 0.0v 1729.505n 0.0v 1739.495n 0.0v 1739.505n 0.0v 1749.495n 0.0v 1749.505n 1.95v 1759.495n 1.95v 1759.505n 1.95v 1769.495n 1.95v 1769.505n 0.0v 1779.495n 0.0v 1779.505n 0.0v 1789.495n 0.0v 1789.505n 1.95v 1799.495n 1.95v 1799.505n 0.0v 1809.495n 0.0v 1809.505n 0.0v 1819.495n 0.0v 1819.505n 1.95v 1829.495n 1.95v 1829.505n 0.0v 1839.495n 0.0v 1839.505n 0.0v 1849.495n 0.0v 1849.505n 1.95v 1859.495n 1.95v 1859.505n 1.95v 1869.495n 1.95v 1869.505n 1.95v 1879.495n 1.95v 1879.505n 1.95v 1889.495n 1.95v 1889.505n 0.0v 1899.495n 0.0v 1899.505n 0.0v 1909.495n 0.0v 1909.505n 0.0v 1919.495n 0.0v 1919.505n 0.0v 1929.495n 0.0v 1929.505n 0.0v 1939.495n 0.0v 1939.505n 0.0v 1949.495n 0.0v 1949.505n 0.0v 1959.495n 0.0v 1959.505n 0.0v 1969.495n 0.0v 1969.505n 0.0v 1979.495n 0.0v 1979.505n 0.0v 1989.495n 0.0v 1989.505n 0.0v 1999.495n 0.0v 1999.505n 0.0v 2009.495n 0.0v 2009.505n 0.0v 2019.495n 0.0v 2019.505n 0.0v 2029.495n 0.0v 2029.505n 0.0v 2039.495n 0.0v 2039.505n 0.0v 2049.495n 0.0v 2049.505n 0.0v )
* (time, data): [(0, 0), (10, 0), (20, 0), (30, 0), (40, 0), (50, 0), (60, 0), (70, 0), (80, 0), (90, 0), (100, 0), (110, 0), (120, 0), (130, 0), (140, 0), (150, 0), (160, 0), (170, 0), (180, 0), (190, 0), (200, 0), (210, 0), (220, 0), (230, 0), (240, 0), (250, 0), (260, 0), (270, 0), (280, 0), (290, 0), (300, 0), (310, 0), (320, 0), (330, 0), (340, 0), (350, 0), (360, 0), (370, 0), (380, 0), (390, 0), (400, 0), (410, 0), (420, 1), (430, 0), (440, 0), (450, 0), (460, 1), (470, 1), (480, 1), (490, 1), (500, 1), (510, 1), (520, 1), (530, 1), (540, 1), (550, 1), (560, 1), (570, 1), (580, 1), (590, 1), (600, 1), (610, 1), (620, 0), (630, 0), (640, 0), (650, 1), (660, 0), (670, 0), (680, 0), (690, 1), (700, 1), (710, 1), (720, 1), (730, 1), (740, 0), (750, 0), (760, 0), (770, 0), (780, 1), (790, 1), (800, 1), (810, 1), (820, 1), (830, 1), (840, 1), (850, 0), (860, 0), (870, 0), (880, 1), (890, 1), (900, 0), (910, 0), (920, 0), (930, 0), (940, 0), (950, 0), (960, 1), (970, 1), (980, 1), (990, 1), (1000, 1), (1010, 0), (1020, 0), (1030, 0), (1040, 0), (1050, 1), (1060, 1), (1070, 0), (1080, 0), (1090, 1), (1100, 1), (1110, 1), (1120, 1), (1130, 1), (1140, 1), (1150, 1), (1160, 1), (1170, 0), (1180, 1), (1190, 1), (1200, 0), (1210, 0), (1220, 1), (1230, 1), (1240, 1), (1250, 0), (1260, 1), (1270, 1), (1280, 0), (1290, 0), (1300, 1), (1310, 1), (1320, 0), (1330, 0), (1340, 0), (1350, 0), (1360, 1), (1370, 1), (1380, 1), (1390, 1), (1400, 1), (1410, 1), (1420, 0), (1430, 0), (1440, 0), (1450, 0), (1460, 0), (1470, 0), (1480, 0), (1490, 0), (1500, 0), (1510, 0), (1520, 0), (1530, 1), (1540, 0), (1550, 0), (1560, 0), (1570, 1), (1580, 1), (1590, 1), (1600, 1), (1610, 1), (1620, 1), (1630, 1), (1640, 1), (1650, 1), (1660, 0), (1670, 0), (1680, 0), (1690, 0), (1700, 1), (1710, 1), (1720, 1), (1730, 0), (1740, 0), (1750, 1), (1760, 1), (1770, 0), (1780, 0), (1790, 1), (1800, 0), (1810, 0), (1820, 1), (1830, 0), (1840, 0), (1850, 1), (1860, 1), (1870, 1), (1880, 1), (1890, 0), (1900, 0), (1910, 0), (1920, 0), (1930, 0), (1940, 0), (1950, 0), (1960, 0), (1970, 0), (1980, 0), (1990, 0), (2000, 0), (2010, 0), (2020, 0), (2030, 0), (2040, 0), (2050, 0)]
Va1_2  a1_2  0 PWL (0n 0.0v 9.495n 0.0v 9.505n 0.0v 19.495n 0.0v 19.505n 0.0v 29.495n 0.0v 29.505n 0.0v 39.495n 0.0v 39.505n 0.0v 49.495n 0.0v 49.505n 0.0v 59.495n 0.0v 59.505n 0.0v 69.495n 0.0v 69.505n 0.0v 79.495n 0.0v 79.505n 0.0v 89.495n 0.0v 89.505n 0.0v 99.495n 0.0v 99.505n 0.0v 109.495n 0.0v 109.505n 0.0v 119.495n 0.0v 119.505n 0.0v 129.495n 0.0v 129.505n 0.0v 139.495n 0.0v 139.505n 0.0v 149.495n 0.0v 149.505n 0.0v 159.495n 0.0v 159.505n 0.0v 169.495n 0.0v 169.505n 0.0v 179.495n 0.0v 179.505n 0.0v 189.495n 0.0v 189.505n 0.0v 199.495n 0.0v 199.505n 0.0v 209.495n 0.0v 209.505n 0.0v 219.495n 0.0v 219.505n 0.0v 229.495n 0.0v 229.505n 0.0v 239.495n 0.0v 239.505n 0.0v 249.495n 0.0v 249.505n 0.0v 259.495n 0.0v 259.505n 0.0v 269.495n 0.0v 269.505n 0.0v 279.495n 0.0v 279.505n 0.0v 289.495n 0.0v 289.505n 0.0v 299.495n 0.0v 299.505n 0.0v 309.495n 0.0v 309.505n 0.0v 319.495n 0.0v 319.505n 0.0v 329.495n 0.0v 329.505n 0.0v 339.495n 0.0v 339.505n 0.0v 349.495n 0.0v 349.505n 0.0v 359.495n 0.0v 359.505n 0.0v 369.495n 0.0v 369.505n 0.0v 379.495n 0.0v 379.505n 0.0v 389.495n 0.0v 389.505n 0.0v 399.495n 0.0v 399.505n 0.0v 409.495n 0.0v 409.505n 0.0v 419.495n 0.0v 419.505n 1.95v 429.495n 1.95v 429.505n 0.0v 439.495n 0.0v 439.505n 0.0v 449.495n 0.0v 449.505n 0.0v 459.495n 0.0v 459.505n 1.95v 469.495n 1.95v 469.505n 1.95v 479.495n 1.95v 479.505n 1.95v 489.495n 1.95v 489.505n 1.95v 499.495n 1.95v 499.505n 1.95v 509.495n 1.95v 509.505n 1.95v 519.495n 1.95v 519.505n 1.95v 529.495n 1.95v 529.505n 1.95v 539.495n 1.95v 539.505n 1.95v 549.495n 1.95v 549.505n 1.95v 559.495n 1.95v 559.505n 1.95v 569.495n 1.95v 569.505n 1.95v 579.495n 1.95v 579.505n 1.95v 589.495n 1.95v 589.505n 1.95v 599.495n 1.95v 599.505n 1.95v 609.495n 1.95v 609.505n 1.95v 619.495n 1.95v 619.505n 0.0v 629.495n 0.0v 629.505n 0.0v 639.495n 0.0v 639.505n 0.0v 649.495n 0.0v 649.505n 1.95v 659.495n 1.95v 659.505n 0.0v 669.495n 0.0v 669.505n 0.0v 679.495n 0.0v 679.505n 0.0v 689.495n 0.0v 689.505n 1.95v 699.495n 1.95v 699.505n 1.95v 709.495n 1.95v 709.505n 1.95v 719.495n 1.95v 719.505n 1.95v 729.495n 1.95v 729.505n 1.95v 739.495n 1.95v 739.505n 0.0v 749.495n 0.0v 749.505n 0.0v 759.495n 0.0v 759.505n 0.0v 769.495n 0.0v 769.505n 0.0v 779.495n 0.0v 779.505n 1.95v 789.495n 1.95v 789.505n 1.95v 799.495n 1.95v 799.505n 1.95v 809.495n 1.95v 809.505n 1.95v 819.495n 1.95v 819.505n 1.95v 829.495n 1.95v 829.505n 1.95v 839.495n 1.95v 839.505n 1.95v 849.495n 1.95v 849.505n 0.0v 859.495n 0.0v 859.505n 0.0v 869.495n 0.0v 869.505n 0.0v 879.495n 0.0v 879.505n 1.95v 889.495n 1.95v 889.505n 1.95v 899.495n 1.95v 899.505n 0.0v 909.495n 0.0v 909.505n 0.0v 919.495n 0.0v 919.505n 0.0v 929.495n 0.0v 929.505n 0.0v 939.495n 0.0v 939.505n 0.0v 949.495n 0.0v 949.505n 0.0v 959.495n 0.0v 959.505n 1.95v 969.495n 1.95v 969.505n 1.95v 979.495n 1.95v 979.505n 1.95v 989.495n 1.95v 989.505n 1.95v 999.495n 1.95v 999.505n 1.95v 1009.495n 1.95v 1009.505n 0.0v 1019.495n 0.0v 1019.505n 0.0v 1029.495n 0.0v 1029.505n 0.0v 1039.495n 0.0v 1039.505n 0.0v 1049.495n 0.0v 1049.505n 1.95v 1059.495n 1.95v 1059.505n 1.95v 1069.495n 1.95v 1069.505n 0.0v 1079.495n 0.0v 1079.505n 0.0v 1089.495n 0.0v 1089.505n 1.95v 1099.495n 1.95v 1099.505n 1.95v 1109.495n 1.95v 1109.505n 1.95v 1119.495n 1.95v 1119.505n 1.95v 1129.495n 1.95v 1129.505n 1.95v 1139.495n 1.95v 1139.505n 1.95v 1149.495n 1.95v 1149.505n 1.95v 1159.495n 1.95v 1159.505n 1.95v 1169.495n 1.95v 1169.505n 0.0v 1179.495n 0.0v 1179.505n 1.95v 1189.495n 1.95v 1189.505n 1.95v 1199.495n 1.95v 1199.505n 0.0v 1209.495n 0.0v 1209.505n 0.0v 1219.495n 0.0v 1219.505n 1.95v 1229.495n 1.95v 1229.505n 1.95v 1239.495n 1.95v 1239.505n 1.95v 1249.495n 1.95v 1249.505n 0.0v 1259.495n 0.0v 1259.505n 1.95v 1269.495n 1.95v 1269.505n 1.95v 1279.495n 1.95v 1279.505n 0.0v 1289.495n 0.0v 1289.505n 0.0v 1299.495n 0.0v 1299.505n 1.95v 1309.495n 1.95v 1309.505n 1.95v 1319.495n 1.95v 1319.505n 0.0v 1329.495n 0.0v 1329.505n 0.0v 1339.495n 0.0v 1339.505n 0.0v 1349.495n 0.0v 1349.505n 0.0v 1359.495n 0.0v 1359.505n 1.95v 1369.495n 1.95v 1369.505n 1.95v 1379.495n 1.95v 1379.505n 1.95v 1389.495n 1.95v 1389.505n 1.95v 1399.495n 1.95v 1399.505n 1.95v 1409.495n 1.95v 1409.505n 1.95v 1419.495n 1.95v 1419.505n 0.0v 1429.495n 0.0v 1429.505n 0.0v 1439.495n 0.0v 1439.505n 0.0v 1449.495n 0.0v 1449.505n 0.0v 1459.495n 0.0v 1459.505n 0.0v 1469.495n 0.0v 1469.505n 0.0v 1479.495n 0.0v 1479.505n 0.0v 1489.495n 0.0v 1489.505n 0.0v 1499.495n 0.0v 1499.505n 0.0v 1509.495n 0.0v 1509.505n 0.0v 1519.495n 0.0v 1519.505n 0.0v 1529.495n 0.0v 1529.505n 1.95v 1539.495n 1.95v 1539.505n 0.0v 1549.495n 0.0v 1549.505n 0.0v 1559.495n 0.0v 1559.505n 0.0v 1569.495n 0.0v 1569.505n 1.95v 1579.495n 1.95v 1579.505n 1.95v 1589.495n 1.95v 1589.505n 1.95v 1599.495n 1.95v 1599.505n 1.95v 1609.495n 1.95v 1609.505n 1.95v 1619.495n 1.95v 1619.505n 1.95v 1629.495n 1.95v 1629.505n 1.95v 1639.495n 1.95v 1639.505n 1.95v 1649.495n 1.95v 1649.505n 1.95v 1659.495n 1.95v 1659.505n 0.0v 1669.495n 0.0v 1669.505n 0.0v 1679.495n 0.0v 1679.505n 0.0v 1689.495n 0.0v 1689.505n 0.0v 1699.495n 0.0v 1699.505n 1.95v 1709.495n 1.95v 1709.505n 1.95v 1719.495n 1.95v 1719.505n 1.95v 1729.495n 1.95v 1729.505n 0.0v 1739.495n 0.0v 1739.505n 0.0v 1749.495n 0.0v 1749.505n 1.95v 1759.495n 1.95v 1759.505n 1.95v 1769.495n 1.95v 1769.505n 0.0v 1779.495n 0.0v 1779.505n 0.0v 1789.495n 0.0v 1789.505n 1.95v 1799.495n 1.95v 1799.505n 0.0v 1809.495n 0.0v 1809.505n 0.0v 1819.495n 0.0v 1819.505n 1.95v 1829.495n 1.95v 1829.505n 0.0v 1839.495n 0.0v 1839.505n 0.0v 1849.495n 0.0v 1849.505n 1.95v 1859.495n 1.95v 1859.505n 1.95v 1869.495n 1.95v 1869.505n 1.95v 1879.495n 1.95v 1879.505n 1.95v 1889.495n 1.95v 1889.505n 0.0v 1899.495n 0.0v 1899.505n 0.0v 1909.495n 0.0v 1909.505n 0.0v 1919.495n 0.0v 1919.505n 0.0v 1929.495n 0.0v 1929.505n 0.0v 1939.495n 0.0v 1939.505n 0.0v 1949.495n 0.0v 1949.505n 0.0v 1959.495n 0.0v 1959.505n 0.0v 1969.495n 0.0v 1969.505n 0.0v 1979.495n 0.0v 1979.505n 0.0v 1989.495n 0.0v 1989.505n 0.0v 1999.495n 0.0v 1999.505n 0.0v 2009.495n 0.0v 2009.505n 0.0v 2019.495n 0.0v 2019.505n 0.0v 2029.495n 0.0v 2029.505n 0.0v 2039.495n 0.0v 2039.505n 0.0v 2049.495n 0.0v 2049.505n 0.0v )
* (time, data): [(0, 0), (10, 0), (20, 0), (30, 0), (40, 0), (50, 0), (60, 0), (70, 0), (80, 0), (90, 0), (100, 0), (110, 0), (120, 0), (130, 0), (140, 0), (150, 0), (160, 0), (170, 0), (180, 0), (190, 0), (200, 0), (210, 0), (220, 0), (230, 0), (240, 0), (250, 0), (260, 0), (270, 0), (280, 0), (290, 0), (300, 0), (310, 0), (320, 0), (330, 0), (340, 0), (350, 0), (360, 0), (370, 0), (380, 0), (390, 0), (400, 0), (410, 0), (420, 1), (430, 0), (440, 0), (450, 0), (460, 1), (470, 1), (480, 1), (490, 1), (500, 1), (510, 1), (520, 1), (530, 1), (540, 1), (550, 1), (560, 1), (570, 1), (580, 1), (590, 1), (600, 1), (610, 1), (620, 0), (630, 0), (640, 0), (650, 1), (660, 0), (670, 0), (680, 0), (690, 1), (700, 1), (710, 1), (720, 1), (730, 1), (740, 0), (750, 0), (760, 0), (770, 0), (780, 1), (790, 1), (800, 1), (810, 1), (820, 1), (830, 1), (840, 1), (850, 0), (860, 0), (870, 0), (880, 1), (890, 1), (900, 0), (910, 0), (920, 0), (930, 0), (940, 0), (950, 0), (960, 1), (970, 1), (980, 1), (990, 1), (1000, 1), (1010, 0), (1020, 0), (1030, 0), (1040, 0), (1050, 1), (1060, 1), (1070, 0), (1080, 0), (1090, 1), (1100, 1), (1110, 1), (1120, 1), (1130, 1), (1140, 1), (1150, 1), (1160, 1), (1170, 0), (1180, 1), (1190, 1), (1200, 0), (1210, 0), (1220, 1), (1230, 1), (1240, 1), (1250, 0), (1260, 1), (1270, 1), (1280, 0), (1290, 0), (1300, 1), (1310, 1), (1320, 0), (1330, 0), (1340, 0), (1350, 0), (1360, 1), (1370, 1), (1380, 1), (1390, 1), (1400, 1), (1410, 1), (1420, 0), (1430, 0), (1440, 0), (1450, 0), (1460, 0), (1470, 0), (1480, 0), (1490, 0), (1500, 0), (1510, 0), (1520, 0), (1530, 1), (1540, 0), (1550, 0), (1560, 0), (1570, 1), (1580, 1), (1590, 1), (1600, 1), (1610, 1), (1620, 1), (1630, 1), (1640, 1), (1650, 1), (1660, 0), (1670, 0), (1680, 0), (1690, 0), (1700, 1), (1710, 1), (1720, 1), (1730, 0), (1740, 0), (1750, 1), (1760, 1), (1770, 0), (1780, 0), (1790, 1), (1800, 0), (1810, 0), (1820, 1), (1830, 0), (1840, 0), (1850, 1), (1860, 1), (1870, 1), (1880, 1), (1890, 0), (1900, 0), (1910, 0), (1920, 0), (1930, 0), (1940, 0), (1950, 0), (1960, 0), (1970, 0), (1980, 0), (1990, 0), (2000, 0), (2010, 0), (2020, 0), (2030, 0), (2040, 0), (2050, 0)]
Va1_3  a1_3  0 PWL (0n 0.0v 9.495n 0.0v 9.505n 0.0v 19.495n 0.0v 19.505n 0.0v 29.495n 0.0v 29.505n 0.0v 39.495n 0.0v 39.505n 0.0v 49.495n 0.0v 49.505n 0.0v 59.495n 0.0v 59.505n 0.0v 69.495n 0.0v 69.505n 0.0v 79.495n 0.0v 79.505n 0.0v 89.495n 0.0v 89.505n 0.0v 99.495n 0.0v 99.505n 0.0v 109.495n 0.0v 109.505n 0.0v 119.495n 0.0v 119.505n 0.0v 129.495n 0.0v 129.505n 0.0v 139.495n 0.0v 139.505n 0.0v 149.495n 0.0v 149.505n 0.0v 159.495n 0.0v 159.505n 0.0v 169.495n 0.0v 169.505n 0.0v 179.495n 0.0v 179.505n 0.0v 189.495n 0.0v 189.505n 0.0v 199.495n 0.0v 199.505n 0.0v 209.495n 0.0v 209.505n 0.0v 219.495n 0.0v 219.505n 0.0v 229.495n 0.0v 229.505n 0.0v 239.495n 0.0v 239.505n 0.0v 249.495n 0.0v 249.505n 0.0v 259.495n 0.0v 259.505n 0.0v 269.495n 0.0v 269.505n 0.0v 279.495n 0.0v 279.505n 0.0v 289.495n 0.0v 289.505n 0.0v 299.495n 0.0v 299.505n 0.0v 309.495n 0.0v 309.505n 0.0v 319.495n 0.0v 319.505n 0.0v 329.495n 0.0v 329.505n 0.0v 339.495n 0.0v 339.505n 0.0v 349.495n 0.0v 349.505n 0.0v 359.495n 0.0v 359.505n 0.0v 369.495n 0.0v 369.505n 0.0v 379.495n 0.0v 379.505n 0.0v 389.495n 0.0v 389.505n 0.0v 399.495n 0.0v 399.505n 0.0v 409.495n 0.0v 409.505n 0.0v 419.495n 0.0v 419.505n 1.95v 429.495n 1.95v 429.505n 0.0v 439.495n 0.0v 439.505n 0.0v 449.495n 0.0v 449.505n 0.0v 459.495n 0.0v 459.505n 1.95v 469.495n 1.95v 469.505n 1.95v 479.495n 1.95v 479.505n 1.95v 489.495n 1.95v 489.505n 1.95v 499.495n 1.95v 499.505n 1.95v 509.495n 1.95v 509.505n 1.95v 519.495n 1.95v 519.505n 1.95v 529.495n 1.95v 529.505n 1.95v 539.495n 1.95v 539.505n 1.95v 549.495n 1.95v 549.505n 1.95v 559.495n 1.95v 559.505n 1.95v 569.495n 1.95v 569.505n 1.95v 579.495n 1.95v 579.505n 1.95v 589.495n 1.95v 589.505n 1.95v 599.495n 1.95v 599.505n 1.95v 609.495n 1.95v 609.505n 1.95v 619.495n 1.95v 619.505n 0.0v 629.495n 0.0v 629.505n 0.0v 639.495n 0.0v 639.505n 0.0v 649.495n 0.0v 649.505n 1.95v 659.495n 1.95v 659.505n 0.0v 669.495n 0.0v 669.505n 0.0v 679.495n 0.0v 679.505n 0.0v 689.495n 0.0v 689.505n 1.95v 699.495n 1.95v 699.505n 1.95v 709.495n 1.95v 709.505n 1.95v 719.495n 1.95v 719.505n 1.95v 729.495n 1.95v 729.505n 1.95v 739.495n 1.95v 739.505n 0.0v 749.495n 0.0v 749.505n 0.0v 759.495n 0.0v 759.505n 0.0v 769.495n 0.0v 769.505n 0.0v 779.495n 0.0v 779.505n 1.95v 789.495n 1.95v 789.505n 1.95v 799.495n 1.95v 799.505n 1.95v 809.495n 1.95v 809.505n 1.95v 819.495n 1.95v 819.505n 1.95v 829.495n 1.95v 829.505n 1.95v 839.495n 1.95v 839.505n 1.95v 849.495n 1.95v 849.505n 0.0v 859.495n 0.0v 859.505n 0.0v 869.495n 0.0v 869.505n 0.0v 879.495n 0.0v 879.505n 1.95v 889.495n 1.95v 889.505n 1.95v 899.495n 1.95v 899.505n 0.0v 909.495n 0.0v 909.505n 0.0v 919.495n 0.0v 919.505n 0.0v 929.495n 0.0v 929.505n 0.0v 939.495n 0.0v 939.505n 0.0v 949.495n 0.0v 949.505n 0.0v 959.495n 0.0v 959.505n 1.95v 969.495n 1.95v 969.505n 1.95v 979.495n 1.95v 979.505n 1.95v 989.495n 1.95v 989.505n 1.95v 999.495n 1.95v 999.505n 1.95v 1009.495n 1.95v 1009.505n 0.0v 1019.495n 0.0v 1019.505n 0.0v 1029.495n 0.0v 1029.505n 0.0v 1039.495n 0.0v 1039.505n 0.0v 1049.495n 0.0v 1049.505n 1.95v 1059.495n 1.95v 1059.505n 1.95v 1069.495n 1.95v 1069.505n 0.0v 1079.495n 0.0v 1079.505n 0.0v 1089.495n 0.0v 1089.505n 1.95v 1099.495n 1.95v 1099.505n 1.95v 1109.495n 1.95v 1109.505n 1.95v 1119.495n 1.95v 1119.505n 1.95v 1129.495n 1.95v 1129.505n 1.95v 1139.495n 1.95v 1139.505n 1.95v 1149.495n 1.95v 1149.505n 1.95v 1159.495n 1.95v 1159.505n 1.95v 1169.495n 1.95v 1169.505n 0.0v 1179.495n 0.0v 1179.505n 1.95v 1189.495n 1.95v 1189.505n 1.95v 1199.495n 1.95v 1199.505n 0.0v 1209.495n 0.0v 1209.505n 0.0v 1219.495n 0.0v 1219.505n 1.95v 1229.495n 1.95v 1229.505n 1.95v 1239.495n 1.95v 1239.505n 1.95v 1249.495n 1.95v 1249.505n 0.0v 1259.495n 0.0v 1259.505n 1.95v 1269.495n 1.95v 1269.505n 1.95v 1279.495n 1.95v 1279.505n 0.0v 1289.495n 0.0v 1289.505n 0.0v 1299.495n 0.0v 1299.505n 1.95v 1309.495n 1.95v 1309.505n 1.95v 1319.495n 1.95v 1319.505n 0.0v 1329.495n 0.0v 1329.505n 0.0v 1339.495n 0.0v 1339.505n 0.0v 1349.495n 0.0v 1349.505n 0.0v 1359.495n 0.0v 1359.505n 1.95v 1369.495n 1.95v 1369.505n 1.95v 1379.495n 1.95v 1379.505n 1.95v 1389.495n 1.95v 1389.505n 1.95v 1399.495n 1.95v 1399.505n 1.95v 1409.495n 1.95v 1409.505n 1.95v 1419.495n 1.95v 1419.505n 0.0v 1429.495n 0.0v 1429.505n 0.0v 1439.495n 0.0v 1439.505n 0.0v 1449.495n 0.0v 1449.505n 0.0v 1459.495n 0.0v 1459.505n 0.0v 1469.495n 0.0v 1469.505n 0.0v 1479.495n 0.0v 1479.505n 0.0v 1489.495n 0.0v 1489.505n 0.0v 1499.495n 0.0v 1499.505n 0.0v 1509.495n 0.0v 1509.505n 0.0v 1519.495n 0.0v 1519.505n 0.0v 1529.495n 0.0v 1529.505n 1.95v 1539.495n 1.95v 1539.505n 0.0v 1549.495n 0.0v 1549.505n 0.0v 1559.495n 0.0v 1559.505n 0.0v 1569.495n 0.0v 1569.505n 1.95v 1579.495n 1.95v 1579.505n 1.95v 1589.495n 1.95v 1589.505n 1.95v 1599.495n 1.95v 1599.505n 1.95v 1609.495n 1.95v 1609.505n 1.95v 1619.495n 1.95v 1619.505n 1.95v 1629.495n 1.95v 1629.505n 1.95v 1639.495n 1.95v 1639.505n 1.95v 1649.495n 1.95v 1649.505n 1.95v 1659.495n 1.95v 1659.505n 0.0v 1669.495n 0.0v 1669.505n 0.0v 1679.495n 0.0v 1679.505n 0.0v 1689.495n 0.0v 1689.505n 0.0v 1699.495n 0.0v 1699.505n 1.95v 1709.495n 1.95v 1709.505n 1.95v 1719.495n 1.95v 1719.505n 1.95v 1729.495n 1.95v 1729.505n 0.0v 1739.495n 0.0v 1739.505n 0.0v 1749.495n 0.0v 1749.505n 1.95v 1759.495n 1.95v 1759.505n 1.95v 1769.495n 1.95v 1769.505n 0.0v 1779.495n 0.0v 1779.505n 0.0v 1789.495n 0.0v 1789.505n 1.95v 1799.495n 1.95v 1799.505n 0.0v 1809.495n 0.0v 1809.505n 0.0v 1819.495n 0.0v 1819.505n 1.95v 1829.495n 1.95v 1829.505n 0.0v 1839.495n 0.0v 1839.505n 0.0v 1849.495n 0.0v 1849.505n 1.95v 1859.495n 1.95v 1859.505n 1.95v 1869.495n 1.95v 1869.505n 1.95v 1879.495n 1.95v 1879.505n 1.95v 1889.495n 1.95v 1889.505n 0.0v 1899.495n 0.0v 1899.505n 0.0v 1909.495n 0.0v 1909.505n 0.0v 1919.495n 0.0v 1919.505n 0.0v 1929.495n 0.0v 1929.505n 0.0v 1939.495n 0.0v 1939.505n 0.0v 1949.495n 0.0v 1949.505n 0.0v 1959.495n 0.0v 1959.505n 0.0v 1969.495n 0.0v 1969.505n 0.0v 1979.495n 0.0v 1979.505n 0.0v 1989.495n 0.0v 1989.505n 0.0v 1999.495n 0.0v 1999.505n 0.0v 2009.495n 0.0v 2009.505n 0.0v 2019.495n 0.0v 2019.505n 0.0v 2029.495n 0.0v 2029.505n 0.0v 2039.495n 0.0v 2039.505n 0.0v 2049.495n 0.0v 2049.505n 0.0v )
* (time, data): [(0, 0), (10, 0), (20, 0), (30, 0), (40, 0), (50, 0), (60, 0), (70, 0), (80, 0), (90, 0), (100, 0), (110, 0), (120, 0), (130, 0), (140, 0), (150, 0), (160, 0), (170, 0), (180, 0), (190, 0), (200, 0), (210, 0), (220, 0), (230, 0), (240, 0), (250, 0), (260, 0), (270, 0), (280, 0), (290, 0), (300, 0), (310, 0), (320, 0), (330, 0), (340, 0), (350, 0), (360, 0), (370, 0), (380, 0), (390, 0), (400, 0), (410, 0), (420, 1), (430, 0), (440, 0), (450, 0), (460, 1), (470, 1), (480, 1), (490, 1), (500, 1), (510, 1), (520, 1), (530, 1), (540, 1), (550, 1), (560, 1), (570, 1), (580, 1), (590, 1), (600, 1), (610, 1), (620, 0), (630, 0), (640, 0), (650, 1), (660, 0), (670, 0), (680, 0), (690, 1), (700, 1), (710, 1), (720, 1), (730, 1), (740, 0), (750, 0), (760, 0), (770, 0), (780, 1), (790, 1), (800, 1), (810, 1), (820, 1), (830, 1), (840, 1), (850, 0), (860, 0), (870, 0), (880, 1), (890, 1), (900, 0), (910, 0), (920, 0), (930, 0), (940, 0), (950, 0), (960, 1), (970, 1), (980, 1), (990, 1), (1000, 1), (1010, 0), (1020, 0), (1030, 0), (1040, 0), (1050, 1), (1060, 1), (1070, 0), (1080, 0), (1090, 1), (1100, 1), (1110, 1), (1120, 1), (1130, 1), (1140, 1), (1150, 1), (1160, 1), (1170, 0), (1180, 1), (1190, 1), (1200, 0), (1210, 0), (1220, 1), (1230, 1), (1240, 1), (1250, 0), (1260, 1), (1270, 1), (1280, 0), (1290, 0), (1300, 1), (1310, 1), (1320, 0), (1330, 0), (1340, 0), (1350, 0), (1360, 1), (1370, 1), (1380, 1), (1390, 1), (1400, 1), (1410, 1), (1420, 0), (1430, 0), (1440, 0), (1450, 0), (1460, 0), (1470, 0), (1480, 0), (1490, 0), (1500, 0), (1510, 0), (1520, 0), (1530, 1), (1540, 0), (1550, 0), (1560, 0), (1570, 1), (1580, 1), (1590, 1), (1600, 1), (1610, 1), (1620, 1), (1630, 1), (1640, 1), (1650, 1), (1660, 0), (1670, 0), (1680, 0), (1690, 0), (1700, 1), (1710, 1), (1720, 1), (1730, 0), (1740, 0), (1750, 1), (1760, 1), (1770, 0), (1780, 0), (1790, 1), (1800, 0), (1810, 0), (1820, 1), (1830, 0), (1840, 0), (1850, 1), (1860, 1), (1870, 1), (1880, 1), (1890, 0), (1900, 0), (1910, 0), (1920, 0), (1930, 0), (1940, 0), (1950, 0), (1960, 0), (1970, 0), (1980, 0), (1990, 0), (2000, 0), (2010, 0), (2020, 0), (2030, 0), (2040, 0), (2050, 0)]
Va1_4  a1_4  0 PWL (0n 0.0v 9.495n 0.0v 9.505n 0.0v 19.495n 0.0v 19.505n 0.0v 29.495n 0.0v 29.505n 0.0v 39.495n 0.0v 39.505n 0.0v 49.495n 0.0v 49.505n 0.0v 59.495n 0.0v 59.505n 0.0v 69.495n 0.0v 69.505n 0.0v 79.495n 0.0v 79.505n 0.0v 89.495n 0.0v 89.505n 0.0v 99.495n 0.0v 99.505n 0.0v 109.495n 0.0v 109.505n 0.0v 119.495n 0.0v 119.505n 0.0v 129.495n 0.0v 129.505n 0.0v 139.495n 0.0v 139.505n 0.0v 149.495n 0.0v 149.505n 0.0v 159.495n 0.0v 159.505n 0.0v 169.495n 0.0v 169.505n 0.0v 179.495n 0.0v 179.505n 0.0v 189.495n 0.0v 189.505n 0.0v 199.495n 0.0v 199.505n 0.0v 209.495n 0.0v 209.505n 0.0v 219.495n 0.0v 219.505n 0.0v 229.495n 0.0v 229.505n 0.0v 239.495n 0.0v 239.505n 0.0v 249.495n 0.0v 249.505n 0.0v 259.495n 0.0v 259.505n 0.0v 269.495n 0.0v 269.505n 0.0v 279.495n 0.0v 279.505n 0.0v 289.495n 0.0v 289.505n 0.0v 299.495n 0.0v 299.505n 0.0v 309.495n 0.0v 309.505n 0.0v 319.495n 0.0v 319.505n 0.0v 329.495n 0.0v 329.505n 0.0v 339.495n 0.0v 339.505n 0.0v 349.495n 0.0v 349.505n 0.0v 359.495n 0.0v 359.505n 0.0v 369.495n 0.0v 369.505n 0.0v 379.495n 0.0v 379.505n 0.0v 389.495n 0.0v 389.505n 0.0v 399.495n 0.0v 399.505n 0.0v 409.495n 0.0v 409.505n 0.0v 419.495n 0.0v 419.505n 1.95v 429.495n 1.95v 429.505n 0.0v 439.495n 0.0v 439.505n 0.0v 449.495n 0.0v 449.505n 0.0v 459.495n 0.0v 459.505n 1.95v 469.495n 1.95v 469.505n 1.95v 479.495n 1.95v 479.505n 1.95v 489.495n 1.95v 489.505n 1.95v 499.495n 1.95v 499.505n 1.95v 509.495n 1.95v 509.505n 1.95v 519.495n 1.95v 519.505n 1.95v 529.495n 1.95v 529.505n 1.95v 539.495n 1.95v 539.505n 1.95v 549.495n 1.95v 549.505n 1.95v 559.495n 1.95v 559.505n 1.95v 569.495n 1.95v 569.505n 1.95v 579.495n 1.95v 579.505n 1.95v 589.495n 1.95v 589.505n 1.95v 599.495n 1.95v 599.505n 1.95v 609.495n 1.95v 609.505n 1.95v 619.495n 1.95v 619.505n 0.0v 629.495n 0.0v 629.505n 0.0v 639.495n 0.0v 639.505n 0.0v 649.495n 0.0v 649.505n 1.95v 659.495n 1.95v 659.505n 0.0v 669.495n 0.0v 669.505n 0.0v 679.495n 0.0v 679.505n 0.0v 689.495n 0.0v 689.505n 1.95v 699.495n 1.95v 699.505n 1.95v 709.495n 1.95v 709.505n 1.95v 719.495n 1.95v 719.505n 1.95v 729.495n 1.95v 729.505n 1.95v 739.495n 1.95v 739.505n 0.0v 749.495n 0.0v 749.505n 0.0v 759.495n 0.0v 759.505n 0.0v 769.495n 0.0v 769.505n 0.0v 779.495n 0.0v 779.505n 1.95v 789.495n 1.95v 789.505n 1.95v 799.495n 1.95v 799.505n 1.95v 809.495n 1.95v 809.505n 1.95v 819.495n 1.95v 819.505n 1.95v 829.495n 1.95v 829.505n 1.95v 839.495n 1.95v 839.505n 1.95v 849.495n 1.95v 849.505n 0.0v 859.495n 0.0v 859.505n 0.0v 869.495n 0.0v 869.505n 0.0v 879.495n 0.0v 879.505n 1.95v 889.495n 1.95v 889.505n 1.95v 899.495n 1.95v 899.505n 0.0v 909.495n 0.0v 909.505n 0.0v 919.495n 0.0v 919.505n 0.0v 929.495n 0.0v 929.505n 0.0v 939.495n 0.0v 939.505n 0.0v 949.495n 0.0v 949.505n 0.0v 959.495n 0.0v 959.505n 1.95v 969.495n 1.95v 969.505n 1.95v 979.495n 1.95v 979.505n 1.95v 989.495n 1.95v 989.505n 1.95v 999.495n 1.95v 999.505n 1.95v 1009.495n 1.95v 1009.505n 0.0v 1019.495n 0.0v 1019.505n 0.0v 1029.495n 0.0v 1029.505n 0.0v 1039.495n 0.0v 1039.505n 0.0v 1049.495n 0.0v 1049.505n 1.95v 1059.495n 1.95v 1059.505n 1.95v 1069.495n 1.95v 1069.505n 0.0v 1079.495n 0.0v 1079.505n 0.0v 1089.495n 0.0v 1089.505n 1.95v 1099.495n 1.95v 1099.505n 1.95v 1109.495n 1.95v 1109.505n 1.95v 1119.495n 1.95v 1119.505n 1.95v 1129.495n 1.95v 1129.505n 1.95v 1139.495n 1.95v 1139.505n 1.95v 1149.495n 1.95v 1149.505n 1.95v 1159.495n 1.95v 1159.505n 1.95v 1169.495n 1.95v 1169.505n 0.0v 1179.495n 0.0v 1179.505n 1.95v 1189.495n 1.95v 1189.505n 1.95v 1199.495n 1.95v 1199.505n 0.0v 1209.495n 0.0v 1209.505n 0.0v 1219.495n 0.0v 1219.505n 1.95v 1229.495n 1.95v 1229.505n 1.95v 1239.495n 1.95v 1239.505n 1.95v 1249.495n 1.95v 1249.505n 0.0v 1259.495n 0.0v 1259.505n 1.95v 1269.495n 1.95v 1269.505n 1.95v 1279.495n 1.95v 1279.505n 0.0v 1289.495n 0.0v 1289.505n 0.0v 1299.495n 0.0v 1299.505n 1.95v 1309.495n 1.95v 1309.505n 1.95v 1319.495n 1.95v 1319.505n 0.0v 1329.495n 0.0v 1329.505n 0.0v 1339.495n 0.0v 1339.505n 0.0v 1349.495n 0.0v 1349.505n 0.0v 1359.495n 0.0v 1359.505n 1.95v 1369.495n 1.95v 1369.505n 1.95v 1379.495n 1.95v 1379.505n 1.95v 1389.495n 1.95v 1389.505n 1.95v 1399.495n 1.95v 1399.505n 1.95v 1409.495n 1.95v 1409.505n 1.95v 1419.495n 1.95v 1419.505n 0.0v 1429.495n 0.0v 1429.505n 0.0v 1439.495n 0.0v 1439.505n 0.0v 1449.495n 0.0v 1449.505n 0.0v 1459.495n 0.0v 1459.505n 0.0v 1469.495n 0.0v 1469.505n 0.0v 1479.495n 0.0v 1479.505n 0.0v 1489.495n 0.0v 1489.505n 0.0v 1499.495n 0.0v 1499.505n 0.0v 1509.495n 0.0v 1509.505n 0.0v 1519.495n 0.0v 1519.505n 0.0v 1529.495n 0.0v 1529.505n 1.95v 1539.495n 1.95v 1539.505n 0.0v 1549.495n 0.0v 1549.505n 0.0v 1559.495n 0.0v 1559.505n 0.0v 1569.495n 0.0v 1569.505n 1.95v 1579.495n 1.95v 1579.505n 1.95v 1589.495n 1.95v 1589.505n 1.95v 1599.495n 1.95v 1599.505n 1.95v 1609.495n 1.95v 1609.505n 1.95v 1619.495n 1.95v 1619.505n 1.95v 1629.495n 1.95v 1629.505n 1.95v 1639.495n 1.95v 1639.505n 1.95v 1649.495n 1.95v 1649.505n 1.95v 1659.495n 1.95v 1659.505n 0.0v 1669.495n 0.0v 1669.505n 0.0v 1679.495n 0.0v 1679.505n 0.0v 1689.495n 0.0v 1689.505n 0.0v 1699.495n 0.0v 1699.505n 1.95v 1709.495n 1.95v 1709.505n 1.95v 1719.495n 1.95v 1719.505n 1.95v 1729.495n 1.95v 1729.505n 0.0v 1739.495n 0.0v 1739.505n 0.0v 1749.495n 0.0v 1749.505n 1.95v 1759.495n 1.95v 1759.505n 1.95v 1769.495n 1.95v 1769.505n 0.0v 1779.495n 0.0v 1779.505n 0.0v 1789.495n 0.0v 1789.505n 1.95v 1799.495n 1.95v 1799.505n 0.0v 1809.495n 0.0v 1809.505n 0.0v 1819.495n 0.0v 1819.505n 1.95v 1829.495n 1.95v 1829.505n 0.0v 1839.495n 0.0v 1839.505n 0.0v 1849.495n 0.0v 1849.505n 1.95v 1859.495n 1.95v 1859.505n 1.95v 1869.495n 1.95v 1869.505n 1.95v 1879.495n 1.95v 1879.505n 1.95v 1889.495n 1.95v 1889.505n 0.0v 1899.495n 0.0v 1899.505n 0.0v 1909.495n 0.0v 1909.505n 0.0v 1919.495n 0.0v 1919.505n 0.0v 1929.495n 0.0v 1929.505n 0.0v 1939.495n 0.0v 1939.505n 0.0v 1949.495n 0.0v 1949.505n 0.0v 1959.495n 0.0v 1959.505n 0.0v 1969.495n 0.0v 1969.505n 0.0v 1979.495n 0.0v 1979.505n 0.0v 1989.495n 0.0v 1989.505n 0.0v 1999.495n 0.0v 1999.505n 0.0v 2009.495n 0.0v 2009.505n 0.0v 2019.495n 0.0v 2019.505n 0.0v 2029.495n 0.0v 2029.505n 0.0v 2039.495n 0.0v 2039.505n 0.0v 2049.495n 0.0v 2049.505n 0.0v )
* (time, data): [(0, 0), (10, 0), (20, 0), (30, 0), (40, 0), (50, 0), (60, 0), (70, 0), (80, 0), (90, 0), (100, 0), (110, 0), (120, 0), (130, 0), (140, 0), (150, 0), (160, 0), (170, 0), (180, 0), (190, 0), (200, 0), (210, 0), (220, 0), (230, 0), (240, 0), (250, 0), (260, 0), (270, 0), (280, 0), (290, 0), (300, 0), (310, 0), (320, 0), (330, 0), (340, 0), (350, 0), (360, 0), (370, 0), (380, 0), (390, 0), (400, 0), (410, 0), (420, 1), (430, 0), (440, 0), (450, 0), (460, 1), (470, 1), (480, 1), (490, 1), (500, 1), (510, 1), (520, 1), (530, 1), (540, 1), (550, 1), (560, 1), (570, 1), (580, 1), (590, 1), (600, 1), (610, 1), (620, 0), (630, 0), (640, 0), (650, 1), (660, 0), (670, 0), (680, 0), (690, 1), (700, 1), (710, 1), (720, 1), (730, 1), (740, 0), (750, 0), (760, 0), (770, 0), (780, 1), (790, 1), (800, 1), (810, 1), (820, 1), (830, 1), (840, 1), (850, 0), (860, 0), (870, 0), (880, 1), (890, 1), (900, 0), (910, 0), (920, 0), (930, 0), (940, 0), (950, 0), (960, 1), (970, 1), (980, 1), (990, 1), (1000, 1), (1010, 0), (1020, 0), (1030, 0), (1040, 0), (1050, 1), (1060, 1), (1070, 0), (1080, 0), (1090, 1), (1100, 1), (1110, 1), (1120, 1), (1130, 1), (1140, 1), (1150, 1), (1160, 1), (1170, 0), (1180, 1), (1190, 1), (1200, 0), (1210, 0), (1220, 1), (1230, 1), (1240, 1), (1250, 0), (1260, 1), (1270, 1), (1280, 0), (1290, 0), (1300, 1), (1310, 1), (1320, 0), (1330, 0), (1340, 0), (1350, 0), (1360, 1), (1370, 1), (1380, 1), (1390, 1), (1400, 1), (1410, 1), (1420, 0), (1430, 0), (1440, 0), (1450, 0), (1460, 0), (1470, 0), (1480, 0), (1490, 0), (1500, 0), (1510, 0), (1520, 0), (1530, 1), (1540, 0), (1550, 0), (1560, 0), (1570, 1), (1580, 1), (1590, 1), (1600, 1), (1610, 1), (1620, 1), (1630, 1), (1640, 1), (1650, 1), (1660, 0), (1670, 0), (1680, 0), (1690, 0), (1700, 1), (1710, 1), (1720, 1), (1730, 0), (1740, 0), (1750, 1), (1760, 1), (1770, 0), (1780, 0), (1790, 1), (1800, 0), (1810, 0), (1820, 1), (1830, 0), (1840, 0), (1850, 1), (1860, 1), (1870, 1), (1880, 1), (1890, 0), (1900, 0), (1910, 0), (1920, 0), (1930, 0), (1940, 0), (1950, 0), (1960, 0), (1970, 0), (1980, 0), (1990, 0), (2000, 0), (2010, 0), (2020, 0), (2030, 0), (2040, 0), (2050, 0)]
Va1_5  a1_5  0 PWL (0n 0.0v 9.495n 0.0v 9.505n 0.0v 19.495n 0.0v 19.505n 0.0v 29.495n 0.0v 29.505n 0.0v 39.495n 0.0v 39.505n 0.0v 49.495n 0.0v 49.505n 0.0v 59.495n 0.0v 59.505n 0.0v 69.495n 0.0v 69.505n 0.0v 79.495n 0.0v 79.505n 0.0v 89.495n 0.0v 89.505n 0.0v 99.495n 0.0v 99.505n 0.0v 109.495n 0.0v 109.505n 0.0v 119.495n 0.0v 119.505n 0.0v 129.495n 0.0v 129.505n 0.0v 139.495n 0.0v 139.505n 0.0v 149.495n 0.0v 149.505n 0.0v 159.495n 0.0v 159.505n 0.0v 169.495n 0.0v 169.505n 0.0v 179.495n 0.0v 179.505n 0.0v 189.495n 0.0v 189.505n 0.0v 199.495n 0.0v 199.505n 0.0v 209.495n 0.0v 209.505n 0.0v 219.495n 0.0v 219.505n 0.0v 229.495n 0.0v 229.505n 0.0v 239.495n 0.0v 239.505n 0.0v 249.495n 0.0v 249.505n 0.0v 259.495n 0.0v 259.505n 0.0v 269.495n 0.0v 269.505n 0.0v 279.495n 0.0v 279.505n 0.0v 289.495n 0.0v 289.505n 0.0v 299.495n 0.0v 299.505n 0.0v 309.495n 0.0v 309.505n 0.0v 319.495n 0.0v 319.505n 0.0v 329.495n 0.0v 329.505n 0.0v 339.495n 0.0v 339.505n 0.0v 349.495n 0.0v 349.505n 0.0v 359.495n 0.0v 359.505n 0.0v 369.495n 0.0v 369.505n 0.0v 379.495n 0.0v 379.505n 0.0v 389.495n 0.0v 389.505n 0.0v 399.495n 0.0v 399.505n 0.0v 409.495n 0.0v 409.505n 0.0v 419.495n 0.0v 419.505n 1.95v 429.495n 1.95v 429.505n 0.0v 439.495n 0.0v 439.505n 0.0v 449.495n 0.0v 449.505n 0.0v 459.495n 0.0v 459.505n 1.95v 469.495n 1.95v 469.505n 1.95v 479.495n 1.95v 479.505n 1.95v 489.495n 1.95v 489.505n 1.95v 499.495n 1.95v 499.505n 1.95v 509.495n 1.95v 509.505n 1.95v 519.495n 1.95v 519.505n 1.95v 529.495n 1.95v 529.505n 1.95v 539.495n 1.95v 539.505n 1.95v 549.495n 1.95v 549.505n 1.95v 559.495n 1.95v 559.505n 1.95v 569.495n 1.95v 569.505n 1.95v 579.495n 1.95v 579.505n 1.95v 589.495n 1.95v 589.505n 1.95v 599.495n 1.95v 599.505n 1.95v 609.495n 1.95v 609.505n 1.95v 619.495n 1.95v 619.505n 0.0v 629.495n 0.0v 629.505n 0.0v 639.495n 0.0v 639.505n 0.0v 649.495n 0.0v 649.505n 1.95v 659.495n 1.95v 659.505n 0.0v 669.495n 0.0v 669.505n 0.0v 679.495n 0.0v 679.505n 0.0v 689.495n 0.0v 689.505n 1.95v 699.495n 1.95v 699.505n 1.95v 709.495n 1.95v 709.505n 1.95v 719.495n 1.95v 719.505n 1.95v 729.495n 1.95v 729.505n 1.95v 739.495n 1.95v 739.505n 0.0v 749.495n 0.0v 749.505n 0.0v 759.495n 0.0v 759.505n 0.0v 769.495n 0.0v 769.505n 0.0v 779.495n 0.0v 779.505n 1.95v 789.495n 1.95v 789.505n 1.95v 799.495n 1.95v 799.505n 1.95v 809.495n 1.95v 809.505n 1.95v 819.495n 1.95v 819.505n 1.95v 829.495n 1.95v 829.505n 1.95v 839.495n 1.95v 839.505n 1.95v 849.495n 1.95v 849.505n 0.0v 859.495n 0.0v 859.505n 0.0v 869.495n 0.0v 869.505n 0.0v 879.495n 0.0v 879.505n 1.95v 889.495n 1.95v 889.505n 1.95v 899.495n 1.95v 899.505n 0.0v 909.495n 0.0v 909.505n 0.0v 919.495n 0.0v 919.505n 0.0v 929.495n 0.0v 929.505n 0.0v 939.495n 0.0v 939.505n 0.0v 949.495n 0.0v 949.505n 0.0v 959.495n 0.0v 959.505n 1.95v 969.495n 1.95v 969.505n 1.95v 979.495n 1.95v 979.505n 1.95v 989.495n 1.95v 989.505n 1.95v 999.495n 1.95v 999.505n 1.95v 1009.495n 1.95v 1009.505n 0.0v 1019.495n 0.0v 1019.505n 0.0v 1029.495n 0.0v 1029.505n 0.0v 1039.495n 0.0v 1039.505n 0.0v 1049.495n 0.0v 1049.505n 1.95v 1059.495n 1.95v 1059.505n 1.95v 1069.495n 1.95v 1069.505n 0.0v 1079.495n 0.0v 1079.505n 0.0v 1089.495n 0.0v 1089.505n 1.95v 1099.495n 1.95v 1099.505n 1.95v 1109.495n 1.95v 1109.505n 1.95v 1119.495n 1.95v 1119.505n 1.95v 1129.495n 1.95v 1129.505n 1.95v 1139.495n 1.95v 1139.505n 1.95v 1149.495n 1.95v 1149.505n 1.95v 1159.495n 1.95v 1159.505n 1.95v 1169.495n 1.95v 1169.505n 0.0v 1179.495n 0.0v 1179.505n 1.95v 1189.495n 1.95v 1189.505n 1.95v 1199.495n 1.95v 1199.505n 0.0v 1209.495n 0.0v 1209.505n 0.0v 1219.495n 0.0v 1219.505n 1.95v 1229.495n 1.95v 1229.505n 1.95v 1239.495n 1.95v 1239.505n 1.95v 1249.495n 1.95v 1249.505n 0.0v 1259.495n 0.0v 1259.505n 1.95v 1269.495n 1.95v 1269.505n 1.95v 1279.495n 1.95v 1279.505n 0.0v 1289.495n 0.0v 1289.505n 0.0v 1299.495n 0.0v 1299.505n 1.95v 1309.495n 1.95v 1309.505n 1.95v 1319.495n 1.95v 1319.505n 0.0v 1329.495n 0.0v 1329.505n 0.0v 1339.495n 0.0v 1339.505n 0.0v 1349.495n 0.0v 1349.505n 0.0v 1359.495n 0.0v 1359.505n 1.95v 1369.495n 1.95v 1369.505n 1.95v 1379.495n 1.95v 1379.505n 1.95v 1389.495n 1.95v 1389.505n 1.95v 1399.495n 1.95v 1399.505n 1.95v 1409.495n 1.95v 1409.505n 1.95v 1419.495n 1.95v 1419.505n 0.0v 1429.495n 0.0v 1429.505n 0.0v 1439.495n 0.0v 1439.505n 0.0v 1449.495n 0.0v 1449.505n 0.0v 1459.495n 0.0v 1459.505n 0.0v 1469.495n 0.0v 1469.505n 0.0v 1479.495n 0.0v 1479.505n 0.0v 1489.495n 0.0v 1489.505n 0.0v 1499.495n 0.0v 1499.505n 0.0v 1509.495n 0.0v 1509.505n 0.0v 1519.495n 0.0v 1519.505n 0.0v 1529.495n 0.0v 1529.505n 1.95v 1539.495n 1.95v 1539.505n 0.0v 1549.495n 0.0v 1549.505n 0.0v 1559.495n 0.0v 1559.505n 0.0v 1569.495n 0.0v 1569.505n 1.95v 1579.495n 1.95v 1579.505n 1.95v 1589.495n 1.95v 1589.505n 1.95v 1599.495n 1.95v 1599.505n 1.95v 1609.495n 1.95v 1609.505n 1.95v 1619.495n 1.95v 1619.505n 1.95v 1629.495n 1.95v 1629.505n 1.95v 1639.495n 1.95v 1639.505n 1.95v 1649.495n 1.95v 1649.505n 1.95v 1659.495n 1.95v 1659.505n 0.0v 1669.495n 0.0v 1669.505n 0.0v 1679.495n 0.0v 1679.505n 0.0v 1689.495n 0.0v 1689.505n 0.0v 1699.495n 0.0v 1699.505n 1.95v 1709.495n 1.95v 1709.505n 1.95v 1719.495n 1.95v 1719.505n 1.95v 1729.495n 1.95v 1729.505n 0.0v 1739.495n 0.0v 1739.505n 0.0v 1749.495n 0.0v 1749.505n 1.95v 1759.495n 1.95v 1759.505n 1.95v 1769.495n 1.95v 1769.505n 0.0v 1779.495n 0.0v 1779.505n 0.0v 1789.495n 0.0v 1789.505n 1.95v 1799.495n 1.95v 1799.505n 0.0v 1809.495n 0.0v 1809.505n 0.0v 1819.495n 0.0v 1819.505n 1.95v 1829.495n 1.95v 1829.505n 0.0v 1839.495n 0.0v 1839.505n 0.0v 1849.495n 0.0v 1849.505n 1.95v 1859.495n 1.95v 1859.505n 1.95v 1869.495n 1.95v 1869.505n 1.95v 1879.495n 1.95v 1879.505n 1.95v 1889.495n 1.95v 1889.505n 0.0v 1899.495n 0.0v 1899.505n 0.0v 1909.495n 0.0v 1909.505n 0.0v 1919.495n 0.0v 1919.505n 0.0v 1929.495n 0.0v 1929.505n 0.0v 1939.495n 0.0v 1939.505n 0.0v 1949.495n 0.0v 1949.505n 0.0v 1959.495n 0.0v 1959.505n 0.0v 1969.495n 0.0v 1969.505n 0.0v 1979.495n 0.0v 1979.505n 0.0v 1989.495n 0.0v 1989.505n 0.0v 1999.495n 0.0v 1999.505n 0.0v 2009.495n 0.0v 2009.505n 0.0v 2019.495n 0.0v 2019.505n 0.0v 2029.495n 0.0v 2029.505n 0.0v 2039.495n 0.0v 2039.505n 0.0v 2049.495n 0.0v 2049.505n 0.0v )

 * Generation of control signals
* (time, data): [(0, 1), (10, 0), (20, 0), (30, 0), (40, 0), (50, 0), (60, 0), (70, 0), (80, 0), (90, 0), (100, 1), (110, 0), (120, 0), (130, 1), (140, 0), (150, 1), (160, 0), (170, 0), (180, 0), (190, 0), (200, 0), (210, 0), (220, 1), (230, 1), (240, 0), (250, 1), (260, 1), (270, 0), (280, 0), (290, 0), (300, 0), (310, 1), (320, 1), (330, 1), (340, 0), (350, 0), (360, 0), (370, 0), (380, 1), (390, 1), (400, 0), (410, 1), (420, 0), (430, 0), (440, 0), (450, 1), (460, 0), (470, 0), (480, 1), (490, 0), (500, 0), (510, 0), (520, 0), (530, 1), (540, 0), (550, 0), (560, 0), (570, 1), (580, 0), (590, 0), (600, 0), (610, 0), (620, 0), (630, 1), (640, 0), (650, 0), (660, 0), (670, 0), (680, 0), (690, 0), (700, 0), (710, 1), (720, 1), (730, 0), (740, 0), (750, 0), (760, 0), (770, 0), (780, 0), (790, 0), (800, 1), (810, 0), (820, 0), (830, 0), (840, 1), (850, 0), (860, 0), (870, 1), (880, 0), (890, 0), (900, 0), (910, 0), (920, 0), (930, 0), (940, 0), (950, 0), (960, 0), (970, 0), (980, 0), (990, 0), (1000, 0), (1010, 0), (1020, 0), (1030, 0), (1040, 1), (1050, 0), (1060, 1), (1070, 0), (1080, 1), (1090, 0), (1100, 1), (1110, 0), (1120, 0), (1130, 0), (1140, 0), (1150, 0), (1160, 0), (1170, 0), (1180, 1), (1190, 0), (1200, 0), (1210, 0), (1220, 1), (1230, 0), (1240, 0), (1250, 0), (1260, 1), (1270, 0), (1280, 0), (1290, 0), (1300, 0), (1310, 1), (1320, 0), (1330, 0), (1340, 0), (1350, 0), (1360, 1), (1370, 0), (1380, 0), (1390, 0), (1400, 0), (1410, 0), (1420, 0), (1430, 1), (1440, 0), (1450, 0), (1460, 0), (1470, 1), (1480, 0), (1490, 0), (1500, 0), (1510, 0), (1520, 1), (1530, 0), (1540, 1), (1550, 0), (1560, 0), (1570, 0), (1580, 0), (1590, 0), (1600, 0), (1610, 0), (1620, 0), (1630, 0), (1640, 1), (1650, 0), (1660, 0), (1670, 0), (1680, 0), (1690, 0), (1700, 0), (1710, 1), (1720, 0), (1730, 0), (1740, 0), (1750, 0), (1760, 0), (1770, 1), (1780, 1), (1790, 1), (1800, 0), (1810, 0), (1820, 0), (1830, 1), (1840, 0), (1850, 0), (1860, 0), (1870, 1), (1880, 1), (1890, 0), (1900, 0), (1910, 1), (1920, 0), (1930, 1), (1940, 0), (1950, 0), (1960, 0), (1970, 0), (1980, 1), (1990, 0), (2000, 0), (2010, 0), (2020, 0), (2030, 0), (2040, 0), (2050, 1)]
VCSB0 CSB0 0 PWL (0n 1.95v 9.495n 1.95v 9.505n 0.0v 19.495n 0.0v 19.505n 0.0v 29.495n 0.0v 29.505n 0.0v 39.495n 0.0v 39.505n 0.0v 49.495n 0.0v 49.505n 0.0v 59.495n 0.0v 59.505n 0.0v 69.495n 0.0v 69.505n 0.0v 79.495n 0.0v 79.505n 0.0v 89.495n 0.0v 89.505n 0.0v 99.495n 0.0v 99.505n 1.95v 109.495n 1.95v 109.505n 0.0v 119.495n 0.0v 119.505n 0.0v 129.495n 0.0v 129.505n 1.95v 139.495n 1.95v 139.505n 0.0v 149.495n 0.0v 149.505n 1.95v 159.495n 1.95v 159.505n 0.0v 169.495n 0.0v 169.505n 0.0v 179.495n 0.0v 179.505n 0.0v 189.495n 0.0v 189.505n 0.0v 199.495n 0.0v 199.505n 0.0v 209.495n 0.0v 209.505n 0.0v 219.495n 0.0v 219.505n 1.95v 229.495n 1.95v 229.505n 1.95v 239.495n 1.95v 239.505n 0.0v 249.495n 0.0v 249.505n 1.95v 259.495n 1.95v 259.505n 1.95v 269.495n 1.95v 269.505n 0.0v 279.495n 0.0v 279.505n 0.0v 289.495n 0.0v 289.505n 0.0v 299.495n 0.0v 299.505n 0.0v 309.495n 0.0v 309.505n 1.95v 319.495n 1.95v 319.505n 1.95v 329.495n 1.95v 329.505n 1.95v 339.495n 1.95v 339.505n 0.0v 349.495n 0.0v 349.505n 0.0v 359.495n 0.0v 359.505n 0.0v 369.495n 0.0v 369.505n 0.0v 379.495n 0.0v 379.505n 1.95v 389.495n 1.95v 389.505n 1.95v 399.495n 1.95v 399.505n 0.0v 409.495n 0.0v 409.505n 1.95v 419.495n 1.95v 419.505n 0.0v 429.495n 0.0v 429.505n 0.0v 439.495n 0.0v 439.505n 0.0v 449.495n 0.0v 449.505n 1.95v 459.495n 1.95v 459.505n 0.0v 469.495n 0.0v 469.505n 0.0v 479.495n 0.0v 479.505n 1.95v 489.495n 1.95v 489.505n 0.0v 499.495n 0.0v 499.505n 0.0v 509.495n 0.0v 509.505n 0.0v 519.495n 0.0v 519.505n 0.0v 529.495n 0.0v 529.505n 1.95v 539.495n 1.95v 539.505n 0.0v 549.495n 0.0v 549.505n 0.0v 559.495n 0.0v 559.505n 0.0v 569.495n 0.0v 569.505n 1.95v 579.495n 1.95v 579.505n 0.0v 589.495n 0.0v 589.505n 0.0v 599.495n 0.0v 599.505n 0.0v 609.495n 0.0v 609.505n 0.0v 619.495n 0.0v 619.505n 0.0v 629.495n 0.0v 629.505n 1.95v 639.495n 1.95v 639.505n 0.0v 649.495n 0.0v 649.505n 0.0v 659.495n 0.0v 659.505n 0.0v 669.495n 0.0v 669.505n 0.0v 679.495n 0.0v 679.505n 0.0v 689.495n 0.0v 689.505n 0.0v 699.495n 0.0v 699.505n 0.0v 709.495n 0.0v 709.505n 1.95v 719.495n 1.95v 719.505n 1.95v 729.495n 1.95v 729.505n 0.0v 739.495n 0.0v 739.505n 0.0v 749.495n 0.0v 749.505n 0.0v 759.495n 0.0v 759.505n 0.0v 769.495n 0.0v 769.505n 0.0v 779.495n 0.0v 779.505n 0.0v 789.495n 0.0v 789.505n 0.0v 799.495n 0.0v 799.505n 1.95v 809.495n 1.95v 809.505n 0.0v 819.495n 0.0v 819.505n 0.0v 829.495n 0.0v 829.505n 0.0v 839.495n 0.0v 839.505n 1.95v 849.495n 1.95v 849.505n 0.0v 859.495n 0.0v 859.505n 0.0v 869.495n 0.0v 869.505n 1.95v 879.495n 1.95v 879.505n 0.0v 889.495n 0.0v 889.505n 0.0v 899.495n 0.0v 899.505n 0.0v 909.495n 0.0v 909.505n 0.0v 919.495n 0.0v 919.505n 0.0v 929.495n 0.0v 929.505n 0.0v 939.495n 0.0v 939.505n 0.0v 949.495n 0.0v 949.505n 0.0v 959.495n 0.0v 959.505n 0.0v 969.495n 0.0v 969.505n 0.0v 979.495n 0.0v 979.505n 0.0v 989.495n 0.0v 989.505n 0.0v 999.495n 0.0v 999.505n 0.0v 1009.495n 0.0v 1009.505n 0.0v 1019.495n 0.0v 1019.505n 0.0v 1029.495n 0.0v 1029.505n 0.0v 1039.495n 0.0v 1039.505n 1.95v 1049.495n 1.95v 1049.505n 0.0v 1059.495n 0.0v 1059.505n 1.95v 1069.495n 1.95v 1069.505n 0.0v 1079.495n 0.0v 1079.505n 1.95v 1089.495n 1.95v 1089.505n 0.0v 1099.495n 0.0v 1099.505n 1.95v 1109.495n 1.95v 1109.505n 0.0v 1119.495n 0.0v 1119.505n 0.0v 1129.495n 0.0v 1129.505n 0.0v 1139.495n 0.0v 1139.505n 0.0v 1149.495n 0.0v 1149.505n 0.0v 1159.495n 0.0v 1159.505n 0.0v 1169.495n 0.0v 1169.505n 0.0v 1179.495n 0.0v 1179.505n 1.95v 1189.495n 1.95v 1189.505n 0.0v 1199.495n 0.0v 1199.505n 0.0v 1209.495n 0.0v 1209.505n 0.0v 1219.495n 0.0v 1219.505n 1.95v 1229.495n 1.95v 1229.505n 0.0v 1239.495n 0.0v 1239.505n 0.0v 1249.495n 0.0v 1249.505n 0.0v 1259.495n 0.0v 1259.505n 1.95v 1269.495n 1.95v 1269.505n 0.0v 1279.495n 0.0v 1279.505n 0.0v 1289.495n 0.0v 1289.505n 0.0v 1299.495n 0.0v 1299.505n 0.0v 1309.495n 0.0v 1309.505n 1.95v 1319.495n 1.95v 1319.505n 0.0v 1329.495n 0.0v 1329.505n 0.0v 1339.495n 0.0v 1339.505n 0.0v 1349.495n 0.0v 1349.505n 0.0v 1359.495n 0.0v 1359.505n 1.95v 1369.495n 1.95v 1369.505n 0.0v 1379.495n 0.0v 1379.505n 0.0v 1389.495n 0.0v 1389.505n 0.0v 1399.495n 0.0v 1399.505n 0.0v 1409.495n 0.0v 1409.505n 0.0v 1419.495n 0.0v 1419.505n 0.0v 1429.495n 0.0v 1429.505n 1.95v 1439.495n 1.95v 1439.505n 0.0v 1449.495n 0.0v 1449.505n 0.0v 1459.495n 0.0v 1459.505n 0.0v 1469.495n 0.0v 1469.505n 1.95v 1479.495n 1.95v 1479.505n 0.0v 1489.495n 0.0v 1489.505n 0.0v 1499.495n 0.0v 1499.505n 0.0v 1509.495n 0.0v 1509.505n 0.0v 1519.495n 0.0v 1519.505n 1.95v 1529.495n 1.95v 1529.505n 0.0v 1539.495n 0.0v 1539.505n 1.95v 1549.495n 1.95v 1549.505n 0.0v 1559.495n 0.0v 1559.505n 0.0v 1569.495n 0.0v 1569.505n 0.0v 1579.495n 0.0v 1579.505n 0.0v 1589.495n 0.0v 1589.505n 0.0v 1599.495n 0.0v 1599.505n 0.0v 1609.495n 0.0v 1609.505n 0.0v 1619.495n 0.0v 1619.505n 0.0v 1629.495n 0.0v 1629.505n 0.0v 1639.495n 0.0v 1639.505n 1.95v 1649.495n 1.95v 1649.505n 0.0v 1659.495n 0.0v 1659.505n 0.0v 1669.495n 0.0v 1669.505n 0.0v 1679.495n 0.0v 1679.505n 0.0v 1689.495n 0.0v 1689.505n 0.0v 1699.495n 0.0v 1699.505n 0.0v 1709.495n 0.0v 1709.505n 1.95v 1719.495n 1.95v 1719.505n 0.0v 1729.495n 0.0v 1729.505n 0.0v 1739.495n 0.0v 1739.505n 0.0v 1749.495n 0.0v 1749.505n 0.0v 1759.495n 0.0v 1759.505n 0.0v 1769.495n 0.0v 1769.505n 1.95v 1779.495n 1.95v 1779.505n 1.95v 1789.495n 1.95v 1789.505n 1.95v 1799.495n 1.95v 1799.505n 0.0v 1809.495n 0.0v 1809.505n 0.0v 1819.495n 0.0v 1819.505n 0.0v 1829.495n 0.0v 1829.505n 1.95v 1839.495n 1.95v 1839.505n 0.0v 1849.495n 0.0v 1849.505n 0.0v 1859.495n 0.0v 1859.505n 0.0v 1869.495n 0.0v 1869.505n 1.95v 1879.495n 1.95v 1879.505n 1.95v 1889.495n 1.95v 1889.505n 0.0v 1899.495n 0.0v 1899.505n 0.0v 1909.495n 0.0v 1909.505n 1.95v 1919.495n 1.95v 1919.505n 0.0v 1929.495n 0.0v 1929.505n 1.95v 1939.495n 1.95v 1939.505n 0.0v 1949.495n 0.0v 1949.505n 0.0v 1959.495n 0.0v 1959.505n 0.0v 1969.495n 0.0v 1969.505n 0.0v 1979.495n 0.0v 1979.505n 1.95v 1989.495n 1.95v 1989.505n 0.0v 1999.495n 0.0v 1999.505n 0.0v 2009.495n 0.0v 2009.505n 0.0v 2019.495n 0.0v 2019.505n 0.0v 2029.495n 0.0v 2029.505n 0.0v 2039.495n 0.0v 2039.505n 0.0v 2049.495n 0.0v 2049.505n 1.95v )
* (time, data): [(0, 1), (10, 1), (20, 1), (30, 1), (40, 0), (50, 0), (60, 1), (70, 1), (80, 1), (90, 0), (100, 1), (110, 1), (120, 0), (130, 0), (140, 0), (150, 0), (160, 1), (170, 0), (180, 0), (190, 1), (200, 0), (210, 0), (220, 1), (230, 1), (240, 1), (250, 0), (260, 1), (270, 1), (280, 1), (290, 0), (300, 1), (310, 0), (320, 0), (330, 1), (340, 1), (350, 1), (360, 1), (370, 0), (380, 0), (390, 1), (400, 1), (410, 1), (420, 0), (430, 0), (440, 0), (450, 1), (460, 0), (470, 1), (480, 1), (490, 1), (500, 1), (510, 0), (520, 1), (530, 1), (540, 1), (550, 1), (560, 1), (570, 1), (580, 0), (590, 1), (600, 0), (610, 1), (620, 0), (630, 0), (640, 1), (650, 0), (660, 0), (670, 1), (680, 1), (690, 0), (700, 0), (710, 1), (720, 1), (730, 1), (740, 0), (750, 1), (760, 1), (770, 1), (780, 0), (790, 1), (800, 1), (810, 1), (820, 0), (830, 0), (840, 1), (850, 0), (860, 0), (870, 0), (880, 0), (890, 0), (900, 0), (910, 1), (920, 0), (930, 0), (940, 1), (950, 1), (960, 0), (970, 1), (980, 1), (990, 1), (1000, 1), (1010, 0), (1020, 0), (1030, 1), (1040, 0), (1050, 0), (1060, 1), (1070, 0), (1080, 1), (1090, 0), (1100, 1), (1110, 0), (1120, 0), (1130, 0), (1140, 1), (1150, 0), (1160, 0), (1170, 0), (1180, 0), (1190, 1), (1200, 0), (1210, 0), (1220, 0), (1230, 0), (1240, 0), (1250, 0), (1260, 0), (1270, 0), (1280, 0), (1290, 1), (1300, 0), (1310, 0), (1320, 0), (1330, 1), (1340, 1), (1350, 1), (1360, 0), (1370, 0), (1380, 1), (1390, 1), (1400, 1), (1410, 0), (1420, 0), (1430, 1), (1440, 1), (1450, 1), (1460, 1), (1470, 0), (1480, 1), (1490, 1), (1500, 1), (1510, 1), (1520, 1), (1530, 0), (1540, 0), (1550, 1), (1560, 1), (1570, 0), (1580, 1), (1590, 1), (1600, 1), (1610, 1), (1620, 0), (1630, 1), (1640, 1), (1650, 0), (1660, 0), (1670, 1), (1680, 1), (1690, 1), (1700, 0), (1710, 1), (1720, 1), (1730, 0), (1740, 1), (1750, 0), (1760, 1), (1770, 0), (1780, 0), (1790, 0), (1800, 0), (1810, 0), (1820, 0), (1830, 0), (1840, 1), (1850, 0), (1860, 1), (1870, 1), (1880, 0), (1890, 0), (1900, 0), (1910, 1), (1920, 0), (1930, 1), (1940, 1), (1950, 0), (1960, 1), (1970, 1), (1980, 0), (1990, 1), (2000, 1), (2010, 1), (2020, 0), (2030, 1), (2040, 0), (2050, 1)]
VCSB1 CSB1 0 PWL (0n 1.95v 9.495n 1.95v 9.505n 1.95v 19.495n 1.95v 19.505n 1.95v 29.495n 1.95v 29.505n 1.95v 39.495n 1.95v 39.505n 0.0v 49.495n 0.0v 49.505n 0.0v 59.495n 0.0v 59.505n 1.95v 69.495n 1.95v 69.505n 1.95v 79.495n 1.95v 79.505n 1.95v 89.495n 1.95v 89.505n 0.0v 99.495n 0.0v 99.505n 1.95v 109.495n 1.95v 109.505n 1.95v 119.495n 1.95v 119.505n 0.0v 129.495n 0.0v 129.505n 0.0v 139.495n 0.0v 139.505n 0.0v 149.495n 0.0v 149.505n 0.0v 159.495n 0.0v 159.505n 1.95v 169.495n 1.95v 169.505n 0.0v 179.495n 0.0v 179.505n 0.0v 189.495n 0.0v 189.505n 1.95v 199.495n 1.95v 199.505n 0.0v 209.495n 0.0v 209.505n 0.0v 219.495n 0.0v 219.505n 1.95v 229.495n 1.95v 229.505n 1.95v 239.495n 1.95v 239.505n 1.95v 249.495n 1.95v 249.505n 0.0v 259.495n 0.0v 259.505n 1.95v 269.495n 1.95v 269.505n 1.95v 279.495n 1.95v 279.505n 1.95v 289.495n 1.95v 289.505n 0.0v 299.495n 0.0v 299.505n 1.95v 309.495n 1.95v 309.505n 0.0v 319.495n 0.0v 319.505n 0.0v 329.495n 0.0v 329.505n 1.95v 339.495n 1.95v 339.505n 1.95v 349.495n 1.95v 349.505n 1.95v 359.495n 1.95v 359.505n 1.95v 369.495n 1.95v 369.505n 0.0v 379.495n 0.0v 379.505n 0.0v 389.495n 0.0v 389.505n 1.95v 399.495n 1.95v 399.505n 1.95v 409.495n 1.95v 409.505n 1.95v 419.495n 1.95v 419.505n 0.0v 429.495n 0.0v 429.505n 0.0v 439.495n 0.0v 439.505n 0.0v 449.495n 0.0v 449.505n 1.95v 459.495n 1.95v 459.505n 0.0v 469.495n 0.0v 469.505n 1.95v 479.495n 1.95v 479.505n 1.95v 489.495n 1.95v 489.505n 1.95v 499.495n 1.95v 499.505n 1.95v 509.495n 1.95v 509.505n 0.0v 519.495n 0.0v 519.505n 1.95v 529.495n 1.95v 529.505n 1.95v 539.495n 1.95v 539.505n 1.95v 549.495n 1.95v 549.505n 1.95v 559.495n 1.95v 559.505n 1.95v 569.495n 1.95v 569.505n 1.95v 579.495n 1.95v 579.505n 0.0v 589.495n 0.0v 589.505n 1.95v 599.495n 1.95v 599.505n 0.0v 609.495n 0.0v 609.505n 1.95v 619.495n 1.95v 619.505n 0.0v 629.495n 0.0v 629.505n 0.0v 639.495n 0.0v 639.505n 1.95v 649.495n 1.95v 649.505n 0.0v 659.495n 0.0v 659.505n 0.0v 669.495n 0.0v 669.505n 1.95v 679.495n 1.95v 679.505n 1.95v 689.495n 1.95v 689.505n 0.0v 699.495n 0.0v 699.505n 0.0v 709.495n 0.0v 709.505n 1.95v 719.495n 1.95v 719.505n 1.95v 729.495n 1.95v 729.505n 1.95v 739.495n 1.95v 739.505n 0.0v 749.495n 0.0v 749.505n 1.95v 759.495n 1.95v 759.505n 1.95v 769.495n 1.95v 769.505n 1.95v 779.495n 1.95v 779.505n 0.0v 789.495n 0.0v 789.505n 1.95v 799.495n 1.95v 799.505n 1.95v 809.495n 1.95v 809.505n 1.95v 819.495n 1.95v 819.505n 0.0v 829.495n 0.0v 829.505n 0.0v 839.495n 0.0v 839.505n 1.95v 849.495n 1.95v 849.505n 0.0v 859.495n 0.0v 859.505n 0.0v 869.495n 0.0v 869.505n 0.0v 879.495n 0.0v 879.505n 0.0v 889.495n 0.0v 889.505n 0.0v 899.495n 0.0v 899.505n 0.0v 909.495n 0.0v 909.505n 1.95v 919.495n 1.95v 919.505n 0.0v 929.495n 0.0v 929.505n 0.0v 939.495n 0.0v 939.505n 1.95v 949.495n 1.95v 949.505n 1.95v 959.495n 1.95v 959.505n 0.0v 969.495n 0.0v 969.505n 1.95v 979.495n 1.95v 979.505n 1.95v 989.495n 1.95v 989.505n 1.95v 999.495n 1.95v 999.505n 1.95v 1009.495n 1.95v 1009.505n 0.0v 1019.495n 0.0v 1019.505n 0.0v 1029.495n 0.0v 1029.505n 1.95v 1039.495n 1.95v 1039.505n 0.0v 1049.495n 0.0v 1049.505n 0.0v 1059.495n 0.0v 1059.505n 1.95v 1069.495n 1.95v 1069.505n 0.0v 1079.495n 0.0v 1079.505n 1.95v 1089.495n 1.95v 1089.505n 0.0v 1099.495n 0.0v 1099.505n 1.95v 1109.495n 1.95v 1109.505n 0.0v 1119.495n 0.0v 1119.505n 0.0v 1129.495n 0.0v 1129.505n 0.0v 1139.495n 0.0v 1139.505n 1.95v 1149.495n 1.95v 1149.505n 0.0v 1159.495n 0.0v 1159.505n 0.0v 1169.495n 0.0v 1169.505n 0.0v 1179.495n 0.0v 1179.505n 0.0v 1189.495n 0.0v 1189.505n 1.95v 1199.495n 1.95v 1199.505n 0.0v 1209.495n 0.0v 1209.505n 0.0v 1219.495n 0.0v 1219.505n 0.0v 1229.495n 0.0v 1229.505n 0.0v 1239.495n 0.0v 1239.505n 0.0v 1249.495n 0.0v 1249.505n 0.0v 1259.495n 0.0v 1259.505n 0.0v 1269.495n 0.0v 1269.505n 0.0v 1279.495n 0.0v 1279.505n 0.0v 1289.495n 0.0v 1289.505n 1.95v 1299.495n 1.95v 1299.505n 0.0v 1309.495n 0.0v 1309.505n 0.0v 1319.495n 0.0v 1319.505n 0.0v 1329.495n 0.0v 1329.505n 1.95v 1339.495n 1.95v 1339.505n 1.95v 1349.495n 1.95v 1349.505n 1.95v 1359.495n 1.95v 1359.505n 0.0v 1369.495n 0.0v 1369.505n 0.0v 1379.495n 0.0v 1379.505n 1.95v 1389.495n 1.95v 1389.505n 1.95v 1399.495n 1.95v 1399.505n 1.95v 1409.495n 1.95v 1409.505n 0.0v 1419.495n 0.0v 1419.505n 0.0v 1429.495n 0.0v 1429.505n 1.95v 1439.495n 1.95v 1439.505n 1.95v 1449.495n 1.95v 1449.505n 1.95v 1459.495n 1.95v 1459.505n 1.95v 1469.495n 1.95v 1469.505n 0.0v 1479.495n 0.0v 1479.505n 1.95v 1489.495n 1.95v 1489.505n 1.95v 1499.495n 1.95v 1499.505n 1.95v 1509.495n 1.95v 1509.505n 1.95v 1519.495n 1.95v 1519.505n 1.95v 1529.495n 1.95v 1529.505n 0.0v 1539.495n 0.0v 1539.505n 0.0v 1549.495n 0.0v 1549.505n 1.95v 1559.495n 1.95v 1559.505n 1.95v 1569.495n 1.95v 1569.505n 0.0v 1579.495n 0.0v 1579.505n 1.95v 1589.495n 1.95v 1589.505n 1.95v 1599.495n 1.95v 1599.505n 1.95v 1609.495n 1.95v 1609.505n 1.95v 1619.495n 1.95v 1619.505n 0.0v 1629.495n 0.0v 1629.505n 1.95v 1639.495n 1.95v 1639.505n 1.95v 1649.495n 1.95v 1649.505n 0.0v 1659.495n 0.0v 1659.505n 0.0v 1669.495n 0.0v 1669.505n 1.95v 1679.495n 1.95v 1679.505n 1.95v 1689.495n 1.95v 1689.505n 1.95v 1699.495n 1.95v 1699.505n 0.0v 1709.495n 0.0v 1709.505n 1.95v 1719.495n 1.95v 1719.505n 1.95v 1729.495n 1.95v 1729.505n 0.0v 1739.495n 0.0v 1739.505n 1.95v 1749.495n 1.95v 1749.505n 0.0v 1759.495n 0.0v 1759.505n 1.95v 1769.495n 1.95v 1769.505n 0.0v 1779.495n 0.0v 1779.505n 0.0v 1789.495n 0.0v 1789.505n 0.0v 1799.495n 0.0v 1799.505n 0.0v 1809.495n 0.0v 1809.505n 0.0v 1819.495n 0.0v 1819.505n 0.0v 1829.495n 0.0v 1829.505n 0.0v 1839.495n 0.0v 1839.505n 1.95v 1849.495n 1.95v 1849.505n 0.0v 1859.495n 0.0v 1859.505n 1.95v 1869.495n 1.95v 1869.505n 1.95v 1879.495n 1.95v 1879.505n 0.0v 1889.495n 0.0v 1889.505n 0.0v 1899.495n 0.0v 1899.505n 0.0v 1909.495n 0.0v 1909.505n 1.95v 1919.495n 1.95v 1919.505n 0.0v 1929.495n 0.0v 1929.505n 1.95v 1939.495n 1.95v 1939.505n 1.95v 1949.495n 1.95v 1949.505n 0.0v 1959.495n 0.0v 1959.505n 1.95v 1969.495n 1.95v 1969.505n 1.95v 1979.495n 1.95v 1979.505n 0.0v 1989.495n 0.0v 1989.505n 1.95v 1999.495n 1.95v 1999.505n 1.95v 2009.495n 1.95v 2009.505n 1.95v 2019.495n 1.95v 2019.505n 0.0v 2029.495n 0.0v 2029.505n 1.95v 2039.495n 1.95v 2039.505n 0.0v 2049.495n 0.0v 2049.505n 1.95v )
* (time, data): [(0, 1), (10, 0), (20, 0), (30, 0), (40, 1), (50, 1), (60, 0), (70, 0), (80, 0), (90, 1), (100, 1), (110, 0), (120, 1), (130, 1), (140, 1), (150, 1), (160, 0), (170, 1), (180, 1), (190, 1), (200, 1), (210, 1), (220, 1), (230, 1), (240, 0), (250, 1), (260, 1), (270, 0), (280, 1), (290, 1), (300, 0), (310, 1), (320, 1), (330, 1), (340, 0), (350, 1), (360, 1), (370, 0), (380, 1), (390, 1), (400, 0), (410, 1), (420, 0), (430, 1), (440, 1), (450, 1), (460, 1), (470, 1), (480, 1), (490, 1), (500, 0), (510, 0), (520, 1), (530, 1), (540, 0), (550, 0), (560, 1), (570, 1), (580, 1), (590, 0), (600, 1), (610, 1), (620, 1), (630, 1), (640, 0), (650, 0), (660, 1), (670, 0), (680, 1), (690, 1), (700, 0), (710, 1), (720, 1), (730, 0), (740, 1), (750, 0), (760, 1), (770, 0), (780, 0), (790, 0), (800, 1), (810, 0), (820, 1), (830, 0), (840, 1), (850, 0), (860, 1), (870, 1), (880, 1), (890, 1), (900, 1), (910, 1), (920, 1), (930, 1), (940, 0), (950, 0), (960, 1), (970, 0), (980, 0), (990, 0), (1000, 1), (1010, 0), (1020, 1), (1030, 0), (1040, 1), (1050, 0), (1060, 1), (1070, 1), (1080, 1), (1090, 1), (1100, 1), (1110, 0), (1120, 1), (1130, 1), (1140, 1), (1150, 0), (1160, 1), (1170, 1), (1180, 1), (1190, 1), (1200, 1), (1210, 0), (1220, 1), (1230, 0), (1240, 0), (1250, 0), (1260, 1), (1270, 1), (1280, 1), (1290, 0), (1300, 1), (1310, 1), (1320, 0), (1330, 0), (1340, 0), (1350, 1), (1360, 1), (1370, 1), (1380, 0), (1390, 0), (1400, 1), (1410, 1), (1420, 0), (1430, 1), (1440, 0), (1450, 1), (1460, 1), (1470, 1), (1480, 1), (1490, 1), (1500, 1), (1510, 1), (1520, 1), (1530, 1), (1540, 1), (1550, 0), (1560, 0), (1570, 1), (1580, 0), (1590, 1), (1600, 0), (1610, 0), (1620, 1), (1630, 1), (1640, 1), (1650, 1), (1660, 0), (1670, 1), (1680, 0), (1690, 0), (1700, 1), (1710, 1), (1720, 0), (1730, 0), (1740, 0), (1750, 1), (1760, 0), (1770, 1), (1780, 1), (1790, 1), (1800, 1), (1810, 0), (1820, 1), (1830, 1), (1840, 0), (1850, 0), (1860, 0), (1870, 1), (1880, 1), (1890, 1), (1900, 1), (1910, 1), (1920, 1), (1930, 1), (1940, 1), (1950, 0), (1960, 0), (1970, 0), (1980, 1), (1990, 0), (2000, 1), (2010, 1), (2020, 1), (2030, 1), (2040, 1), (2050, 1)]
VWEB0 WEB0 0 PWL (0n 1.95v 9.495n 1.95v 9.505n 0.0v 19.495n 0.0v 19.505n 0.0v 29.495n 0.0v 29.505n 0.0v 39.495n 0.0v 39.505n 1.95v 49.495n 1.95v 49.505n 1.95v 59.495n 1.95v 59.505n 0.0v 69.495n 0.0v 69.505n 0.0v 79.495n 0.0v 79.505n 0.0v 89.495n 0.0v 89.505n 1.95v 99.495n 1.95v 99.505n 1.95v 109.495n 1.95v 109.505n 0.0v 119.495n 0.0v 119.505n 1.95v 129.495n 1.95v 129.505n 1.95v 139.495n 1.95v 139.505n 1.95v 149.495n 1.95v 149.505n 1.95v 159.495n 1.95v 159.505n 0.0v 169.495n 0.0v 169.505n 1.95v 179.495n 1.95v 179.505n 1.95v 189.495n 1.95v 189.505n 1.95v 199.495n 1.95v 199.505n 1.95v 209.495n 1.95v 209.505n 1.95v 219.495n 1.95v 219.505n 1.95v 229.495n 1.95v 229.505n 1.95v 239.495n 1.95v 239.505n 0.0v 249.495n 0.0v 249.505n 1.95v 259.495n 1.95v 259.505n 1.95v 269.495n 1.95v 269.505n 0.0v 279.495n 0.0v 279.505n 1.95v 289.495n 1.95v 289.505n 1.95v 299.495n 1.95v 299.505n 0.0v 309.495n 0.0v 309.505n 1.95v 319.495n 1.95v 319.505n 1.95v 329.495n 1.95v 329.505n 1.95v 339.495n 1.95v 339.505n 0.0v 349.495n 0.0v 349.505n 1.95v 359.495n 1.95v 359.505n 1.95v 369.495n 1.95v 369.505n 0.0v 379.495n 0.0v 379.505n 1.95v 389.495n 1.95v 389.505n 1.95v 399.495n 1.95v 399.505n 0.0v 409.495n 0.0v 409.505n 1.95v 419.495n 1.95v 419.505n 0.0v 429.495n 0.0v 429.505n 1.95v 439.495n 1.95v 439.505n 1.95v 449.495n 1.95v 449.505n 1.95v 459.495n 1.95v 459.505n 1.95v 469.495n 1.95v 469.505n 1.95v 479.495n 1.95v 479.505n 1.95v 489.495n 1.95v 489.505n 1.95v 499.495n 1.95v 499.505n 0.0v 509.495n 0.0v 509.505n 0.0v 519.495n 0.0v 519.505n 1.95v 529.495n 1.95v 529.505n 1.95v 539.495n 1.95v 539.505n 0.0v 549.495n 0.0v 549.505n 0.0v 559.495n 0.0v 559.505n 1.95v 569.495n 1.95v 569.505n 1.95v 579.495n 1.95v 579.505n 1.95v 589.495n 1.95v 589.505n 0.0v 599.495n 0.0v 599.505n 1.95v 609.495n 1.95v 609.505n 1.95v 619.495n 1.95v 619.505n 1.95v 629.495n 1.95v 629.505n 1.95v 639.495n 1.95v 639.505n 0.0v 649.495n 0.0v 649.505n 0.0v 659.495n 0.0v 659.505n 1.95v 669.495n 1.95v 669.505n 0.0v 679.495n 0.0v 679.505n 1.95v 689.495n 1.95v 689.505n 1.95v 699.495n 1.95v 699.505n 0.0v 709.495n 0.0v 709.505n 1.95v 719.495n 1.95v 719.505n 1.95v 729.495n 1.95v 729.505n 0.0v 739.495n 0.0v 739.505n 1.95v 749.495n 1.95v 749.505n 0.0v 759.495n 0.0v 759.505n 1.95v 769.495n 1.95v 769.505n 0.0v 779.495n 0.0v 779.505n 0.0v 789.495n 0.0v 789.505n 0.0v 799.495n 0.0v 799.505n 1.95v 809.495n 1.95v 809.505n 0.0v 819.495n 0.0v 819.505n 1.95v 829.495n 1.95v 829.505n 0.0v 839.495n 0.0v 839.505n 1.95v 849.495n 1.95v 849.505n 0.0v 859.495n 0.0v 859.505n 1.95v 869.495n 1.95v 869.505n 1.95v 879.495n 1.95v 879.505n 1.95v 889.495n 1.95v 889.505n 1.95v 899.495n 1.95v 899.505n 1.95v 909.495n 1.95v 909.505n 1.95v 919.495n 1.95v 919.505n 1.95v 929.495n 1.95v 929.505n 1.95v 939.495n 1.95v 939.505n 0.0v 949.495n 0.0v 949.505n 0.0v 959.495n 0.0v 959.505n 1.95v 969.495n 1.95v 969.505n 0.0v 979.495n 0.0v 979.505n 0.0v 989.495n 0.0v 989.505n 0.0v 999.495n 0.0v 999.505n 1.95v 1009.495n 1.95v 1009.505n 0.0v 1019.495n 0.0v 1019.505n 1.95v 1029.495n 1.95v 1029.505n 0.0v 1039.495n 0.0v 1039.505n 1.95v 1049.495n 1.95v 1049.505n 0.0v 1059.495n 0.0v 1059.505n 1.95v 1069.495n 1.95v 1069.505n 1.95v 1079.495n 1.95v 1079.505n 1.95v 1089.495n 1.95v 1089.505n 1.95v 1099.495n 1.95v 1099.505n 1.95v 1109.495n 1.95v 1109.505n 0.0v 1119.495n 0.0v 1119.505n 1.95v 1129.495n 1.95v 1129.505n 1.95v 1139.495n 1.95v 1139.505n 1.95v 1149.495n 1.95v 1149.505n 0.0v 1159.495n 0.0v 1159.505n 1.95v 1169.495n 1.95v 1169.505n 1.95v 1179.495n 1.95v 1179.505n 1.95v 1189.495n 1.95v 1189.505n 1.95v 1199.495n 1.95v 1199.505n 1.95v 1209.495n 1.95v 1209.505n 0.0v 1219.495n 0.0v 1219.505n 1.95v 1229.495n 1.95v 1229.505n 0.0v 1239.495n 0.0v 1239.505n 0.0v 1249.495n 0.0v 1249.505n 0.0v 1259.495n 0.0v 1259.505n 1.95v 1269.495n 1.95v 1269.505n 1.95v 1279.495n 1.95v 1279.505n 1.95v 1289.495n 1.95v 1289.505n 0.0v 1299.495n 0.0v 1299.505n 1.95v 1309.495n 1.95v 1309.505n 1.95v 1319.495n 1.95v 1319.505n 0.0v 1329.495n 0.0v 1329.505n 0.0v 1339.495n 0.0v 1339.505n 0.0v 1349.495n 0.0v 1349.505n 1.95v 1359.495n 1.95v 1359.505n 1.95v 1369.495n 1.95v 1369.505n 1.95v 1379.495n 1.95v 1379.505n 0.0v 1389.495n 0.0v 1389.505n 0.0v 1399.495n 0.0v 1399.505n 1.95v 1409.495n 1.95v 1409.505n 1.95v 1419.495n 1.95v 1419.505n 0.0v 1429.495n 0.0v 1429.505n 1.95v 1439.495n 1.95v 1439.505n 0.0v 1449.495n 0.0v 1449.505n 1.95v 1459.495n 1.95v 1459.505n 1.95v 1469.495n 1.95v 1469.505n 1.95v 1479.495n 1.95v 1479.505n 1.95v 1489.495n 1.95v 1489.505n 1.95v 1499.495n 1.95v 1499.505n 1.95v 1509.495n 1.95v 1509.505n 1.95v 1519.495n 1.95v 1519.505n 1.95v 1529.495n 1.95v 1529.505n 1.95v 1539.495n 1.95v 1539.505n 1.95v 1549.495n 1.95v 1549.505n 0.0v 1559.495n 0.0v 1559.505n 0.0v 1569.495n 0.0v 1569.505n 1.95v 1579.495n 1.95v 1579.505n 0.0v 1589.495n 0.0v 1589.505n 1.95v 1599.495n 1.95v 1599.505n 0.0v 1609.495n 0.0v 1609.505n 0.0v 1619.495n 0.0v 1619.505n 1.95v 1629.495n 1.95v 1629.505n 1.95v 1639.495n 1.95v 1639.505n 1.95v 1649.495n 1.95v 1649.505n 1.95v 1659.495n 1.95v 1659.505n 0.0v 1669.495n 0.0v 1669.505n 1.95v 1679.495n 1.95v 1679.505n 0.0v 1689.495n 0.0v 1689.505n 0.0v 1699.495n 0.0v 1699.505n 1.95v 1709.495n 1.95v 1709.505n 1.95v 1719.495n 1.95v 1719.505n 0.0v 1729.495n 0.0v 1729.505n 0.0v 1739.495n 0.0v 1739.505n 0.0v 1749.495n 0.0v 1749.505n 1.95v 1759.495n 1.95v 1759.505n 0.0v 1769.495n 0.0v 1769.505n 1.95v 1779.495n 1.95v 1779.505n 1.95v 1789.495n 1.95v 1789.505n 1.95v 1799.495n 1.95v 1799.505n 1.95v 1809.495n 1.95v 1809.505n 0.0v 1819.495n 0.0v 1819.505n 1.95v 1829.495n 1.95v 1829.505n 1.95v 1839.495n 1.95v 1839.505n 0.0v 1849.495n 0.0v 1849.505n 0.0v 1859.495n 0.0v 1859.505n 0.0v 1869.495n 0.0v 1869.505n 1.95v 1879.495n 1.95v 1879.505n 1.95v 1889.495n 1.95v 1889.505n 1.95v 1899.495n 1.95v 1899.505n 1.95v 1909.495n 1.95v 1909.505n 1.95v 1919.495n 1.95v 1919.505n 1.95v 1929.495n 1.95v 1929.505n 1.95v 1939.495n 1.95v 1939.505n 1.95v 1949.495n 1.95v 1949.505n 0.0v 1959.495n 0.0v 1959.505n 0.0v 1969.495n 0.0v 1969.505n 0.0v 1979.495n 0.0v 1979.505n 1.95v 1989.495n 1.95v 1989.505n 0.0v 1999.495n 0.0v 1999.505n 1.95v 2009.495n 1.95v 2009.505n 1.95v 2019.495n 1.95v 2019.505n 1.95v 2029.495n 1.95v 2029.505n 1.95v 2039.495n 1.95v 2039.505n 1.95v 2049.495n 1.95v 2049.505n 1.95v )

* Generation of wmask signals
* (time, data): [(0, 0), (10, 1), (20, 1), (30, 1), (40, 1), (50, 1), (60, 1), (70, 1), (80, 1), (90, 1), (100, 1), (110, 1), (120, 1), (130, 1), (140, 1), (150, 1), (160, 0), (170, 0), (180, 0), (190, 0), (200, 0), (210, 0), (220, 0), (230, 0), (240, 0), (250, 0), (260, 0), (270, 0), (280, 0), (290, 0), (300, 1), (310, 1), (320, 1), (330, 1), (340, 1), (350, 1), (360, 1), (370, 0), (380, 0), (390, 0), (400, 1), (410, 1), (420, 1), (430, 1), (440, 1), (450, 1), (460, 1), (470, 1), (480, 1), (490, 1), (500, 1), (510, 1), (520, 1), (530, 1), (540, 1), (550, 1), (560, 1), (570, 1), (580, 1), (590, 1), (600, 1), (610, 1), (620, 1), (630, 1), (640, 0), (650, 1), (660, 1), (670, 1), (680, 1), (690, 1), (700, 1), (710, 1), (720, 1), (730, 0), (740, 0), (750, 1), (760, 1), (770, 1), (780, 1), (790, 0), (800, 0), (810, 0), (820, 0), (830, 0), (840, 0), (850, 1), (860, 1), (870, 1), (880, 1), (890, 1), (900, 1), (910, 1), (920, 1), (930, 1), (940, 1), (950, 1), (960, 1), (970, 1), (980, 1), (990, 0), (1000, 0), (1010, 0), (1020, 0), (1030, 1), (1040, 1), (1050, 1), (1060, 1), (1070, 1), (1080, 1), (1090, 1), (1100, 1), (1110, 0), (1120, 0), (1130, 0), (1140, 0), (1150, 1), (1160, 1), (1170, 1), (1180, 1), (1190, 1), (1200, 1), (1210, 1), (1220, 1), (1230, 1), (1240, 0), (1250, 1), (1260, 1), (1270, 1), (1280, 1), (1290, 1), (1300, 1), (1310, 1), (1320, 0), (1330, 0), (1340, 1), (1350, 1), (1360, 1), (1370, 1), (1380, 1), (1390, 0), (1400, 0), (1410, 0), (1420, 1), (1430, 1), (1440, 1), (1450, 1), (1460, 1), (1470, 1), (1480, 1), (1490, 1), (1500, 1), (1510, 1), (1520, 1), (1530, 1), (1540, 1), (1550, 1), (1560, 1), (1570, 1), (1580, 0), (1590, 0), (1600, 1), (1610, 0), (1620, 0), (1630, 0), (1640, 0), (1650, 0), (1660, 0), (1670, 0), (1680, 1), (1690, 1), (1700, 1), (1710, 1), (1720, 1), (1730, 1), (1740, 0), (1750, 0), (1760, 1), (1770, 1), (1780, 1), (1790, 1), (1800, 1), (1810, 0), (1820, 0), (1830, 0), (1840, 0), (1850, 1), (1860, 1), (1870, 1), (1880, 1), (1890, 1), (1900, 1), (1910, 1), (1920, 1), (1930, 1), (1940, 1), (1950, 0), (1960, 1), (1970, 0), (1980, 0), (1990, 1), (2000, 1), (2010, 1), (2020, 1), (2030, 1), (2040, 1), (2050, 1)]
VWMASK0_0  WMASK0_0  0 PWL (0n 0.0v 9.495n 0.0v 9.505n 1.95v 19.495n 1.95v 19.505n 1.95v 29.495n 1.95v 29.505n 1.95v 39.495n 1.95v 39.505n 1.95v 49.495n 1.95v 49.505n 1.95v 59.495n 1.95v 59.505n 1.95v 69.495n 1.95v 69.505n 1.95v 79.495n 1.95v 79.505n 1.95v 89.495n 1.95v 89.505n 1.95v 99.495n 1.95v 99.505n 1.95v 109.495n 1.95v 109.505n 1.95v 119.495n 1.95v 119.505n 1.95v 129.495n 1.95v 129.505n 1.95v 139.495n 1.95v 139.505n 1.95v 149.495n 1.95v 149.505n 1.95v 159.495n 1.95v 159.505n 0.0v 169.495n 0.0v 169.505n 0.0v 179.495n 0.0v 179.505n 0.0v 189.495n 0.0v 189.505n 0.0v 199.495n 0.0v 199.505n 0.0v 209.495n 0.0v 209.505n 0.0v 219.495n 0.0v 219.505n 0.0v 229.495n 0.0v 229.505n 0.0v 239.495n 0.0v 239.505n 0.0v 249.495n 0.0v 249.505n 0.0v 259.495n 0.0v 259.505n 0.0v 269.495n 0.0v 269.505n 0.0v 279.495n 0.0v 279.505n 0.0v 289.495n 0.0v 289.505n 0.0v 299.495n 0.0v 299.505n 1.95v 309.495n 1.95v 309.505n 1.95v 319.495n 1.95v 319.505n 1.95v 329.495n 1.95v 329.505n 1.95v 339.495n 1.95v 339.505n 1.95v 349.495n 1.95v 349.505n 1.95v 359.495n 1.95v 359.505n 1.95v 369.495n 1.95v 369.505n 0.0v 379.495n 0.0v 379.505n 0.0v 389.495n 0.0v 389.505n 0.0v 399.495n 0.0v 399.505n 1.95v 409.495n 1.95v 409.505n 1.95v 419.495n 1.95v 419.505n 1.95v 429.495n 1.95v 429.505n 1.95v 439.495n 1.95v 439.505n 1.95v 449.495n 1.95v 449.505n 1.95v 459.495n 1.95v 459.505n 1.95v 469.495n 1.95v 469.505n 1.95v 479.495n 1.95v 479.505n 1.95v 489.495n 1.95v 489.505n 1.95v 499.495n 1.95v 499.505n 1.95v 509.495n 1.95v 509.505n 1.95v 519.495n 1.95v 519.505n 1.95v 529.495n 1.95v 529.505n 1.95v 539.495n 1.95v 539.505n 1.95v 549.495n 1.95v 549.505n 1.95v 559.495n 1.95v 559.505n 1.95v 569.495n 1.95v 569.505n 1.95v 579.495n 1.95v 579.505n 1.95v 589.495n 1.95v 589.505n 1.95v 599.495n 1.95v 599.505n 1.95v 609.495n 1.95v 609.505n 1.95v 619.495n 1.95v 619.505n 1.95v 629.495n 1.95v 629.505n 1.95v 639.495n 1.95v 639.505n 0.0v 649.495n 0.0v 649.505n 1.95v 659.495n 1.95v 659.505n 1.95v 669.495n 1.95v 669.505n 1.95v 679.495n 1.95v 679.505n 1.95v 689.495n 1.95v 689.505n 1.95v 699.495n 1.95v 699.505n 1.95v 709.495n 1.95v 709.505n 1.95v 719.495n 1.95v 719.505n 1.95v 729.495n 1.95v 729.505n 0.0v 739.495n 0.0v 739.505n 0.0v 749.495n 0.0v 749.505n 1.95v 759.495n 1.95v 759.505n 1.95v 769.495n 1.95v 769.505n 1.95v 779.495n 1.95v 779.505n 1.95v 789.495n 1.95v 789.505n 0.0v 799.495n 0.0v 799.505n 0.0v 809.495n 0.0v 809.505n 0.0v 819.495n 0.0v 819.505n 0.0v 829.495n 0.0v 829.505n 0.0v 839.495n 0.0v 839.505n 0.0v 849.495n 0.0v 849.505n 1.95v 859.495n 1.95v 859.505n 1.95v 869.495n 1.95v 869.505n 1.95v 879.495n 1.95v 879.505n 1.95v 889.495n 1.95v 889.505n 1.95v 899.495n 1.95v 899.505n 1.95v 909.495n 1.95v 909.505n 1.95v 919.495n 1.95v 919.505n 1.95v 929.495n 1.95v 929.505n 1.95v 939.495n 1.95v 939.505n 1.95v 949.495n 1.95v 949.505n 1.95v 959.495n 1.95v 959.505n 1.95v 969.495n 1.95v 969.505n 1.95v 979.495n 1.95v 979.505n 1.95v 989.495n 1.95v 989.505n 0.0v 999.495n 0.0v 999.505n 0.0v 1009.495n 0.0v 1009.505n 0.0v 1019.495n 0.0v 1019.505n 0.0v 1029.495n 0.0v 1029.505n 1.95v 1039.495n 1.95v 1039.505n 1.95v 1049.495n 1.95v 1049.505n 1.95v 1059.495n 1.95v 1059.505n 1.95v 1069.495n 1.95v 1069.505n 1.95v 1079.495n 1.95v 1079.505n 1.95v 1089.495n 1.95v 1089.505n 1.95v 1099.495n 1.95v 1099.505n 1.95v 1109.495n 1.95v 1109.505n 0.0v 1119.495n 0.0v 1119.505n 0.0v 1129.495n 0.0v 1129.505n 0.0v 1139.495n 0.0v 1139.505n 0.0v 1149.495n 0.0v 1149.505n 1.95v 1159.495n 1.95v 1159.505n 1.95v 1169.495n 1.95v 1169.505n 1.95v 1179.495n 1.95v 1179.505n 1.95v 1189.495n 1.95v 1189.505n 1.95v 1199.495n 1.95v 1199.505n 1.95v 1209.495n 1.95v 1209.505n 1.95v 1219.495n 1.95v 1219.505n 1.95v 1229.495n 1.95v 1229.505n 1.95v 1239.495n 1.95v 1239.505n 0.0v 1249.495n 0.0v 1249.505n 1.95v 1259.495n 1.95v 1259.505n 1.95v 1269.495n 1.95v 1269.505n 1.95v 1279.495n 1.95v 1279.505n 1.95v 1289.495n 1.95v 1289.505n 1.95v 1299.495n 1.95v 1299.505n 1.95v 1309.495n 1.95v 1309.505n 1.95v 1319.495n 1.95v 1319.505n 0.0v 1329.495n 0.0v 1329.505n 0.0v 1339.495n 0.0v 1339.505n 1.95v 1349.495n 1.95v 1349.505n 1.95v 1359.495n 1.95v 1359.505n 1.95v 1369.495n 1.95v 1369.505n 1.95v 1379.495n 1.95v 1379.505n 1.95v 1389.495n 1.95v 1389.505n 0.0v 1399.495n 0.0v 1399.505n 0.0v 1409.495n 0.0v 1409.505n 0.0v 1419.495n 0.0v 1419.505n 1.95v 1429.495n 1.95v 1429.505n 1.95v 1439.495n 1.95v 1439.505n 1.95v 1449.495n 1.95v 1449.505n 1.95v 1459.495n 1.95v 1459.505n 1.95v 1469.495n 1.95v 1469.505n 1.95v 1479.495n 1.95v 1479.505n 1.95v 1489.495n 1.95v 1489.505n 1.95v 1499.495n 1.95v 1499.505n 1.95v 1509.495n 1.95v 1509.505n 1.95v 1519.495n 1.95v 1519.505n 1.95v 1529.495n 1.95v 1529.505n 1.95v 1539.495n 1.95v 1539.505n 1.95v 1549.495n 1.95v 1549.505n 1.95v 1559.495n 1.95v 1559.505n 1.95v 1569.495n 1.95v 1569.505n 1.95v 1579.495n 1.95v 1579.505n 0.0v 1589.495n 0.0v 1589.505n 0.0v 1599.495n 0.0v 1599.505n 1.95v 1609.495n 1.95v 1609.505n 0.0v 1619.495n 0.0v 1619.505n 0.0v 1629.495n 0.0v 1629.505n 0.0v 1639.495n 0.0v 1639.505n 0.0v 1649.495n 0.0v 1649.505n 0.0v 1659.495n 0.0v 1659.505n 0.0v 1669.495n 0.0v 1669.505n 0.0v 1679.495n 0.0v 1679.505n 1.95v 1689.495n 1.95v 1689.505n 1.95v 1699.495n 1.95v 1699.505n 1.95v 1709.495n 1.95v 1709.505n 1.95v 1719.495n 1.95v 1719.505n 1.95v 1729.495n 1.95v 1729.505n 1.95v 1739.495n 1.95v 1739.505n 0.0v 1749.495n 0.0v 1749.505n 0.0v 1759.495n 0.0v 1759.505n 1.95v 1769.495n 1.95v 1769.505n 1.95v 1779.495n 1.95v 1779.505n 1.95v 1789.495n 1.95v 1789.505n 1.95v 1799.495n 1.95v 1799.505n 1.95v 1809.495n 1.95v 1809.505n 0.0v 1819.495n 0.0v 1819.505n 0.0v 1829.495n 0.0v 1829.505n 0.0v 1839.495n 0.0v 1839.505n 0.0v 1849.495n 0.0v 1849.505n 1.95v 1859.495n 1.95v 1859.505n 1.95v 1869.495n 1.95v 1869.505n 1.95v 1879.495n 1.95v 1879.505n 1.95v 1889.495n 1.95v 1889.505n 1.95v 1899.495n 1.95v 1899.505n 1.95v 1909.495n 1.95v 1909.505n 1.95v 1919.495n 1.95v 1919.505n 1.95v 1929.495n 1.95v 1929.505n 1.95v 1939.495n 1.95v 1939.505n 1.95v 1949.495n 1.95v 1949.505n 0.0v 1959.495n 0.0v 1959.505n 1.95v 1969.495n 1.95v 1969.505n 0.0v 1979.495n 0.0v 1979.505n 0.0v 1989.495n 0.0v 1989.505n 1.95v 1999.495n 1.95v 1999.505n 1.95v 2009.495n 1.95v 2009.505n 1.95v 2019.495n 1.95v 2019.505n 1.95v 2029.495n 1.95v 2029.505n 1.95v 2039.495n 1.95v 2039.505n 1.95v 2049.495n 1.95v 2049.505n 1.95v )
* (time, data): [(0, 0), (10, 1), (20, 1), (30, 1), (40, 1), (50, 1), (60, 1), (70, 1), (80, 1), (90, 1), (100, 1), (110, 1), (120, 1), (130, 1), (140, 1), (150, 1), (160, 1), (170, 1), (180, 1), (190, 1), (200, 1), (210, 1), (220, 1), (230, 1), (240, 0), (250, 0), (260, 0), (270, 0), (280, 0), (290, 0), (300, 1), (310, 1), (320, 1), (330, 1), (340, 1), (350, 1), (360, 1), (370, 1), (380, 1), (390, 1), (400, 1), (410, 1), (420, 1), (430, 1), (440, 1), (450, 1), (460, 1), (470, 1), (480, 1), (490, 1), (500, 1), (510, 1), (520, 1), (530, 1), (540, 1), (550, 1), (560, 1), (570, 1), (580, 1), (590, 1), (600, 1), (610, 1), (620, 1), (630, 1), (640, 1), (650, 0), (660, 0), (670, 1), (680, 1), (690, 1), (700, 0), (710, 0), (720, 0), (730, 0), (740, 0), (750, 0), (760, 0), (770, 1), (780, 0), (790, 1), (800, 1), (810, 1), (820, 1), (830, 0), (840, 0), (850, 1), (860, 1), (870, 1), (880, 1), (890, 1), (900, 1), (910, 1), (920, 1), (930, 1), (940, 1), (950, 1), (960, 1), (970, 1), (980, 0), (990, 1), (1000, 1), (1010, 1), (1020, 1), (1030, 1), (1040, 1), (1050, 1), (1060, 1), (1070, 1), (1080, 1), (1090, 1), (1100, 1), (1110, 0), (1120, 0), (1130, 0), (1140, 0), (1150, 1), (1160, 1), (1170, 1), (1180, 1), (1190, 1), (1200, 1), (1210, 0), (1220, 0), (1230, 1), (1240, 0), (1250, 1), (1260, 1), (1270, 1), (1280, 1), (1290, 1), (1300, 1), (1310, 1), (1320, 0), (1330, 0), (1340, 1), (1350, 1), (1360, 1), (1370, 1), (1380, 1), (1390, 0), (1400, 0), (1410, 0), (1420, 1), (1430, 1), (1440, 0), (1450, 0), (1460, 0), (1470, 0), (1480, 0), (1490, 0), (1500, 0), (1510, 0), (1520, 0), (1530, 0), (1540, 0), (1550, 1), (1560, 0), (1570, 0), (1580, 1), (1590, 1), (1600, 1), (1610, 0), (1620, 0), (1630, 0), (1640, 0), (1650, 0), (1660, 0), (1670, 0), (1680, 1), (1690, 1), (1700, 1), (1710, 1), (1720, 1), (1730, 0), (1740, 0), (1750, 0), (1760, 1), (1770, 1), (1780, 1), (1790, 1), (1800, 1), (1810, 1), (1820, 1), (1830, 1), (1840, 0), (1850, 1), (1860, 1), (1870, 1), (1880, 1), (1890, 1), (1900, 1), (1910, 1), (1920, 1), (1930, 1), (1940, 1), (1950, 0), (1960, 1), (1970, 0), (1980, 0), (1990, 1), (2000, 1), (2010, 1), (2020, 1), (2030, 1), (2040, 1), (2050, 1)]
VWMASK0_1  WMASK0_1  0 PWL (0n 0.0v 9.495n 0.0v 9.505n 1.95v 19.495n 1.95v 19.505n 1.95v 29.495n 1.95v 29.505n 1.95v 39.495n 1.95v 39.505n 1.95v 49.495n 1.95v 49.505n 1.95v 59.495n 1.95v 59.505n 1.95v 69.495n 1.95v 69.505n 1.95v 79.495n 1.95v 79.505n 1.95v 89.495n 1.95v 89.505n 1.95v 99.495n 1.95v 99.505n 1.95v 109.495n 1.95v 109.505n 1.95v 119.495n 1.95v 119.505n 1.95v 129.495n 1.95v 129.505n 1.95v 139.495n 1.95v 139.505n 1.95v 149.495n 1.95v 149.505n 1.95v 159.495n 1.95v 159.505n 1.95v 169.495n 1.95v 169.505n 1.95v 179.495n 1.95v 179.505n 1.95v 189.495n 1.95v 189.505n 1.95v 199.495n 1.95v 199.505n 1.95v 209.495n 1.95v 209.505n 1.95v 219.495n 1.95v 219.505n 1.95v 229.495n 1.95v 229.505n 1.95v 239.495n 1.95v 239.505n 0.0v 249.495n 0.0v 249.505n 0.0v 259.495n 0.0v 259.505n 0.0v 269.495n 0.0v 269.505n 0.0v 279.495n 0.0v 279.505n 0.0v 289.495n 0.0v 289.505n 0.0v 299.495n 0.0v 299.505n 1.95v 309.495n 1.95v 309.505n 1.95v 319.495n 1.95v 319.505n 1.95v 329.495n 1.95v 329.505n 1.95v 339.495n 1.95v 339.505n 1.95v 349.495n 1.95v 349.505n 1.95v 359.495n 1.95v 359.505n 1.95v 369.495n 1.95v 369.505n 1.95v 379.495n 1.95v 379.505n 1.95v 389.495n 1.95v 389.505n 1.95v 399.495n 1.95v 399.505n 1.95v 409.495n 1.95v 409.505n 1.95v 419.495n 1.95v 419.505n 1.95v 429.495n 1.95v 429.505n 1.95v 439.495n 1.95v 439.505n 1.95v 449.495n 1.95v 449.505n 1.95v 459.495n 1.95v 459.505n 1.95v 469.495n 1.95v 469.505n 1.95v 479.495n 1.95v 479.505n 1.95v 489.495n 1.95v 489.505n 1.95v 499.495n 1.95v 499.505n 1.95v 509.495n 1.95v 509.505n 1.95v 519.495n 1.95v 519.505n 1.95v 529.495n 1.95v 529.505n 1.95v 539.495n 1.95v 539.505n 1.95v 549.495n 1.95v 549.505n 1.95v 559.495n 1.95v 559.505n 1.95v 569.495n 1.95v 569.505n 1.95v 579.495n 1.95v 579.505n 1.95v 589.495n 1.95v 589.505n 1.95v 599.495n 1.95v 599.505n 1.95v 609.495n 1.95v 609.505n 1.95v 619.495n 1.95v 619.505n 1.95v 629.495n 1.95v 629.505n 1.95v 639.495n 1.95v 639.505n 1.95v 649.495n 1.95v 649.505n 0.0v 659.495n 0.0v 659.505n 0.0v 669.495n 0.0v 669.505n 1.95v 679.495n 1.95v 679.505n 1.95v 689.495n 1.95v 689.505n 1.95v 699.495n 1.95v 699.505n 0.0v 709.495n 0.0v 709.505n 0.0v 719.495n 0.0v 719.505n 0.0v 729.495n 0.0v 729.505n 0.0v 739.495n 0.0v 739.505n 0.0v 749.495n 0.0v 749.505n 0.0v 759.495n 0.0v 759.505n 0.0v 769.495n 0.0v 769.505n 1.95v 779.495n 1.95v 779.505n 0.0v 789.495n 0.0v 789.505n 1.95v 799.495n 1.95v 799.505n 1.95v 809.495n 1.95v 809.505n 1.95v 819.495n 1.95v 819.505n 1.95v 829.495n 1.95v 829.505n 0.0v 839.495n 0.0v 839.505n 0.0v 849.495n 0.0v 849.505n 1.95v 859.495n 1.95v 859.505n 1.95v 869.495n 1.95v 869.505n 1.95v 879.495n 1.95v 879.505n 1.95v 889.495n 1.95v 889.505n 1.95v 899.495n 1.95v 899.505n 1.95v 909.495n 1.95v 909.505n 1.95v 919.495n 1.95v 919.505n 1.95v 929.495n 1.95v 929.505n 1.95v 939.495n 1.95v 939.505n 1.95v 949.495n 1.95v 949.505n 1.95v 959.495n 1.95v 959.505n 1.95v 969.495n 1.95v 969.505n 1.95v 979.495n 1.95v 979.505n 0.0v 989.495n 0.0v 989.505n 1.95v 999.495n 1.95v 999.505n 1.95v 1009.495n 1.95v 1009.505n 1.95v 1019.495n 1.95v 1019.505n 1.95v 1029.495n 1.95v 1029.505n 1.95v 1039.495n 1.95v 1039.505n 1.95v 1049.495n 1.95v 1049.505n 1.95v 1059.495n 1.95v 1059.505n 1.95v 1069.495n 1.95v 1069.505n 1.95v 1079.495n 1.95v 1079.505n 1.95v 1089.495n 1.95v 1089.505n 1.95v 1099.495n 1.95v 1099.505n 1.95v 1109.495n 1.95v 1109.505n 0.0v 1119.495n 0.0v 1119.505n 0.0v 1129.495n 0.0v 1129.505n 0.0v 1139.495n 0.0v 1139.505n 0.0v 1149.495n 0.0v 1149.505n 1.95v 1159.495n 1.95v 1159.505n 1.95v 1169.495n 1.95v 1169.505n 1.95v 1179.495n 1.95v 1179.505n 1.95v 1189.495n 1.95v 1189.505n 1.95v 1199.495n 1.95v 1199.505n 1.95v 1209.495n 1.95v 1209.505n 0.0v 1219.495n 0.0v 1219.505n 0.0v 1229.495n 0.0v 1229.505n 1.95v 1239.495n 1.95v 1239.505n 0.0v 1249.495n 0.0v 1249.505n 1.95v 1259.495n 1.95v 1259.505n 1.95v 1269.495n 1.95v 1269.505n 1.95v 1279.495n 1.95v 1279.505n 1.95v 1289.495n 1.95v 1289.505n 1.95v 1299.495n 1.95v 1299.505n 1.95v 1309.495n 1.95v 1309.505n 1.95v 1319.495n 1.95v 1319.505n 0.0v 1329.495n 0.0v 1329.505n 0.0v 1339.495n 0.0v 1339.505n 1.95v 1349.495n 1.95v 1349.505n 1.95v 1359.495n 1.95v 1359.505n 1.95v 1369.495n 1.95v 1369.505n 1.95v 1379.495n 1.95v 1379.505n 1.95v 1389.495n 1.95v 1389.505n 0.0v 1399.495n 0.0v 1399.505n 0.0v 1409.495n 0.0v 1409.505n 0.0v 1419.495n 0.0v 1419.505n 1.95v 1429.495n 1.95v 1429.505n 1.95v 1439.495n 1.95v 1439.505n 0.0v 1449.495n 0.0v 1449.505n 0.0v 1459.495n 0.0v 1459.505n 0.0v 1469.495n 0.0v 1469.505n 0.0v 1479.495n 0.0v 1479.505n 0.0v 1489.495n 0.0v 1489.505n 0.0v 1499.495n 0.0v 1499.505n 0.0v 1509.495n 0.0v 1509.505n 0.0v 1519.495n 0.0v 1519.505n 0.0v 1529.495n 0.0v 1529.505n 0.0v 1539.495n 0.0v 1539.505n 0.0v 1549.495n 0.0v 1549.505n 1.95v 1559.495n 1.95v 1559.505n 0.0v 1569.495n 0.0v 1569.505n 0.0v 1579.495n 0.0v 1579.505n 1.95v 1589.495n 1.95v 1589.505n 1.95v 1599.495n 1.95v 1599.505n 1.95v 1609.495n 1.95v 1609.505n 0.0v 1619.495n 0.0v 1619.505n 0.0v 1629.495n 0.0v 1629.505n 0.0v 1639.495n 0.0v 1639.505n 0.0v 1649.495n 0.0v 1649.505n 0.0v 1659.495n 0.0v 1659.505n 0.0v 1669.495n 0.0v 1669.505n 0.0v 1679.495n 0.0v 1679.505n 1.95v 1689.495n 1.95v 1689.505n 1.95v 1699.495n 1.95v 1699.505n 1.95v 1709.495n 1.95v 1709.505n 1.95v 1719.495n 1.95v 1719.505n 1.95v 1729.495n 1.95v 1729.505n 0.0v 1739.495n 0.0v 1739.505n 0.0v 1749.495n 0.0v 1749.505n 0.0v 1759.495n 0.0v 1759.505n 1.95v 1769.495n 1.95v 1769.505n 1.95v 1779.495n 1.95v 1779.505n 1.95v 1789.495n 1.95v 1789.505n 1.95v 1799.495n 1.95v 1799.505n 1.95v 1809.495n 1.95v 1809.505n 1.95v 1819.495n 1.95v 1819.505n 1.95v 1829.495n 1.95v 1829.505n 1.95v 1839.495n 1.95v 1839.505n 0.0v 1849.495n 0.0v 1849.505n 1.95v 1859.495n 1.95v 1859.505n 1.95v 1869.495n 1.95v 1869.505n 1.95v 1879.495n 1.95v 1879.505n 1.95v 1889.495n 1.95v 1889.505n 1.95v 1899.495n 1.95v 1899.505n 1.95v 1909.495n 1.95v 1909.505n 1.95v 1919.495n 1.95v 1919.505n 1.95v 1929.495n 1.95v 1929.505n 1.95v 1939.495n 1.95v 1939.505n 1.95v 1949.495n 1.95v 1949.505n 0.0v 1959.495n 0.0v 1959.505n 1.95v 1969.495n 1.95v 1969.505n 0.0v 1979.495n 0.0v 1979.505n 0.0v 1989.495n 0.0v 1989.505n 1.95v 1999.495n 1.95v 1999.505n 1.95v 2009.495n 1.95v 2009.505n 1.95v 2019.495n 1.95v 2019.505n 1.95v 2029.495n 1.95v 2029.505n 1.95v 2039.495n 1.95v 2039.505n 1.95v 2049.495n 1.95v 2049.505n 1.95v )
* (time, data): [(0, 0), (10, 1), (20, 1), (30, 1), (40, 1), (50, 1), (60, 0), (70, 1), (80, 1), (90, 1), (100, 1), (110, 1), (120, 1), (130, 1), (140, 1), (150, 1), (160, 0), (170, 0), (180, 0), (190, 0), (200, 0), (210, 0), (220, 0), (230, 0), (240, 0), (250, 0), (260, 0), (270, 1), (280, 1), (290, 1), (300, 1), (310, 1), (320, 1), (330, 1), (340, 1), (350, 1), (360, 1), (370, 1), (380, 1), (390, 1), (400, 1), (410, 1), (420, 1), (430, 1), (440, 1), (450, 1), (460, 1), (470, 1), (480, 1), (490, 1), (500, 1), (510, 1), (520, 1), (530, 1), (540, 1), (550, 1), (560, 1), (570, 1), (580, 1), (590, 1), (600, 1), (610, 1), (620, 1), (630, 1), (640, 1), (650, 0), (660, 0), (670, 1), (680, 1), (690, 1), (700, 1), (710, 1), (720, 1), (730, 1), (740, 1), (750, 1), (760, 1), (770, 1), (780, 1), (790, 1), (800, 1), (810, 0), (820, 0), (830, 0), (840, 0), (850, 1), (860, 1), (870, 1), (880, 1), (890, 1), (900, 1), (910, 1), (920, 1), (930, 1), (940, 1), (950, 1), (960, 1), (970, 1), (980, 0), (990, 0), (1000, 0), (1010, 1), (1020, 1), (1030, 1), (1040, 1), (1050, 0), (1060, 0), (1070, 0), (1080, 0), (1090, 0), (1100, 0), (1110, 0), (1120, 0), (1130, 0), (1140, 0), (1150, 1), (1160, 1), (1170, 1), (1180, 1), (1190, 1), (1200, 1), (1210, 0), (1220, 0), (1230, 1), (1240, 1), (1250, 0), (1260, 0), (1270, 0), (1280, 0), (1290, 1), (1300, 1), (1310, 1), (1320, 1), (1330, 0), (1340, 1), (1350, 1), (1360, 1), (1370, 1), (1380, 1), (1390, 1), (1400, 1), (1410, 1), (1420, 1), (1430, 1), (1440, 1), (1450, 1), (1460, 1), (1470, 1), (1480, 1), (1490, 1), (1500, 1), (1510, 1), (1520, 1), (1530, 1), (1540, 1), (1550, 0), (1560, 0), (1570, 0), (1580, 0), (1590, 0), (1600, 1), (1610, 1), (1620, 1), (1630, 1), (1640, 1), (1650, 1), (1660, 0), (1670, 0), (1680, 1), (1690, 1), (1700, 1), (1710, 1), (1720, 1), (1730, 0), (1740, 1), (1750, 1), (1760, 1), (1770, 1), (1780, 1), (1790, 1), (1800, 1), (1810, 0), (1820, 0), (1830, 0), (1840, 0), (1850, 0), (1860, 1), (1870, 1), (1880, 1), (1890, 1), (1900, 1), (1910, 1), (1920, 1), (1930, 1), (1940, 1), (1950, 1), (1960, 1), (1970, 1), (1980, 1), (1990, 1), (2000, 1), (2010, 1), (2020, 1), (2030, 1), (2040, 1), (2050, 1)]
VWMASK0_2  WMASK0_2  0 PWL (0n 0.0v 9.495n 0.0v 9.505n 1.95v 19.495n 1.95v 19.505n 1.95v 29.495n 1.95v 29.505n 1.95v 39.495n 1.95v 39.505n 1.95v 49.495n 1.95v 49.505n 1.95v 59.495n 1.95v 59.505n 0.0v 69.495n 0.0v 69.505n 1.95v 79.495n 1.95v 79.505n 1.95v 89.495n 1.95v 89.505n 1.95v 99.495n 1.95v 99.505n 1.95v 109.495n 1.95v 109.505n 1.95v 119.495n 1.95v 119.505n 1.95v 129.495n 1.95v 129.505n 1.95v 139.495n 1.95v 139.505n 1.95v 149.495n 1.95v 149.505n 1.95v 159.495n 1.95v 159.505n 0.0v 169.495n 0.0v 169.505n 0.0v 179.495n 0.0v 179.505n 0.0v 189.495n 0.0v 189.505n 0.0v 199.495n 0.0v 199.505n 0.0v 209.495n 0.0v 209.505n 0.0v 219.495n 0.0v 219.505n 0.0v 229.495n 0.0v 229.505n 0.0v 239.495n 0.0v 239.505n 0.0v 249.495n 0.0v 249.505n 0.0v 259.495n 0.0v 259.505n 0.0v 269.495n 0.0v 269.505n 1.95v 279.495n 1.95v 279.505n 1.95v 289.495n 1.95v 289.505n 1.95v 299.495n 1.95v 299.505n 1.95v 309.495n 1.95v 309.505n 1.95v 319.495n 1.95v 319.505n 1.95v 329.495n 1.95v 329.505n 1.95v 339.495n 1.95v 339.505n 1.95v 349.495n 1.95v 349.505n 1.95v 359.495n 1.95v 359.505n 1.95v 369.495n 1.95v 369.505n 1.95v 379.495n 1.95v 379.505n 1.95v 389.495n 1.95v 389.505n 1.95v 399.495n 1.95v 399.505n 1.95v 409.495n 1.95v 409.505n 1.95v 419.495n 1.95v 419.505n 1.95v 429.495n 1.95v 429.505n 1.95v 439.495n 1.95v 439.505n 1.95v 449.495n 1.95v 449.505n 1.95v 459.495n 1.95v 459.505n 1.95v 469.495n 1.95v 469.505n 1.95v 479.495n 1.95v 479.505n 1.95v 489.495n 1.95v 489.505n 1.95v 499.495n 1.95v 499.505n 1.95v 509.495n 1.95v 509.505n 1.95v 519.495n 1.95v 519.505n 1.95v 529.495n 1.95v 529.505n 1.95v 539.495n 1.95v 539.505n 1.95v 549.495n 1.95v 549.505n 1.95v 559.495n 1.95v 559.505n 1.95v 569.495n 1.95v 569.505n 1.95v 579.495n 1.95v 579.505n 1.95v 589.495n 1.95v 589.505n 1.95v 599.495n 1.95v 599.505n 1.95v 609.495n 1.95v 609.505n 1.95v 619.495n 1.95v 619.505n 1.95v 629.495n 1.95v 629.505n 1.95v 639.495n 1.95v 639.505n 1.95v 649.495n 1.95v 649.505n 0.0v 659.495n 0.0v 659.505n 0.0v 669.495n 0.0v 669.505n 1.95v 679.495n 1.95v 679.505n 1.95v 689.495n 1.95v 689.505n 1.95v 699.495n 1.95v 699.505n 1.95v 709.495n 1.95v 709.505n 1.95v 719.495n 1.95v 719.505n 1.95v 729.495n 1.95v 729.505n 1.95v 739.495n 1.95v 739.505n 1.95v 749.495n 1.95v 749.505n 1.95v 759.495n 1.95v 759.505n 1.95v 769.495n 1.95v 769.505n 1.95v 779.495n 1.95v 779.505n 1.95v 789.495n 1.95v 789.505n 1.95v 799.495n 1.95v 799.505n 1.95v 809.495n 1.95v 809.505n 0.0v 819.495n 0.0v 819.505n 0.0v 829.495n 0.0v 829.505n 0.0v 839.495n 0.0v 839.505n 0.0v 849.495n 0.0v 849.505n 1.95v 859.495n 1.95v 859.505n 1.95v 869.495n 1.95v 869.505n 1.95v 879.495n 1.95v 879.505n 1.95v 889.495n 1.95v 889.505n 1.95v 899.495n 1.95v 899.505n 1.95v 909.495n 1.95v 909.505n 1.95v 919.495n 1.95v 919.505n 1.95v 929.495n 1.95v 929.505n 1.95v 939.495n 1.95v 939.505n 1.95v 949.495n 1.95v 949.505n 1.95v 959.495n 1.95v 959.505n 1.95v 969.495n 1.95v 969.505n 1.95v 979.495n 1.95v 979.505n 0.0v 989.495n 0.0v 989.505n 0.0v 999.495n 0.0v 999.505n 0.0v 1009.495n 0.0v 1009.505n 1.95v 1019.495n 1.95v 1019.505n 1.95v 1029.495n 1.95v 1029.505n 1.95v 1039.495n 1.95v 1039.505n 1.95v 1049.495n 1.95v 1049.505n 0.0v 1059.495n 0.0v 1059.505n 0.0v 1069.495n 0.0v 1069.505n 0.0v 1079.495n 0.0v 1079.505n 0.0v 1089.495n 0.0v 1089.505n 0.0v 1099.495n 0.0v 1099.505n 0.0v 1109.495n 0.0v 1109.505n 0.0v 1119.495n 0.0v 1119.505n 0.0v 1129.495n 0.0v 1129.505n 0.0v 1139.495n 0.0v 1139.505n 0.0v 1149.495n 0.0v 1149.505n 1.95v 1159.495n 1.95v 1159.505n 1.95v 1169.495n 1.95v 1169.505n 1.95v 1179.495n 1.95v 1179.505n 1.95v 1189.495n 1.95v 1189.505n 1.95v 1199.495n 1.95v 1199.505n 1.95v 1209.495n 1.95v 1209.505n 0.0v 1219.495n 0.0v 1219.505n 0.0v 1229.495n 0.0v 1229.505n 1.95v 1239.495n 1.95v 1239.505n 1.95v 1249.495n 1.95v 1249.505n 0.0v 1259.495n 0.0v 1259.505n 0.0v 1269.495n 0.0v 1269.505n 0.0v 1279.495n 0.0v 1279.505n 0.0v 1289.495n 0.0v 1289.505n 1.95v 1299.495n 1.95v 1299.505n 1.95v 1309.495n 1.95v 1309.505n 1.95v 1319.495n 1.95v 1319.505n 1.95v 1329.495n 1.95v 1329.505n 0.0v 1339.495n 0.0v 1339.505n 1.95v 1349.495n 1.95v 1349.505n 1.95v 1359.495n 1.95v 1359.505n 1.95v 1369.495n 1.95v 1369.505n 1.95v 1379.495n 1.95v 1379.505n 1.95v 1389.495n 1.95v 1389.505n 1.95v 1399.495n 1.95v 1399.505n 1.95v 1409.495n 1.95v 1409.505n 1.95v 1419.495n 1.95v 1419.505n 1.95v 1429.495n 1.95v 1429.505n 1.95v 1439.495n 1.95v 1439.505n 1.95v 1449.495n 1.95v 1449.505n 1.95v 1459.495n 1.95v 1459.505n 1.95v 1469.495n 1.95v 1469.505n 1.95v 1479.495n 1.95v 1479.505n 1.95v 1489.495n 1.95v 1489.505n 1.95v 1499.495n 1.95v 1499.505n 1.95v 1509.495n 1.95v 1509.505n 1.95v 1519.495n 1.95v 1519.505n 1.95v 1529.495n 1.95v 1529.505n 1.95v 1539.495n 1.95v 1539.505n 1.95v 1549.495n 1.95v 1549.505n 0.0v 1559.495n 0.0v 1559.505n 0.0v 1569.495n 0.0v 1569.505n 0.0v 1579.495n 0.0v 1579.505n 0.0v 1589.495n 0.0v 1589.505n 0.0v 1599.495n 0.0v 1599.505n 1.95v 1609.495n 1.95v 1609.505n 1.95v 1619.495n 1.95v 1619.505n 1.95v 1629.495n 1.95v 1629.505n 1.95v 1639.495n 1.95v 1639.505n 1.95v 1649.495n 1.95v 1649.505n 1.95v 1659.495n 1.95v 1659.505n 0.0v 1669.495n 0.0v 1669.505n 0.0v 1679.495n 0.0v 1679.505n 1.95v 1689.495n 1.95v 1689.505n 1.95v 1699.495n 1.95v 1699.505n 1.95v 1709.495n 1.95v 1709.505n 1.95v 1719.495n 1.95v 1719.505n 1.95v 1729.495n 1.95v 1729.505n 0.0v 1739.495n 0.0v 1739.505n 1.95v 1749.495n 1.95v 1749.505n 1.95v 1759.495n 1.95v 1759.505n 1.95v 1769.495n 1.95v 1769.505n 1.95v 1779.495n 1.95v 1779.505n 1.95v 1789.495n 1.95v 1789.505n 1.95v 1799.495n 1.95v 1799.505n 1.95v 1809.495n 1.95v 1809.505n 0.0v 1819.495n 0.0v 1819.505n 0.0v 1829.495n 0.0v 1829.505n 0.0v 1839.495n 0.0v 1839.505n 0.0v 1849.495n 0.0v 1849.505n 0.0v 1859.495n 0.0v 1859.505n 1.95v 1869.495n 1.95v 1869.505n 1.95v 1879.495n 1.95v 1879.505n 1.95v 1889.495n 1.95v 1889.505n 1.95v 1899.495n 1.95v 1899.505n 1.95v 1909.495n 1.95v 1909.505n 1.95v 1919.495n 1.95v 1919.505n 1.95v 1929.495n 1.95v 1929.505n 1.95v 1939.495n 1.95v 1939.505n 1.95v 1949.495n 1.95v 1949.505n 1.95v 1959.495n 1.95v 1959.505n 1.95v 1969.495n 1.95v 1969.505n 1.95v 1979.495n 1.95v 1979.505n 1.95v 1989.495n 1.95v 1989.505n 1.95v 1999.495n 1.95v 1999.505n 1.95v 2009.495n 1.95v 2009.505n 1.95v 2019.495n 1.95v 2019.505n 1.95v 2029.495n 1.95v 2029.505n 1.95v 2039.495n 1.95v 2039.505n 1.95v 2049.495n 1.95v 2049.505n 1.95v )
* (time, data): [(0, 0), (10, 1), (20, 1), (30, 1), (40, 1), (50, 1), (60, 0), (70, 1), (80, 1), (90, 1), (100, 1), (110, 1), (120, 1), (130, 1), (140, 1), (150, 1), (160, 0), (170, 0), (180, 0), (190, 0), (200, 0), (210, 0), (220, 0), (230, 0), (240, 1), (250, 1), (260, 1), (270, 0), (280, 0), (290, 0), (300, 1), (310, 1), (320, 1), (330, 1), (340, 1), (350, 1), (360, 1), (370, 1), (380, 1), (390, 1), (400, 1), (410, 1), (420, 1), (430, 1), (440, 1), (450, 1), (460, 1), (470, 1), (480, 1), (490, 1), (500, 1), (510, 1), (520, 1), (530, 1), (540, 1), (550, 1), (560, 1), (570, 1), (580, 1), (590, 1), (600, 1), (610, 1), (620, 1), (630, 1), (640, 1), (650, 1), (660, 1), (670, 1), (680, 1), (690, 1), (700, 0), (710, 0), (720, 0), (730, 1), (740, 1), (750, 1), (760, 1), (770, 1), (780, 0), (790, 0), (800, 0), (810, 1), (820, 1), (830, 1), (840, 1), (850, 1), (860, 1), (870, 1), (880, 1), (890, 1), (900, 1), (910, 1), (920, 1), (930, 1), (940, 1), (950, 1), (960, 1), (970, 1), (980, 1), (990, 0), (1000, 0), (1010, 0), (1020, 0), (1030, 1), (1040, 1), (1050, 1), (1060, 1), (1070, 1), (1080, 1), (1090, 1), (1100, 1), (1110, 1), (1120, 1), (1130, 1), (1140, 1), (1150, 1), (1160, 1), (1170, 1), (1180, 1), (1190, 1), (1200, 1), (1210, 0), (1220, 0), (1230, 1), (1240, 0), (1250, 1), (1260, 1), (1270, 1), (1280, 1), (1290, 1), (1300, 1), (1310, 1), (1320, 0), (1330, 1), (1340, 1), (1350, 1), (1360, 1), (1370, 1), (1380, 1), (1390, 0), (1400, 0), (1410, 0), (1420, 1), (1430, 1), (1440, 1), (1450, 1), (1460, 1), (1470, 1), (1480, 1), (1490, 1), (1500, 1), (1510, 1), (1520, 1), (1530, 1), (1540, 1), (1550, 0), (1560, 1), (1570, 1), (1580, 1), (1590, 1), (1600, 1), (1610, 1), (1620, 1), (1630, 1), (1640, 1), (1650, 1), (1660, 1), (1670, 1), (1680, 1), (1690, 1), (1700, 1), (1710, 1), (1720, 1), (1730, 1), (1740, 1), (1750, 1), (1760, 1), (1770, 1), (1780, 1), (1790, 1), (1800, 1), (1810, 0), (1820, 0), (1830, 0), (1840, 1), (1850, 1), (1860, 1), (1870, 1), (1880, 1), (1890, 1), (1900, 1), (1910, 1), (1920, 1), (1930, 1), (1940, 1), (1950, 0), (1960, 1), (1970, 0), (1980, 0), (1990, 0), (2000, 0), (2010, 0), (2020, 0), (2030, 0), (2040, 0), (2050, 0)]
VWMASK0_3  WMASK0_3  0 PWL (0n 0.0v 9.495n 0.0v 9.505n 1.95v 19.495n 1.95v 19.505n 1.95v 29.495n 1.95v 29.505n 1.95v 39.495n 1.95v 39.505n 1.95v 49.495n 1.95v 49.505n 1.95v 59.495n 1.95v 59.505n 0.0v 69.495n 0.0v 69.505n 1.95v 79.495n 1.95v 79.505n 1.95v 89.495n 1.95v 89.505n 1.95v 99.495n 1.95v 99.505n 1.95v 109.495n 1.95v 109.505n 1.95v 119.495n 1.95v 119.505n 1.95v 129.495n 1.95v 129.505n 1.95v 139.495n 1.95v 139.505n 1.95v 149.495n 1.95v 149.505n 1.95v 159.495n 1.95v 159.505n 0.0v 169.495n 0.0v 169.505n 0.0v 179.495n 0.0v 179.505n 0.0v 189.495n 0.0v 189.505n 0.0v 199.495n 0.0v 199.505n 0.0v 209.495n 0.0v 209.505n 0.0v 219.495n 0.0v 219.505n 0.0v 229.495n 0.0v 229.505n 0.0v 239.495n 0.0v 239.505n 1.95v 249.495n 1.95v 249.505n 1.95v 259.495n 1.95v 259.505n 1.95v 269.495n 1.95v 269.505n 0.0v 279.495n 0.0v 279.505n 0.0v 289.495n 0.0v 289.505n 0.0v 299.495n 0.0v 299.505n 1.95v 309.495n 1.95v 309.505n 1.95v 319.495n 1.95v 319.505n 1.95v 329.495n 1.95v 329.505n 1.95v 339.495n 1.95v 339.505n 1.95v 349.495n 1.95v 349.505n 1.95v 359.495n 1.95v 359.505n 1.95v 369.495n 1.95v 369.505n 1.95v 379.495n 1.95v 379.505n 1.95v 389.495n 1.95v 389.505n 1.95v 399.495n 1.95v 399.505n 1.95v 409.495n 1.95v 409.505n 1.95v 419.495n 1.95v 419.505n 1.95v 429.495n 1.95v 429.505n 1.95v 439.495n 1.95v 439.505n 1.95v 449.495n 1.95v 449.505n 1.95v 459.495n 1.95v 459.505n 1.95v 469.495n 1.95v 469.505n 1.95v 479.495n 1.95v 479.505n 1.95v 489.495n 1.95v 489.505n 1.95v 499.495n 1.95v 499.505n 1.95v 509.495n 1.95v 509.505n 1.95v 519.495n 1.95v 519.505n 1.95v 529.495n 1.95v 529.505n 1.95v 539.495n 1.95v 539.505n 1.95v 549.495n 1.95v 549.505n 1.95v 559.495n 1.95v 559.505n 1.95v 569.495n 1.95v 569.505n 1.95v 579.495n 1.95v 579.505n 1.95v 589.495n 1.95v 589.505n 1.95v 599.495n 1.95v 599.505n 1.95v 609.495n 1.95v 609.505n 1.95v 619.495n 1.95v 619.505n 1.95v 629.495n 1.95v 629.505n 1.95v 639.495n 1.95v 639.505n 1.95v 649.495n 1.95v 649.505n 1.95v 659.495n 1.95v 659.505n 1.95v 669.495n 1.95v 669.505n 1.95v 679.495n 1.95v 679.505n 1.95v 689.495n 1.95v 689.505n 1.95v 699.495n 1.95v 699.505n 0.0v 709.495n 0.0v 709.505n 0.0v 719.495n 0.0v 719.505n 0.0v 729.495n 0.0v 729.505n 1.95v 739.495n 1.95v 739.505n 1.95v 749.495n 1.95v 749.505n 1.95v 759.495n 1.95v 759.505n 1.95v 769.495n 1.95v 769.505n 1.95v 779.495n 1.95v 779.505n 0.0v 789.495n 0.0v 789.505n 0.0v 799.495n 0.0v 799.505n 0.0v 809.495n 0.0v 809.505n 1.95v 819.495n 1.95v 819.505n 1.95v 829.495n 1.95v 829.505n 1.95v 839.495n 1.95v 839.505n 1.95v 849.495n 1.95v 849.505n 1.95v 859.495n 1.95v 859.505n 1.95v 869.495n 1.95v 869.505n 1.95v 879.495n 1.95v 879.505n 1.95v 889.495n 1.95v 889.505n 1.95v 899.495n 1.95v 899.505n 1.95v 909.495n 1.95v 909.505n 1.95v 919.495n 1.95v 919.505n 1.95v 929.495n 1.95v 929.505n 1.95v 939.495n 1.95v 939.505n 1.95v 949.495n 1.95v 949.505n 1.95v 959.495n 1.95v 959.505n 1.95v 969.495n 1.95v 969.505n 1.95v 979.495n 1.95v 979.505n 1.95v 989.495n 1.95v 989.505n 0.0v 999.495n 0.0v 999.505n 0.0v 1009.495n 0.0v 1009.505n 0.0v 1019.495n 0.0v 1019.505n 0.0v 1029.495n 0.0v 1029.505n 1.95v 1039.495n 1.95v 1039.505n 1.95v 1049.495n 1.95v 1049.505n 1.95v 1059.495n 1.95v 1059.505n 1.95v 1069.495n 1.95v 1069.505n 1.95v 1079.495n 1.95v 1079.505n 1.95v 1089.495n 1.95v 1089.505n 1.95v 1099.495n 1.95v 1099.505n 1.95v 1109.495n 1.95v 1109.505n 1.95v 1119.495n 1.95v 1119.505n 1.95v 1129.495n 1.95v 1129.505n 1.95v 1139.495n 1.95v 1139.505n 1.95v 1149.495n 1.95v 1149.505n 1.95v 1159.495n 1.95v 1159.505n 1.95v 1169.495n 1.95v 1169.505n 1.95v 1179.495n 1.95v 1179.505n 1.95v 1189.495n 1.95v 1189.505n 1.95v 1199.495n 1.95v 1199.505n 1.95v 1209.495n 1.95v 1209.505n 0.0v 1219.495n 0.0v 1219.505n 0.0v 1229.495n 0.0v 1229.505n 1.95v 1239.495n 1.95v 1239.505n 0.0v 1249.495n 0.0v 1249.505n 1.95v 1259.495n 1.95v 1259.505n 1.95v 1269.495n 1.95v 1269.505n 1.95v 1279.495n 1.95v 1279.505n 1.95v 1289.495n 1.95v 1289.505n 1.95v 1299.495n 1.95v 1299.505n 1.95v 1309.495n 1.95v 1309.505n 1.95v 1319.495n 1.95v 1319.505n 0.0v 1329.495n 0.0v 1329.505n 1.95v 1339.495n 1.95v 1339.505n 1.95v 1349.495n 1.95v 1349.505n 1.95v 1359.495n 1.95v 1359.505n 1.95v 1369.495n 1.95v 1369.505n 1.95v 1379.495n 1.95v 1379.505n 1.95v 1389.495n 1.95v 1389.505n 0.0v 1399.495n 0.0v 1399.505n 0.0v 1409.495n 0.0v 1409.505n 0.0v 1419.495n 0.0v 1419.505n 1.95v 1429.495n 1.95v 1429.505n 1.95v 1439.495n 1.95v 1439.505n 1.95v 1449.495n 1.95v 1449.505n 1.95v 1459.495n 1.95v 1459.505n 1.95v 1469.495n 1.95v 1469.505n 1.95v 1479.495n 1.95v 1479.505n 1.95v 1489.495n 1.95v 1489.505n 1.95v 1499.495n 1.95v 1499.505n 1.95v 1509.495n 1.95v 1509.505n 1.95v 1519.495n 1.95v 1519.505n 1.95v 1529.495n 1.95v 1529.505n 1.95v 1539.495n 1.95v 1539.505n 1.95v 1549.495n 1.95v 1549.505n 0.0v 1559.495n 0.0v 1559.505n 1.95v 1569.495n 1.95v 1569.505n 1.95v 1579.495n 1.95v 1579.505n 1.95v 1589.495n 1.95v 1589.505n 1.95v 1599.495n 1.95v 1599.505n 1.95v 1609.495n 1.95v 1609.505n 1.95v 1619.495n 1.95v 1619.505n 1.95v 1629.495n 1.95v 1629.505n 1.95v 1639.495n 1.95v 1639.505n 1.95v 1649.495n 1.95v 1649.505n 1.95v 1659.495n 1.95v 1659.505n 1.95v 1669.495n 1.95v 1669.505n 1.95v 1679.495n 1.95v 1679.505n 1.95v 1689.495n 1.95v 1689.505n 1.95v 1699.495n 1.95v 1699.505n 1.95v 1709.495n 1.95v 1709.505n 1.95v 1719.495n 1.95v 1719.505n 1.95v 1729.495n 1.95v 1729.505n 1.95v 1739.495n 1.95v 1739.505n 1.95v 1749.495n 1.95v 1749.505n 1.95v 1759.495n 1.95v 1759.505n 1.95v 1769.495n 1.95v 1769.505n 1.95v 1779.495n 1.95v 1779.505n 1.95v 1789.495n 1.95v 1789.505n 1.95v 1799.495n 1.95v 1799.505n 1.95v 1809.495n 1.95v 1809.505n 0.0v 1819.495n 0.0v 1819.505n 0.0v 1829.495n 0.0v 1829.505n 0.0v 1839.495n 0.0v 1839.505n 1.95v 1849.495n 1.95v 1849.505n 1.95v 1859.495n 1.95v 1859.505n 1.95v 1869.495n 1.95v 1869.505n 1.95v 1879.495n 1.95v 1879.505n 1.95v 1889.495n 1.95v 1889.505n 1.95v 1899.495n 1.95v 1899.505n 1.95v 1909.495n 1.95v 1909.505n 1.95v 1919.495n 1.95v 1919.505n 1.95v 1929.495n 1.95v 1929.505n 1.95v 1939.495n 1.95v 1939.505n 1.95v 1949.495n 1.95v 1949.505n 0.0v 1959.495n 0.0v 1959.505n 1.95v 1969.495n 1.95v 1969.505n 0.0v 1979.495n 0.0v 1979.505n 0.0v 1989.495n 0.0v 1989.505n 0.0v 1999.495n 0.0v 1999.505n 0.0v 2009.495n 0.0v 2009.505n 0.0v 2019.495n 0.0v 2019.505n 0.0v 2029.495n 0.0v 2029.505n 0.0v 2039.495n 0.0v 2039.505n 0.0v 2049.495n 0.0v 2049.505n 0.0v )
* PULSE: period=10
Vclk0 clk0 0 PULSE (0 1.95 9.995n 0.01n 0.01n 4.99n 10n)
* PULSE: period=10
Vclk1 clk1 0 PULSE (0 1.95 9.995n 0.01n 0.01n 4.99n 10n)

 * Generation of dout measurements
* CHECK dout0_0 vdout0_0ck4 = 1.95 time = 50
* CHECK dout0_1 vdout0_1ck4 = 1.95 time = 50
* CHECK dout0_2 vdout0_2ck4 = 1.95 time = 50
* CHECK dout0_3 vdout0_3ck4 = 0 time = 50
* CHECK dout0_4 vdout0_4ck4 = 0 time = 50
* CHECK dout0_5 vdout0_5ck4 = 1.95 time = 50
* CHECK dout0_6 vdout0_6ck4 = 0 time = 50
* CHECK dout0_7 vdout0_7ck4 = 1.95 time = 50
* CHECK dout0_8 vdout0_8ck4 = 1.95 time = 50
* CHECK dout0_9 vdout0_9ck4 = 1.95 time = 50
* CHECK dout0_10 vdout0_10ck4 = 0 time = 50
* CHECK dout0_11 vdout0_11ck4 = 0 time = 50
* CHECK dout0_12 vdout0_12ck4 = 1.95 time = 50
* CHECK dout0_13 vdout0_13ck4 = 1.95 time = 50
* CHECK dout0_14 vdout0_14ck4 = 0 time = 50
* CHECK dout0_15 vdout0_15ck4 = 1.95 time = 50
* CHECK dout0_16 vdout0_16ck4 = 1.95 time = 50
* CHECK dout0_17 vdout0_17ck4 = 0 time = 50
* CHECK dout0_18 vdout0_18ck4 = 0 time = 50
* CHECK dout0_19 vdout0_19ck4 = 1.95 time = 50
* CHECK dout0_20 vdout0_20ck4 = 1.95 time = 50
* CHECK dout0_21 vdout0_21ck4 = 0 time = 50
* CHECK dout0_22 vdout0_22ck4 = 0 time = 50
* CHECK dout0_23 vdout0_23ck4 = 1.95 time = 50
* CHECK dout0_24 vdout0_24ck4 = 1.95 time = 50
* CHECK dout0_25 vdout0_25ck4 = 1.95 time = 50
* CHECK dout0_26 vdout0_26ck4 = 0 time = 50
* CHECK dout0_27 vdout0_27ck4 = 0 time = 50
* CHECK dout0_28 vdout0_28ck4 = 1.95 time = 50
* CHECK dout0_29 vdout0_29ck4 = 0 time = 50
* CHECK dout0_30 vdout0_30ck4 = 1.95 time = 50
* CHECK dout0_31 vdout0_31ck4 = 1.95 time = 50
* CHECK dout1_0 vdout1_0ck4 = 1.95 time = 50
* CHECK dout1_1 vdout1_1ck4 = 1.95 time = 50
* CHECK dout1_2 vdout1_2ck4 = 1.95 time = 50
* CHECK dout1_3 vdout1_3ck4 = 0 time = 50
* CHECK dout1_4 vdout1_4ck4 = 0 time = 50
* CHECK dout1_5 vdout1_5ck4 = 1.95 time = 50
* CHECK dout1_6 vdout1_6ck4 = 0 time = 50
* CHECK dout1_7 vdout1_7ck4 = 1.95 time = 50
* CHECK dout1_8 vdout1_8ck4 = 1.95 time = 50
* CHECK dout1_9 vdout1_9ck4 = 1.95 time = 50
* CHECK dout1_10 vdout1_10ck4 = 0 time = 50
* CHECK dout1_11 vdout1_11ck4 = 0 time = 50
* CHECK dout1_12 vdout1_12ck4 = 1.95 time = 50
* CHECK dout1_13 vdout1_13ck4 = 1.95 time = 50
* CHECK dout1_14 vdout1_14ck4 = 0 time = 50
* CHECK dout1_15 vdout1_15ck4 = 1.95 time = 50
* CHECK dout1_16 vdout1_16ck4 = 1.95 time = 50
* CHECK dout1_17 vdout1_17ck4 = 0 time = 50
* CHECK dout1_18 vdout1_18ck4 = 0 time = 50
* CHECK dout1_19 vdout1_19ck4 = 1.95 time = 50
* CHECK dout1_20 vdout1_20ck4 = 1.95 time = 50
* CHECK dout1_21 vdout1_21ck4 = 0 time = 50
* CHECK dout1_22 vdout1_22ck4 = 0 time = 50
* CHECK dout1_23 vdout1_23ck4 = 1.95 time = 50
* CHECK dout1_24 vdout1_24ck4 = 1.95 time = 50
* CHECK dout1_25 vdout1_25ck4 = 1.95 time = 50
* CHECK dout1_26 vdout1_26ck4 = 0 time = 50
* CHECK dout1_27 vdout1_27ck4 = 0 time = 50
* CHECK dout1_28 vdout1_28ck4 = 1.95 time = 50
* CHECK dout1_29 vdout1_29ck4 = 0 time = 50
* CHECK dout1_30 vdout1_30ck4 = 1.95 time = 50
* CHECK dout1_31 vdout1_31ck4 = 1.95 time = 50
* CHECK dout0_0 vdout0_0ck5 = 0 time = 60
* CHECK dout0_1 vdout0_1ck5 = 0 time = 60
* CHECK dout0_2 vdout0_2ck5 = 0 time = 60
* CHECK dout0_3 vdout0_3ck5 = 1.95 time = 60
* CHECK dout0_4 vdout0_4ck5 = 0 time = 60
* CHECK dout0_5 vdout0_5ck5 = 0 time = 60
* CHECK dout0_6 vdout0_6ck5 = 0 time = 60
* CHECK dout0_7 vdout0_7ck5 = 0 time = 60
* CHECK dout0_8 vdout0_8ck5 = 0 time = 60
* CHECK dout0_9 vdout0_9ck5 = 1.95 time = 60
* CHECK dout0_10 vdout0_10ck5 = 1.95 time = 60
* CHECK dout0_11 vdout0_11ck5 = 0 time = 60
* CHECK dout0_12 vdout0_12ck5 = 1.95 time = 60
* CHECK dout0_13 vdout0_13ck5 = 0 time = 60
* CHECK dout0_14 vdout0_14ck5 = 1.95 time = 60
* CHECK dout0_15 vdout0_15ck5 = 0 time = 60
* CHECK dout0_16 vdout0_16ck5 = 1.95 time = 60
* CHECK dout0_17 vdout0_17ck5 = 1.95 time = 60
* CHECK dout0_18 vdout0_18ck5 = 1.95 time = 60
* CHECK dout0_19 vdout0_19ck5 = 1.95 time = 60
* CHECK dout0_20 vdout0_20ck5 = 0 time = 60
* CHECK dout0_21 vdout0_21ck5 = 1.95 time = 60
* CHECK dout0_22 vdout0_22ck5 = 0 time = 60
* CHECK dout0_23 vdout0_23ck5 = 1.95 time = 60
* CHECK dout0_24 vdout0_24ck5 = 1.95 time = 60
* CHECK dout0_25 vdout0_25ck5 = 1.95 time = 60
* CHECK dout0_26 vdout0_26ck5 = 1.95 time = 60
* CHECK dout0_27 vdout0_27ck5 = 0 time = 60
* CHECK dout0_28 vdout0_28ck5 = 1.95 time = 60
* CHECK dout0_29 vdout0_29ck5 = 0 time = 60
* CHECK dout0_30 vdout0_30ck5 = 1.95 time = 60
* CHECK dout0_31 vdout0_31ck5 = 1.95 time = 60
* CHECK dout1_0 vdout1_0ck5 = 1.95 time = 60
* CHECK dout1_1 vdout1_1ck5 = 1.95 time = 60
* CHECK dout1_2 vdout1_2ck5 = 1.95 time = 60
* CHECK dout1_3 vdout1_3ck5 = 0 time = 60
* CHECK dout1_4 vdout1_4ck5 = 0 time = 60
* CHECK dout1_5 vdout1_5ck5 = 1.95 time = 60
* CHECK dout1_6 vdout1_6ck5 = 0 time = 60
* CHECK dout1_7 vdout1_7ck5 = 1.95 time = 60
* CHECK dout1_8 vdout1_8ck5 = 1.95 time = 60
* CHECK dout1_9 vdout1_9ck5 = 1.95 time = 60
* CHECK dout1_10 vdout1_10ck5 = 0 time = 60
* CHECK dout1_11 vdout1_11ck5 = 0 time = 60
* CHECK dout1_12 vdout1_12ck5 = 1.95 time = 60
* CHECK dout1_13 vdout1_13ck5 = 1.95 time = 60
* CHECK dout1_14 vdout1_14ck5 = 0 time = 60
* CHECK dout1_15 vdout1_15ck5 = 1.95 time = 60
* CHECK dout1_16 vdout1_16ck5 = 1.95 time = 60
* CHECK dout1_17 vdout1_17ck5 = 0 time = 60
* CHECK dout1_18 vdout1_18ck5 = 0 time = 60
* CHECK dout1_19 vdout1_19ck5 = 1.95 time = 60
* CHECK dout1_20 vdout1_20ck5 = 1.95 time = 60
* CHECK dout1_21 vdout1_21ck5 = 0 time = 60
* CHECK dout1_22 vdout1_22ck5 = 0 time = 60
* CHECK dout1_23 vdout1_23ck5 = 1.95 time = 60
* CHECK dout1_24 vdout1_24ck5 = 1.95 time = 60
* CHECK dout1_25 vdout1_25ck5 = 1.95 time = 60
* CHECK dout1_26 vdout1_26ck5 = 0 time = 60
* CHECK dout1_27 vdout1_27ck5 = 0 time = 60
* CHECK dout1_28 vdout1_28ck5 = 1.95 time = 60
* CHECK dout1_29 vdout1_29ck5 = 0 time = 60
* CHECK dout1_30 vdout1_30ck5 = 1.95 time = 60
* CHECK dout1_31 vdout1_31ck5 = 1.95 time = 60
* CHECK dout0_0 vdout0_0ck9 = 0 time = 100
* CHECK dout0_1 vdout0_1ck9 = 1.95 time = 100
* CHECK dout0_2 vdout0_2ck9 = 0 time = 100
* CHECK dout0_3 vdout0_3ck9 = 1.95 time = 100
* CHECK dout0_4 vdout0_4ck9 = 1.95 time = 100
* CHECK dout0_5 vdout0_5ck9 = 0 time = 100
* CHECK dout0_6 vdout0_6ck9 = 1.95 time = 100
* CHECK dout0_7 vdout0_7ck9 = 0 time = 100
* CHECK dout0_8 vdout0_8ck9 = 1.95 time = 100
* CHECK dout0_9 vdout0_9ck9 = 1.95 time = 100
* CHECK dout0_10 vdout0_10ck9 = 1.95 time = 100
* CHECK dout0_11 vdout0_11ck9 = 1.95 time = 100
* CHECK dout0_12 vdout0_12ck9 = 0 time = 100
* CHECK dout0_13 vdout0_13ck9 = 1.95 time = 100
* CHECK dout0_14 vdout0_14ck9 = 0 time = 100
* CHECK dout0_15 vdout0_15ck9 = 0 time = 100
* CHECK dout0_16 vdout0_16ck9 = 1.95 time = 100
* CHECK dout0_17 vdout0_17ck9 = 1.95 time = 100
* CHECK dout0_18 vdout0_18ck9 = 1.95 time = 100
* CHECK dout0_19 vdout0_19ck9 = 0 time = 100
* CHECK dout0_20 vdout0_20ck9 = 0 time = 100
* CHECK dout0_21 vdout0_21ck9 = 1.95 time = 100
* CHECK dout0_22 vdout0_22ck9 = 0 time = 100
* CHECK dout0_23 vdout0_23ck9 = 0 time = 100
* CHECK dout0_24 vdout0_24ck9 = 1.95 time = 100
* CHECK dout0_25 vdout0_25ck9 = 0 time = 100
* CHECK dout0_26 vdout0_26ck9 = 1.95 time = 100
* CHECK dout0_27 vdout0_27ck9 = 0 time = 100
* CHECK dout0_28 vdout0_28ck9 = 1.95 time = 100
* CHECK dout0_29 vdout0_29ck9 = 1.95 time = 100
* CHECK dout0_30 vdout0_30ck9 = 1.95 time = 100
* CHECK dout0_31 vdout0_31ck9 = 0 time = 100
* CHECK dout1_0 vdout1_0ck9 = 0 time = 100
* CHECK dout1_1 vdout1_1ck9 = 1.95 time = 100
* CHECK dout1_2 vdout1_2ck9 = 0 time = 100
* CHECK dout1_3 vdout1_3ck9 = 1.95 time = 100
* CHECK dout1_4 vdout1_4ck9 = 1.95 time = 100
* CHECK dout1_5 vdout1_5ck9 = 0 time = 100
* CHECK dout1_6 vdout1_6ck9 = 1.95 time = 100
* CHECK dout1_7 vdout1_7ck9 = 0 time = 100
* CHECK dout1_8 vdout1_8ck9 = 1.95 time = 100
* CHECK dout1_9 vdout1_9ck9 = 1.95 time = 100
* CHECK dout1_10 vdout1_10ck9 = 1.95 time = 100
* CHECK dout1_11 vdout1_11ck9 = 1.95 time = 100
* CHECK dout1_12 vdout1_12ck9 = 0 time = 100
* CHECK dout1_13 vdout1_13ck9 = 1.95 time = 100
* CHECK dout1_14 vdout1_14ck9 = 0 time = 100
* CHECK dout1_15 vdout1_15ck9 = 0 time = 100
* CHECK dout1_16 vdout1_16ck9 = 1.95 time = 100
* CHECK dout1_17 vdout1_17ck9 = 1.95 time = 100
* CHECK dout1_18 vdout1_18ck9 = 1.95 time = 100
* CHECK dout1_19 vdout1_19ck9 = 0 time = 100
* CHECK dout1_20 vdout1_20ck9 = 0 time = 100
* CHECK dout1_21 vdout1_21ck9 = 1.95 time = 100
* CHECK dout1_22 vdout1_22ck9 = 0 time = 100
* CHECK dout1_23 vdout1_23ck9 = 0 time = 100
* CHECK dout1_24 vdout1_24ck9 = 1.95 time = 100
* CHECK dout1_25 vdout1_25ck9 = 0 time = 100
* CHECK dout1_26 vdout1_26ck9 = 1.95 time = 100
* CHECK dout1_27 vdout1_27ck9 = 0 time = 100
* CHECK dout1_28 vdout1_28ck9 = 1.95 time = 100
* CHECK dout1_29 vdout1_29ck9 = 1.95 time = 100
* CHECK dout1_30 vdout1_30ck9 = 1.95 time = 100
* CHECK dout1_31 vdout1_31ck9 = 0 time = 100
* CHECK dout0_0 vdout0_0ck12 = 0 time = 130
* CHECK dout0_1 vdout0_1ck12 = 1.95 time = 130
* CHECK dout0_2 vdout0_2ck12 = 0 time = 130
* CHECK dout0_3 vdout0_3ck12 = 1.95 time = 130
* CHECK dout0_4 vdout0_4ck12 = 1.95 time = 130
* CHECK dout0_5 vdout0_5ck12 = 0 time = 130
* CHECK dout0_6 vdout0_6ck12 = 1.95 time = 130
* CHECK dout0_7 vdout0_7ck12 = 0 time = 130
* CHECK dout0_8 vdout0_8ck12 = 1.95 time = 130
* CHECK dout0_9 vdout0_9ck12 = 1.95 time = 130
* CHECK dout0_10 vdout0_10ck12 = 1.95 time = 130
* CHECK dout0_11 vdout0_11ck12 = 1.95 time = 130
* CHECK dout0_12 vdout0_12ck12 = 0 time = 130
* CHECK dout0_13 vdout0_13ck12 = 1.95 time = 130
* CHECK dout0_14 vdout0_14ck12 = 0 time = 130
* CHECK dout0_15 vdout0_15ck12 = 0 time = 130
* CHECK dout0_16 vdout0_16ck12 = 1.95 time = 130
* CHECK dout0_17 vdout0_17ck12 = 1.95 time = 130
* CHECK dout0_18 vdout0_18ck12 = 1.95 time = 130
* CHECK dout0_19 vdout0_19ck12 = 0 time = 130
* CHECK dout0_20 vdout0_20ck12 = 0 time = 130
* CHECK dout0_21 vdout0_21ck12 = 1.95 time = 130
* CHECK dout0_22 vdout0_22ck12 = 0 time = 130
* CHECK dout0_23 vdout0_23ck12 = 0 time = 130
* CHECK dout0_24 vdout0_24ck12 = 1.95 time = 130
* CHECK dout0_25 vdout0_25ck12 = 0 time = 130
* CHECK dout0_26 vdout0_26ck12 = 1.95 time = 130
* CHECK dout0_27 vdout0_27ck12 = 0 time = 130
* CHECK dout0_28 vdout0_28ck12 = 1.95 time = 130
* CHECK dout0_29 vdout0_29ck12 = 1.95 time = 130
* CHECK dout0_30 vdout0_30ck12 = 1.95 time = 130
* CHECK dout0_31 vdout0_31ck12 = 0 time = 130
* CHECK dout1_0 vdout1_0ck12 = 0 time = 130
* CHECK dout1_1 vdout1_1ck12 = 1.95 time = 130
* CHECK dout1_2 vdout1_2ck12 = 0 time = 130
* CHECK dout1_3 vdout1_3ck12 = 1.95 time = 130
* CHECK dout1_4 vdout1_4ck12 = 1.95 time = 130
* CHECK dout1_5 vdout1_5ck12 = 0 time = 130
* CHECK dout1_6 vdout1_6ck12 = 1.95 time = 130
* CHECK dout1_7 vdout1_7ck12 = 0 time = 130
* CHECK dout1_8 vdout1_8ck12 = 1.95 time = 130
* CHECK dout1_9 vdout1_9ck12 = 1.95 time = 130
* CHECK dout1_10 vdout1_10ck12 = 1.95 time = 130
* CHECK dout1_11 vdout1_11ck12 = 1.95 time = 130
* CHECK dout1_12 vdout1_12ck12 = 0 time = 130
* CHECK dout1_13 vdout1_13ck12 = 1.95 time = 130
* CHECK dout1_14 vdout1_14ck12 = 0 time = 130
* CHECK dout1_15 vdout1_15ck12 = 0 time = 130
* CHECK dout1_16 vdout1_16ck12 = 1.95 time = 130
* CHECK dout1_17 vdout1_17ck12 = 1.95 time = 130
* CHECK dout1_18 vdout1_18ck12 = 1.95 time = 130
* CHECK dout1_19 vdout1_19ck12 = 0 time = 130
* CHECK dout1_20 vdout1_20ck12 = 0 time = 130
* CHECK dout1_21 vdout1_21ck12 = 1.95 time = 130
* CHECK dout1_22 vdout1_22ck12 = 0 time = 130
* CHECK dout1_23 vdout1_23ck12 = 0 time = 130
* CHECK dout1_24 vdout1_24ck12 = 1.95 time = 130
* CHECK dout1_25 vdout1_25ck12 = 0 time = 130
* CHECK dout1_26 vdout1_26ck12 = 1.95 time = 130
* CHECK dout1_27 vdout1_27ck12 = 0 time = 130
* CHECK dout1_28 vdout1_28ck12 = 1.95 time = 130
* CHECK dout1_29 vdout1_29ck12 = 1.95 time = 130
* CHECK dout1_30 vdout1_30ck12 = 1.95 time = 130
* CHECK dout1_31 vdout1_31ck12 = 0 time = 130
* CHECK dout1_0 vdout1_0ck13 = 1.95 time = 140
* CHECK dout1_1 vdout1_1ck13 = 0 time = 140
* CHECK dout1_2 vdout1_2ck13 = 1.95 time = 140
* CHECK dout1_3 vdout1_3ck13 = 1.95 time = 140
* CHECK dout1_4 vdout1_4ck13 = 0 time = 140
* CHECK dout1_5 vdout1_5ck13 = 0 time = 140
* CHECK dout1_6 vdout1_6ck13 = 0 time = 140
* CHECK dout1_7 vdout1_7ck13 = 1.95 time = 140
* CHECK dout1_8 vdout1_8ck13 = 1.95 time = 140
* CHECK dout1_9 vdout1_9ck13 = 0 time = 140
* CHECK dout1_10 vdout1_10ck13 = 0 time = 140
* CHECK dout1_11 vdout1_11ck13 = 0 time = 140
* CHECK dout1_12 vdout1_12ck13 = 1.95 time = 140
* CHECK dout1_13 vdout1_13ck13 = 1.95 time = 140
* CHECK dout1_14 vdout1_14ck13 = 0 time = 140
* CHECK dout1_15 vdout1_15ck13 = 1.95 time = 140
* CHECK dout1_16 vdout1_16ck13 = 1.95 time = 140
* CHECK dout1_17 vdout1_17ck13 = 1.95 time = 140
* CHECK dout1_18 vdout1_18ck13 = 1.95 time = 140
* CHECK dout1_19 vdout1_19ck13 = 1.95 time = 140
* CHECK dout1_20 vdout1_20ck13 = 0 time = 140
* CHECK dout1_21 vdout1_21ck13 = 0 time = 140
* CHECK dout1_22 vdout1_22ck13 = 0 time = 140
* CHECK dout1_23 vdout1_23ck13 = 0 time = 140
* CHECK dout1_24 vdout1_24ck13 = 0 time = 140
* CHECK dout1_25 vdout1_25ck13 = 0 time = 140
* CHECK dout1_26 vdout1_26ck13 = 0 time = 140
* CHECK dout1_27 vdout1_27ck13 = 1.95 time = 140
* CHECK dout1_28 vdout1_28ck13 = 1.95 time = 140
* CHECK dout1_29 vdout1_29ck13 = 0 time = 140
* CHECK dout1_30 vdout1_30ck13 = 1.95 time = 140
* CHECK dout1_31 vdout1_31ck13 = 0 time = 140
* CHECK dout0_0 vdout0_0ck14 = 1.95 time = 150
* CHECK dout0_1 vdout0_1ck14 = 0 time = 150
* CHECK dout0_2 vdout0_2ck14 = 1.95 time = 150
* CHECK dout0_3 vdout0_3ck14 = 1.95 time = 150
* CHECK dout0_4 vdout0_4ck14 = 0 time = 150
* CHECK dout0_5 vdout0_5ck14 = 0 time = 150
* CHECK dout0_6 vdout0_6ck14 = 0 time = 150
* CHECK dout0_7 vdout0_7ck14 = 1.95 time = 150
* CHECK dout0_8 vdout0_8ck14 = 1.95 time = 150
* CHECK dout0_9 vdout0_9ck14 = 0 time = 150
* CHECK dout0_10 vdout0_10ck14 = 0 time = 150
* CHECK dout0_11 vdout0_11ck14 = 0 time = 150
* CHECK dout0_12 vdout0_12ck14 = 1.95 time = 150
* CHECK dout0_13 vdout0_13ck14 = 1.95 time = 150
* CHECK dout0_14 vdout0_14ck14 = 0 time = 150
* CHECK dout0_15 vdout0_15ck14 = 1.95 time = 150
* CHECK dout0_16 vdout0_16ck14 = 1.95 time = 150
* CHECK dout0_17 vdout0_17ck14 = 1.95 time = 150
* CHECK dout0_18 vdout0_18ck14 = 1.95 time = 150
* CHECK dout0_19 vdout0_19ck14 = 1.95 time = 150
* CHECK dout0_20 vdout0_20ck14 = 0 time = 150
* CHECK dout0_21 vdout0_21ck14 = 0 time = 150
* CHECK dout0_22 vdout0_22ck14 = 0 time = 150
* CHECK dout0_23 vdout0_23ck14 = 0 time = 150
* CHECK dout0_24 vdout0_24ck14 = 0 time = 150
* CHECK dout0_25 vdout0_25ck14 = 0 time = 150
* CHECK dout0_26 vdout0_26ck14 = 0 time = 150
* CHECK dout0_27 vdout0_27ck14 = 1.95 time = 150
* CHECK dout0_28 vdout0_28ck14 = 1.95 time = 150
* CHECK dout0_29 vdout0_29ck14 = 0 time = 150
* CHECK dout0_30 vdout0_30ck14 = 1.95 time = 150
* CHECK dout0_31 vdout0_31ck14 = 0 time = 150
* CHECK dout1_0 vdout1_0ck14 = 0 time = 150
* CHECK dout1_1 vdout1_1ck14 = 1.95 time = 150
* CHECK dout1_2 vdout1_2ck14 = 0 time = 150
* CHECK dout1_3 vdout1_3ck14 = 1.95 time = 150
* CHECK dout1_4 vdout1_4ck14 = 1.95 time = 150
* CHECK dout1_5 vdout1_5ck14 = 0 time = 150
* CHECK dout1_6 vdout1_6ck14 = 1.95 time = 150
* CHECK dout1_7 vdout1_7ck14 = 0 time = 150
* CHECK dout1_8 vdout1_8ck14 = 1.95 time = 150
* CHECK dout1_9 vdout1_9ck14 = 1.95 time = 150
* CHECK dout1_10 vdout1_10ck14 = 1.95 time = 150
* CHECK dout1_11 vdout1_11ck14 = 1.95 time = 150
* CHECK dout1_12 vdout1_12ck14 = 0 time = 150
* CHECK dout1_13 vdout1_13ck14 = 1.95 time = 150
* CHECK dout1_14 vdout1_14ck14 = 0 time = 150
* CHECK dout1_15 vdout1_15ck14 = 0 time = 150
* CHECK dout1_16 vdout1_16ck14 = 1.95 time = 150
* CHECK dout1_17 vdout1_17ck14 = 1.95 time = 150
* CHECK dout1_18 vdout1_18ck14 = 1.95 time = 150
* CHECK dout1_19 vdout1_19ck14 = 0 time = 150
* CHECK dout1_20 vdout1_20ck14 = 0 time = 150
* CHECK dout1_21 vdout1_21ck14 = 1.95 time = 150
* CHECK dout1_22 vdout1_22ck14 = 0 time = 150
* CHECK dout1_23 vdout1_23ck14 = 0 time = 150
* CHECK dout1_24 vdout1_24ck14 = 1.95 time = 150
* CHECK dout1_25 vdout1_25ck14 = 0 time = 150
* CHECK dout1_26 vdout1_26ck14 = 1.95 time = 150
* CHECK dout1_27 vdout1_27ck14 = 0 time = 150
* CHECK dout1_28 vdout1_28ck14 = 1.95 time = 150
* CHECK dout1_29 vdout1_29ck14 = 1.95 time = 150
* CHECK dout1_30 vdout1_30ck14 = 1.95 time = 150
* CHECK dout1_31 vdout1_31ck14 = 0 time = 150
* CHECK dout1_0 vdout1_0ck15 = 0 time = 160
* CHECK dout1_1 vdout1_1ck15 = 1.95 time = 160
* CHECK dout1_2 vdout1_2ck15 = 0 time = 160
* CHECK dout1_3 vdout1_3ck15 = 1.95 time = 160
* CHECK dout1_4 vdout1_4ck15 = 1.95 time = 160
* CHECK dout1_5 vdout1_5ck15 = 0 time = 160
* CHECK dout1_6 vdout1_6ck15 = 1.95 time = 160
* CHECK dout1_7 vdout1_7ck15 = 0 time = 160
* CHECK dout1_8 vdout1_8ck15 = 1.95 time = 160
* CHECK dout1_9 vdout1_9ck15 = 1.95 time = 160
* CHECK dout1_10 vdout1_10ck15 = 1.95 time = 160
* CHECK dout1_11 vdout1_11ck15 = 1.95 time = 160
* CHECK dout1_12 vdout1_12ck15 = 0 time = 160
* CHECK dout1_13 vdout1_13ck15 = 1.95 time = 160
* CHECK dout1_14 vdout1_14ck15 = 0 time = 160
* CHECK dout1_15 vdout1_15ck15 = 0 time = 160
* CHECK dout1_16 vdout1_16ck15 = 1.95 time = 160
* CHECK dout1_17 vdout1_17ck15 = 1.95 time = 160
* CHECK dout1_18 vdout1_18ck15 = 1.95 time = 160
* CHECK dout1_19 vdout1_19ck15 = 0 time = 160
* CHECK dout1_20 vdout1_20ck15 = 0 time = 160
* CHECK dout1_21 vdout1_21ck15 = 1.95 time = 160
* CHECK dout1_22 vdout1_22ck15 = 0 time = 160
* CHECK dout1_23 vdout1_23ck15 = 0 time = 160
* CHECK dout1_24 vdout1_24ck15 = 1.95 time = 160
* CHECK dout1_25 vdout1_25ck15 = 0 time = 160
* CHECK dout1_26 vdout1_26ck15 = 1.95 time = 160
* CHECK dout1_27 vdout1_27ck15 = 0 time = 160
* CHECK dout1_28 vdout1_28ck15 = 1.95 time = 160
* CHECK dout1_29 vdout1_29ck15 = 1.95 time = 160
* CHECK dout1_30 vdout1_30ck15 = 1.95 time = 160
* CHECK dout1_31 vdout1_31ck15 = 0 time = 160
* CHECK dout0_0 vdout0_0ck17 = 1.95 time = 180
* CHECK dout0_1 vdout0_1ck17 = 0 time = 180
* CHECK dout0_2 vdout0_2ck17 = 1.95 time = 180
* CHECK dout0_3 vdout0_3ck17 = 1.95 time = 180
* CHECK dout0_4 vdout0_4ck17 = 0 time = 180
* CHECK dout0_5 vdout0_5ck17 = 0 time = 180
* CHECK dout0_6 vdout0_6ck17 = 0 time = 180
* CHECK dout0_7 vdout0_7ck17 = 1.95 time = 180
* CHECK dout0_8 vdout0_8ck17 = 1.95 time = 180
* CHECK dout0_9 vdout0_9ck17 = 0 time = 180
* CHECK dout0_10 vdout0_10ck17 = 1.95 time = 180
* CHECK dout0_11 vdout0_11ck17 = 1.95 time = 180
* CHECK dout0_12 vdout0_12ck17 = 0 time = 180
* CHECK dout0_13 vdout0_13ck17 = 0 time = 180
* CHECK dout0_14 vdout0_14ck17 = 1.95 time = 180
* CHECK dout0_15 vdout0_15ck17 = 1.95 time = 180
* CHECK dout0_16 vdout0_16ck17 = 1.95 time = 180
* CHECK dout0_17 vdout0_17ck17 = 1.95 time = 180
* CHECK dout0_18 vdout0_18ck17 = 1.95 time = 180
* CHECK dout0_19 vdout0_19ck17 = 1.95 time = 180
* CHECK dout0_20 vdout0_20ck17 = 0 time = 180
* CHECK dout0_21 vdout0_21ck17 = 0 time = 180
* CHECK dout0_22 vdout0_22ck17 = 0 time = 180
* CHECK dout0_23 vdout0_23ck17 = 0 time = 180
* CHECK dout0_24 vdout0_24ck17 = 0 time = 180
* CHECK dout0_25 vdout0_25ck17 = 0 time = 180
* CHECK dout0_26 vdout0_26ck17 = 0 time = 180
* CHECK dout0_27 vdout0_27ck17 = 1.95 time = 180
* CHECK dout0_28 vdout0_28ck17 = 1.95 time = 180
* CHECK dout0_29 vdout0_29ck17 = 0 time = 180
* CHECK dout0_30 vdout0_30ck17 = 1.95 time = 180
* CHECK dout0_31 vdout0_31ck17 = 0 time = 180
* CHECK dout1_0 vdout1_0ck17 = 1.95 time = 180
* CHECK dout1_1 vdout1_1ck17 = 0 time = 180
* CHECK dout1_2 vdout1_2ck17 = 1.95 time = 180
* CHECK dout1_3 vdout1_3ck17 = 1.95 time = 180
* CHECK dout1_4 vdout1_4ck17 = 0 time = 180
* CHECK dout1_5 vdout1_5ck17 = 0 time = 180
* CHECK dout1_6 vdout1_6ck17 = 0 time = 180
* CHECK dout1_7 vdout1_7ck17 = 1.95 time = 180
* CHECK dout1_8 vdout1_8ck17 = 1.95 time = 180
* CHECK dout1_9 vdout1_9ck17 = 0 time = 180
* CHECK dout1_10 vdout1_10ck17 = 1.95 time = 180
* CHECK dout1_11 vdout1_11ck17 = 1.95 time = 180
* CHECK dout1_12 vdout1_12ck17 = 0 time = 180
* CHECK dout1_13 vdout1_13ck17 = 0 time = 180
* CHECK dout1_14 vdout1_14ck17 = 1.95 time = 180
* CHECK dout1_15 vdout1_15ck17 = 1.95 time = 180
* CHECK dout1_16 vdout1_16ck17 = 1.95 time = 180
* CHECK dout1_17 vdout1_17ck17 = 1.95 time = 180
* CHECK dout1_18 vdout1_18ck17 = 1.95 time = 180
* CHECK dout1_19 vdout1_19ck17 = 1.95 time = 180
* CHECK dout1_20 vdout1_20ck17 = 0 time = 180
* CHECK dout1_21 vdout1_21ck17 = 0 time = 180
* CHECK dout1_22 vdout1_22ck17 = 0 time = 180
* CHECK dout1_23 vdout1_23ck17 = 0 time = 180
* CHECK dout1_24 vdout1_24ck17 = 0 time = 180
* CHECK dout1_25 vdout1_25ck17 = 0 time = 180
* CHECK dout1_26 vdout1_26ck17 = 0 time = 180
* CHECK dout1_27 vdout1_27ck17 = 1.95 time = 180
* CHECK dout1_28 vdout1_28ck17 = 1.95 time = 180
* CHECK dout1_29 vdout1_29ck17 = 0 time = 180
* CHECK dout1_30 vdout1_30ck17 = 1.95 time = 180
* CHECK dout1_31 vdout1_31ck17 = 0 time = 180
* CHECK dout0_0 vdout0_0ck18 = 1.95 time = 190
* CHECK dout0_1 vdout0_1ck18 = 0 time = 190
* CHECK dout0_2 vdout0_2ck18 = 1.95 time = 190
* CHECK dout0_3 vdout0_3ck18 = 1.95 time = 190
* CHECK dout0_4 vdout0_4ck18 = 0 time = 190
* CHECK dout0_5 vdout0_5ck18 = 0 time = 190
* CHECK dout0_6 vdout0_6ck18 = 0 time = 190
* CHECK dout0_7 vdout0_7ck18 = 1.95 time = 190
* CHECK dout0_8 vdout0_8ck18 = 1.95 time = 190
* CHECK dout0_9 vdout0_9ck18 = 0 time = 190
* CHECK dout0_10 vdout0_10ck18 = 1.95 time = 190
* CHECK dout0_11 vdout0_11ck18 = 1.95 time = 190
* CHECK dout0_12 vdout0_12ck18 = 0 time = 190
* CHECK dout0_13 vdout0_13ck18 = 0 time = 190
* CHECK dout0_14 vdout0_14ck18 = 1.95 time = 190
* CHECK dout0_15 vdout0_15ck18 = 1.95 time = 190
* CHECK dout0_16 vdout0_16ck18 = 1.95 time = 190
* CHECK dout0_17 vdout0_17ck18 = 1.95 time = 190
* CHECK dout0_18 vdout0_18ck18 = 1.95 time = 190
* CHECK dout0_19 vdout0_19ck18 = 1.95 time = 190
* CHECK dout0_20 vdout0_20ck18 = 0 time = 190
* CHECK dout0_21 vdout0_21ck18 = 0 time = 190
* CHECK dout0_22 vdout0_22ck18 = 0 time = 190
* CHECK dout0_23 vdout0_23ck18 = 0 time = 190
* CHECK dout0_24 vdout0_24ck18 = 0 time = 190
* CHECK dout0_25 vdout0_25ck18 = 0 time = 190
* CHECK dout0_26 vdout0_26ck18 = 0 time = 190
* CHECK dout0_27 vdout0_27ck18 = 1.95 time = 190
* CHECK dout0_28 vdout0_28ck18 = 1.95 time = 190
* CHECK dout0_29 vdout0_29ck18 = 0 time = 190
* CHECK dout0_30 vdout0_30ck18 = 1.95 time = 190
* CHECK dout0_31 vdout0_31ck18 = 0 time = 190
* CHECK dout1_0 vdout1_0ck18 = 0 time = 190
* CHECK dout1_1 vdout1_1ck18 = 1.95 time = 190
* CHECK dout1_2 vdout1_2ck18 = 0 time = 190
* CHECK dout1_3 vdout1_3ck18 = 1.95 time = 190
* CHECK dout1_4 vdout1_4ck18 = 1.95 time = 190
* CHECK dout1_5 vdout1_5ck18 = 0 time = 190
* CHECK dout1_6 vdout1_6ck18 = 1.95 time = 190
* CHECK dout1_7 vdout1_7ck18 = 0 time = 190
* CHECK dout1_8 vdout1_8ck18 = 1.95 time = 190
* CHECK dout1_9 vdout1_9ck18 = 1.95 time = 190
* CHECK dout1_10 vdout1_10ck18 = 1.95 time = 190
* CHECK dout1_11 vdout1_11ck18 = 1.95 time = 190
* CHECK dout1_12 vdout1_12ck18 = 0 time = 190
* CHECK dout1_13 vdout1_13ck18 = 1.95 time = 190
* CHECK dout1_14 vdout1_14ck18 = 0 time = 190
* CHECK dout1_15 vdout1_15ck18 = 0 time = 190
* CHECK dout1_16 vdout1_16ck18 = 1.95 time = 190
* CHECK dout1_17 vdout1_17ck18 = 1.95 time = 190
* CHECK dout1_18 vdout1_18ck18 = 1.95 time = 190
* CHECK dout1_19 vdout1_19ck18 = 0 time = 190
* CHECK dout1_20 vdout1_20ck18 = 0 time = 190
* CHECK dout1_21 vdout1_21ck18 = 1.95 time = 190
* CHECK dout1_22 vdout1_22ck18 = 0 time = 190
* CHECK dout1_23 vdout1_23ck18 = 0 time = 190
* CHECK dout1_24 vdout1_24ck18 = 1.95 time = 190
* CHECK dout1_25 vdout1_25ck18 = 0 time = 190
* CHECK dout1_26 vdout1_26ck18 = 1.95 time = 190
* CHECK dout1_27 vdout1_27ck18 = 0 time = 190
* CHECK dout1_28 vdout1_28ck18 = 1.95 time = 190
* CHECK dout1_29 vdout1_29ck18 = 1.95 time = 190
* CHECK dout1_30 vdout1_30ck18 = 1.95 time = 190
* CHECK dout1_31 vdout1_31ck18 = 0 time = 190
* CHECK dout0_0 vdout0_0ck19 = 0 time = 200
* CHECK dout0_1 vdout0_1ck19 = 1.95 time = 200
* CHECK dout0_2 vdout0_2ck19 = 0 time = 200
* CHECK dout0_3 vdout0_3ck19 = 1.95 time = 200
* CHECK dout0_4 vdout0_4ck19 = 1.95 time = 200
* CHECK dout0_5 vdout0_5ck19 = 0 time = 200
* CHECK dout0_6 vdout0_6ck19 = 1.95 time = 200
* CHECK dout0_7 vdout0_7ck19 = 0 time = 200
* CHECK dout0_8 vdout0_8ck19 = 1.95 time = 200
* CHECK dout0_9 vdout0_9ck19 = 1.95 time = 200
* CHECK dout0_10 vdout0_10ck19 = 1.95 time = 200
* CHECK dout0_11 vdout0_11ck19 = 1.95 time = 200
* CHECK dout0_12 vdout0_12ck19 = 0 time = 200
* CHECK dout0_13 vdout0_13ck19 = 1.95 time = 200
* CHECK dout0_14 vdout0_14ck19 = 0 time = 200
* CHECK dout0_15 vdout0_15ck19 = 0 time = 200
* CHECK dout0_16 vdout0_16ck19 = 1.95 time = 200
* CHECK dout0_17 vdout0_17ck19 = 1.95 time = 200
* CHECK dout0_18 vdout0_18ck19 = 1.95 time = 200
* CHECK dout0_19 vdout0_19ck19 = 0 time = 200
* CHECK dout0_20 vdout0_20ck19 = 0 time = 200
* CHECK dout0_21 vdout0_21ck19 = 1.95 time = 200
* CHECK dout0_22 vdout0_22ck19 = 0 time = 200
* CHECK dout0_23 vdout0_23ck19 = 0 time = 200
* CHECK dout0_24 vdout0_24ck19 = 1.95 time = 200
* CHECK dout0_25 vdout0_25ck19 = 0 time = 200
* CHECK dout0_26 vdout0_26ck19 = 1.95 time = 200
* CHECK dout0_27 vdout0_27ck19 = 0 time = 200
* CHECK dout0_28 vdout0_28ck19 = 1.95 time = 200
* CHECK dout0_29 vdout0_29ck19 = 1.95 time = 200
* CHECK dout0_30 vdout0_30ck19 = 1.95 time = 200
* CHECK dout0_31 vdout0_31ck19 = 0 time = 200
* CHECK dout0_0 vdout0_0ck20 = 1.95 time = 210
* CHECK dout0_1 vdout0_1ck20 = 0 time = 210
* CHECK dout0_2 vdout0_2ck20 = 1.95 time = 210
* CHECK dout0_3 vdout0_3ck20 = 1.95 time = 210
* CHECK dout0_4 vdout0_4ck20 = 0 time = 210
* CHECK dout0_5 vdout0_5ck20 = 0 time = 210
* CHECK dout0_6 vdout0_6ck20 = 0 time = 210
* CHECK dout0_7 vdout0_7ck20 = 1.95 time = 210
* CHECK dout0_8 vdout0_8ck20 = 1.95 time = 210
* CHECK dout0_9 vdout0_9ck20 = 0 time = 210
* CHECK dout0_10 vdout0_10ck20 = 1.95 time = 210
* CHECK dout0_11 vdout0_11ck20 = 1.95 time = 210
* CHECK dout0_12 vdout0_12ck20 = 0 time = 210
* CHECK dout0_13 vdout0_13ck20 = 0 time = 210
* CHECK dout0_14 vdout0_14ck20 = 1.95 time = 210
* CHECK dout0_15 vdout0_15ck20 = 1.95 time = 210
* CHECK dout0_16 vdout0_16ck20 = 1.95 time = 210
* CHECK dout0_17 vdout0_17ck20 = 1.95 time = 210
* CHECK dout0_18 vdout0_18ck20 = 1.95 time = 210
* CHECK dout0_19 vdout0_19ck20 = 1.95 time = 210
* CHECK dout0_20 vdout0_20ck20 = 0 time = 210
* CHECK dout0_21 vdout0_21ck20 = 0 time = 210
* CHECK dout0_22 vdout0_22ck20 = 0 time = 210
* CHECK dout0_23 vdout0_23ck20 = 0 time = 210
* CHECK dout0_24 vdout0_24ck20 = 0 time = 210
* CHECK dout0_25 vdout0_25ck20 = 0 time = 210
* CHECK dout0_26 vdout0_26ck20 = 0 time = 210
* CHECK dout0_27 vdout0_27ck20 = 1.95 time = 210
* CHECK dout0_28 vdout0_28ck20 = 1.95 time = 210
* CHECK dout0_29 vdout0_29ck20 = 0 time = 210
* CHECK dout0_30 vdout0_30ck20 = 1.95 time = 210
* CHECK dout0_31 vdout0_31ck20 = 0 time = 210
* CHECK dout1_0 vdout1_0ck20 = 0 time = 210
* CHECK dout1_1 vdout1_1ck20 = 1.95 time = 210
* CHECK dout1_2 vdout1_2ck20 = 0 time = 210
* CHECK dout1_3 vdout1_3ck20 = 1.95 time = 210
* CHECK dout1_4 vdout1_4ck20 = 1.95 time = 210
* CHECK dout1_5 vdout1_5ck20 = 0 time = 210
* CHECK dout1_6 vdout1_6ck20 = 1.95 time = 210
* CHECK dout1_7 vdout1_7ck20 = 0 time = 210
* CHECK dout1_8 vdout1_8ck20 = 1.95 time = 210
* CHECK dout1_9 vdout1_9ck20 = 1.95 time = 210
* CHECK dout1_10 vdout1_10ck20 = 1.95 time = 210
* CHECK dout1_11 vdout1_11ck20 = 1.95 time = 210
* CHECK dout1_12 vdout1_12ck20 = 0 time = 210
* CHECK dout1_13 vdout1_13ck20 = 1.95 time = 210
* CHECK dout1_14 vdout1_14ck20 = 0 time = 210
* CHECK dout1_15 vdout1_15ck20 = 0 time = 210
* CHECK dout1_16 vdout1_16ck20 = 1.95 time = 210
* CHECK dout1_17 vdout1_17ck20 = 1.95 time = 210
* CHECK dout1_18 vdout1_18ck20 = 1.95 time = 210
* CHECK dout1_19 vdout1_19ck20 = 0 time = 210
* CHECK dout1_20 vdout1_20ck20 = 0 time = 210
* CHECK dout1_21 vdout1_21ck20 = 1.95 time = 210
* CHECK dout1_22 vdout1_22ck20 = 0 time = 210
* CHECK dout1_23 vdout1_23ck20 = 0 time = 210
* CHECK dout1_24 vdout1_24ck20 = 1.95 time = 210
* CHECK dout1_25 vdout1_25ck20 = 0 time = 210
* CHECK dout1_26 vdout1_26ck20 = 1.95 time = 210
* CHECK dout1_27 vdout1_27ck20 = 0 time = 210
* CHECK dout1_28 vdout1_28ck20 = 1.95 time = 210
* CHECK dout1_29 vdout1_29ck20 = 1.95 time = 210
* CHECK dout1_30 vdout1_30ck20 = 1.95 time = 210
* CHECK dout1_31 vdout1_31ck20 = 0 time = 210
* CHECK dout0_0 vdout0_0ck21 = 0 time = 220
* CHECK dout0_1 vdout0_1ck21 = 1.95 time = 220
* CHECK dout0_2 vdout0_2ck21 = 0 time = 220
* CHECK dout0_3 vdout0_3ck21 = 1.95 time = 220
* CHECK dout0_4 vdout0_4ck21 = 1.95 time = 220
* CHECK dout0_5 vdout0_5ck21 = 0 time = 220
* CHECK dout0_6 vdout0_6ck21 = 1.95 time = 220
* CHECK dout0_7 vdout0_7ck21 = 0 time = 220
* CHECK dout0_8 vdout0_8ck21 = 1.95 time = 220
* CHECK dout0_9 vdout0_9ck21 = 1.95 time = 220
* CHECK dout0_10 vdout0_10ck21 = 1.95 time = 220
* CHECK dout0_11 vdout0_11ck21 = 1.95 time = 220
* CHECK dout0_12 vdout0_12ck21 = 0 time = 220
* CHECK dout0_13 vdout0_13ck21 = 1.95 time = 220
* CHECK dout0_14 vdout0_14ck21 = 0 time = 220
* CHECK dout0_15 vdout0_15ck21 = 0 time = 220
* CHECK dout0_16 vdout0_16ck21 = 1.95 time = 220
* CHECK dout0_17 vdout0_17ck21 = 1.95 time = 220
* CHECK dout0_18 vdout0_18ck21 = 1.95 time = 220
* CHECK dout0_19 vdout0_19ck21 = 0 time = 220
* CHECK dout0_20 vdout0_20ck21 = 0 time = 220
* CHECK dout0_21 vdout0_21ck21 = 1.95 time = 220
* CHECK dout0_22 vdout0_22ck21 = 0 time = 220
* CHECK dout0_23 vdout0_23ck21 = 0 time = 220
* CHECK dout0_24 vdout0_24ck21 = 1.95 time = 220
* CHECK dout0_25 vdout0_25ck21 = 0 time = 220
* CHECK dout0_26 vdout0_26ck21 = 1.95 time = 220
* CHECK dout0_27 vdout0_27ck21 = 0 time = 220
* CHECK dout0_28 vdout0_28ck21 = 1.95 time = 220
* CHECK dout0_29 vdout0_29ck21 = 1.95 time = 220
* CHECK dout0_30 vdout0_30ck21 = 1.95 time = 220
* CHECK dout0_31 vdout0_31ck21 = 0 time = 220
* CHECK dout1_0 vdout1_0ck21 = 1.95 time = 220
* CHECK dout1_1 vdout1_1ck21 = 0 time = 220
* CHECK dout1_2 vdout1_2ck21 = 1.95 time = 220
* CHECK dout1_3 vdout1_3ck21 = 1.95 time = 220
* CHECK dout1_4 vdout1_4ck21 = 0 time = 220
* CHECK dout1_5 vdout1_5ck21 = 0 time = 220
* CHECK dout1_6 vdout1_6ck21 = 0 time = 220
* CHECK dout1_7 vdout1_7ck21 = 1.95 time = 220
* CHECK dout1_8 vdout1_8ck21 = 1.95 time = 220
* CHECK dout1_9 vdout1_9ck21 = 0 time = 220
* CHECK dout1_10 vdout1_10ck21 = 1.95 time = 220
* CHECK dout1_11 vdout1_11ck21 = 1.95 time = 220
* CHECK dout1_12 vdout1_12ck21 = 0 time = 220
* CHECK dout1_13 vdout1_13ck21 = 0 time = 220
* CHECK dout1_14 vdout1_14ck21 = 1.95 time = 220
* CHECK dout1_15 vdout1_15ck21 = 1.95 time = 220
* CHECK dout1_16 vdout1_16ck21 = 1.95 time = 220
* CHECK dout1_17 vdout1_17ck21 = 1.95 time = 220
* CHECK dout1_18 vdout1_18ck21 = 1.95 time = 220
* CHECK dout1_19 vdout1_19ck21 = 1.95 time = 220
* CHECK dout1_20 vdout1_20ck21 = 0 time = 220
* CHECK dout1_21 vdout1_21ck21 = 0 time = 220
* CHECK dout1_22 vdout1_22ck21 = 0 time = 220
* CHECK dout1_23 vdout1_23ck21 = 0 time = 220
* CHECK dout1_24 vdout1_24ck21 = 0 time = 220
* CHECK dout1_25 vdout1_25ck21 = 0 time = 220
* CHECK dout1_26 vdout1_26ck21 = 0 time = 220
* CHECK dout1_27 vdout1_27ck21 = 1.95 time = 220
* CHECK dout1_28 vdout1_28ck21 = 1.95 time = 220
* CHECK dout1_29 vdout1_29ck21 = 0 time = 220
* CHECK dout1_30 vdout1_30ck21 = 1.95 time = 220
* CHECK dout1_31 vdout1_31ck21 = 0 time = 220
* CHECK dout1_0 vdout1_0ck25 = 1.95 time = 260
* CHECK dout1_1 vdout1_1ck25 = 0 time = 260
* CHECK dout1_2 vdout1_2ck25 = 1.95 time = 260
* CHECK dout1_3 vdout1_3ck25 = 1.95 time = 260
* CHECK dout1_4 vdout1_4ck25 = 0 time = 260
* CHECK dout1_5 vdout1_5ck25 = 0 time = 260
* CHECK dout1_6 vdout1_6ck25 = 0 time = 260
* CHECK dout1_7 vdout1_7ck25 = 1.95 time = 260
* CHECK dout1_8 vdout1_8ck25 = 1.95 time = 260
* CHECK dout1_9 vdout1_9ck25 = 0 time = 260
* CHECK dout1_10 vdout1_10ck25 = 1.95 time = 260
* CHECK dout1_11 vdout1_11ck25 = 1.95 time = 260
* CHECK dout1_12 vdout1_12ck25 = 0 time = 260
* CHECK dout1_13 vdout1_13ck25 = 0 time = 260
* CHECK dout1_14 vdout1_14ck25 = 1.95 time = 260
* CHECK dout1_15 vdout1_15ck25 = 1.95 time = 260
* CHECK dout1_16 vdout1_16ck25 = 1.95 time = 260
* CHECK dout1_17 vdout1_17ck25 = 1.95 time = 260
* CHECK dout1_18 vdout1_18ck25 = 1.95 time = 260
* CHECK dout1_19 vdout1_19ck25 = 1.95 time = 260
* CHECK dout1_20 vdout1_20ck25 = 0 time = 260
* CHECK dout1_21 vdout1_21ck25 = 0 time = 260
* CHECK dout1_22 vdout1_22ck25 = 0 time = 260
* CHECK dout1_23 vdout1_23ck25 = 0 time = 260
* CHECK dout1_24 vdout1_24ck25 = 1.95 time = 260
* CHECK dout1_25 vdout1_25ck25 = 1.95 time = 260
* CHECK dout1_26 vdout1_26ck25 = 0 time = 260
* CHECK dout1_27 vdout1_27ck25 = 0 time = 260
* CHECK dout1_28 vdout1_28ck25 = 1.95 time = 260
* CHECK dout1_29 vdout1_29ck25 = 0 time = 260
* CHECK dout1_30 vdout1_30ck25 = 1.95 time = 260
* CHECK dout1_31 vdout1_31ck25 = 1.95 time = 260
* CHECK dout0_0 vdout0_0ck28 = 0 time = 290
* CHECK dout0_1 vdout0_1ck28 = 1.95 time = 290
* CHECK dout0_2 vdout0_2ck28 = 0 time = 290
* CHECK dout0_3 vdout0_3ck28 = 1.95 time = 290
* CHECK dout0_4 vdout0_4ck28 = 1.95 time = 290
* CHECK dout0_5 vdout0_5ck28 = 0 time = 290
* CHECK dout0_6 vdout0_6ck28 = 1.95 time = 290
* CHECK dout0_7 vdout0_7ck28 = 0 time = 290
* CHECK dout0_8 vdout0_8ck28 = 1.95 time = 290
* CHECK dout0_9 vdout0_9ck28 = 1.95 time = 290
* CHECK dout0_10 vdout0_10ck28 = 1.95 time = 290
* CHECK dout0_11 vdout0_11ck28 = 1.95 time = 290
* CHECK dout0_12 vdout0_12ck28 = 0 time = 290
* CHECK dout0_13 vdout0_13ck28 = 1.95 time = 290
* CHECK dout0_14 vdout0_14ck28 = 0 time = 290
* CHECK dout0_15 vdout0_15ck28 = 0 time = 290
* CHECK dout0_16 vdout0_16ck28 = 1.95 time = 290
* CHECK dout0_17 vdout0_17ck28 = 1.95 time = 290
* CHECK dout0_18 vdout0_18ck28 = 1.95 time = 290
* CHECK dout0_19 vdout0_19ck28 = 0 time = 290
* CHECK dout0_20 vdout0_20ck28 = 0 time = 290
* CHECK dout0_21 vdout0_21ck28 = 1.95 time = 290
* CHECK dout0_22 vdout0_22ck28 = 0 time = 290
* CHECK dout0_23 vdout0_23ck28 = 0 time = 290
* CHECK dout0_24 vdout0_24ck28 = 1.95 time = 290
* CHECK dout0_25 vdout0_25ck28 = 0 time = 290
* CHECK dout0_26 vdout0_26ck28 = 1.95 time = 290
* CHECK dout0_27 vdout0_27ck28 = 0 time = 290
* CHECK dout0_28 vdout0_28ck28 = 1.95 time = 290
* CHECK dout0_29 vdout0_29ck28 = 1.95 time = 290
* CHECK dout0_30 vdout0_30ck28 = 1.95 time = 290
* CHECK dout0_31 vdout0_31ck28 = 0 time = 290
* CHECK dout0_0 vdout0_0ck29 = 1.95 time = 300
* CHECK dout0_1 vdout0_1ck29 = 0 time = 300
* CHECK dout0_2 vdout0_2ck29 = 1.95 time = 300
* CHECK dout0_3 vdout0_3ck29 = 1.95 time = 300
* CHECK dout0_4 vdout0_4ck29 = 0 time = 300
* CHECK dout0_5 vdout0_5ck29 = 0 time = 300
* CHECK dout0_6 vdout0_6ck29 = 0 time = 300
* CHECK dout0_7 vdout0_7ck29 = 1.95 time = 300
* CHECK dout0_8 vdout0_8ck29 = 1.95 time = 300
* CHECK dout0_9 vdout0_9ck29 = 0 time = 300
* CHECK dout0_10 vdout0_10ck29 = 1.95 time = 300
* CHECK dout0_11 vdout0_11ck29 = 1.95 time = 300
* CHECK dout0_12 vdout0_12ck29 = 0 time = 300
* CHECK dout0_13 vdout0_13ck29 = 0 time = 300
* CHECK dout0_14 vdout0_14ck29 = 1.95 time = 300
* CHECK dout0_15 vdout0_15ck29 = 1.95 time = 300
* CHECK dout0_16 vdout0_16ck29 = 0 time = 300
* CHECK dout0_17 vdout0_17ck29 = 0 time = 300
* CHECK dout0_18 vdout0_18ck29 = 0 time = 300
* CHECK dout0_19 vdout0_19ck29 = 1.95 time = 300
* CHECK dout0_20 vdout0_20ck29 = 1.95 time = 300
* CHECK dout0_21 vdout0_21ck29 = 0 time = 300
* CHECK dout0_22 vdout0_22ck29 = 1.95 time = 300
* CHECK dout0_23 vdout0_23ck29 = 1.95 time = 300
* CHECK dout0_24 vdout0_24ck29 = 1.95 time = 300
* CHECK dout0_25 vdout0_25ck29 = 1.95 time = 300
* CHECK dout0_26 vdout0_26ck29 = 0 time = 300
* CHECK dout0_27 vdout0_27ck29 = 0 time = 300
* CHECK dout0_28 vdout0_28ck29 = 1.95 time = 300
* CHECK dout0_29 vdout0_29ck29 = 0 time = 300
* CHECK dout0_30 vdout0_30ck29 = 1.95 time = 300
* CHECK dout0_31 vdout0_31ck29 = 1.95 time = 300
* CHECK dout1_0 vdout1_0ck29 = 1.95 time = 300
* CHECK dout1_1 vdout1_1ck29 = 0 time = 300
* CHECK dout1_2 vdout1_2ck29 = 1.95 time = 300
* CHECK dout1_3 vdout1_3ck29 = 1.95 time = 300
* CHECK dout1_4 vdout1_4ck29 = 0 time = 300
* CHECK dout1_5 vdout1_5ck29 = 0 time = 300
* CHECK dout1_6 vdout1_6ck29 = 0 time = 300
* CHECK dout1_7 vdout1_7ck29 = 1.95 time = 300
* CHECK dout1_8 vdout1_8ck29 = 1.95 time = 300
* CHECK dout1_9 vdout1_9ck29 = 0 time = 300
* CHECK dout1_10 vdout1_10ck29 = 1.95 time = 300
* CHECK dout1_11 vdout1_11ck29 = 1.95 time = 300
* CHECK dout1_12 vdout1_12ck29 = 0 time = 300
* CHECK dout1_13 vdout1_13ck29 = 0 time = 300
* CHECK dout1_14 vdout1_14ck29 = 1.95 time = 300
* CHECK dout1_15 vdout1_15ck29 = 1.95 time = 300
* CHECK dout1_16 vdout1_16ck29 = 0 time = 300
* CHECK dout1_17 vdout1_17ck29 = 0 time = 300
* CHECK dout1_18 vdout1_18ck29 = 0 time = 300
* CHECK dout1_19 vdout1_19ck29 = 1.95 time = 300
* CHECK dout1_20 vdout1_20ck29 = 1.95 time = 300
* CHECK dout1_21 vdout1_21ck29 = 0 time = 300
* CHECK dout1_22 vdout1_22ck29 = 1.95 time = 300
* CHECK dout1_23 vdout1_23ck29 = 1.95 time = 300
* CHECK dout1_24 vdout1_24ck29 = 1.95 time = 300
* CHECK dout1_25 vdout1_25ck29 = 1.95 time = 300
* CHECK dout1_26 vdout1_26ck29 = 0 time = 300
* CHECK dout1_27 vdout1_27ck29 = 0 time = 300
* CHECK dout1_28 vdout1_28ck29 = 1.95 time = 300
* CHECK dout1_29 vdout1_29ck29 = 0 time = 300
* CHECK dout1_30 vdout1_30ck29 = 1.95 time = 300
* CHECK dout1_31 vdout1_31ck29 = 1.95 time = 300
* CHECK dout1_0 vdout1_0ck31 = 1.95 time = 320
* CHECK dout1_1 vdout1_1ck31 = 0 time = 320
* CHECK dout1_2 vdout1_2ck31 = 1.95 time = 320
* CHECK dout1_3 vdout1_3ck31 = 1.95 time = 320
* CHECK dout1_4 vdout1_4ck31 = 0 time = 320
* CHECK dout1_5 vdout1_5ck31 = 0 time = 320
* CHECK dout1_6 vdout1_6ck31 = 0 time = 320
* CHECK dout1_7 vdout1_7ck31 = 1.95 time = 320
* CHECK dout1_8 vdout1_8ck31 = 1.95 time = 320
* CHECK dout1_9 vdout1_9ck31 = 0 time = 320
* CHECK dout1_10 vdout1_10ck31 = 1.95 time = 320
* CHECK dout1_11 vdout1_11ck31 = 1.95 time = 320
* CHECK dout1_12 vdout1_12ck31 = 0 time = 320
* CHECK dout1_13 vdout1_13ck31 = 0 time = 320
* CHECK dout1_14 vdout1_14ck31 = 1.95 time = 320
* CHECK dout1_15 vdout1_15ck31 = 1.95 time = 320
* CHECK dout1_16 vdout1_16ck31 = 0 time = 320
* CHECK dout1_17 vdout1_17ck31 = 0 time = 320
* CHECK dout1_18 vdout1_18ck31 = 0 time = 320
* CHECK dout1_19 vdout1_19ck31 = 1.95 time = 320
* CHECK dout1_20 vdout1_20ck31 = 1.95 time = 320
* CHECK dout1_21 vdout1_21ck31 = 0 time = 320
* CHECK dout1_22 vdout1_22ck31 = 1.95 time = 320
* CHECK dout1_23 vdout1_23ck31 = 1.95 time = 320
* CHECK dout1_24 vdout1_24ck31 = 1.95 time = 320
* CHECK dout1_25 vdout1_25ck31 = 1.95 time = 320
* CHECK dout1_26 vdout1_26ck31 = 0 time = 320
* CHECK dout1_27 vdout1_27ck31 = 0 time = 320
* CHECK dout1_28 vdout1_28ck31 = 1.95 time = 320
* CHECK dout1_29 vdout1_29ck31 = 0 time = 320
* CHECK dout1_30 vdout1_30ck31 = 1.95 time = 320
* CHECK dout1_31 vdout1_31ck31 = 1.95 time = 320
* CHECK dout1_0 vdout1_0ck32 = 1.95 time = 330
* CHECK dout1_1 vdout1_1ck32 = 0 time = 330
* CHECK dout1_2 vdout1_2ck32 = 1.95 time = 330
* CHECK dout1_3 vdout1_3ck32 = 1.95 time = 330
* CHECK dout1_4 vdout1_4ck32 = 0 time = 330
* CHECK dout1_5 vdout1_5ck32 = 0 time = 330
* CHECK dout1_6 vdout1_6ck32 = 0 time = 330
* CHECK dout1_7 vdout1_7ck32 = 1.95 time = 330
* CHECK dout1_8 vdout1_8ck32 = 1.95 time = 330
* CHECK dout1_9 vdout1_9ck32 = 0 time = 330
* CHECK dout1_10 vdout1_10ck32 = 1.95 time = 330
* CHECK dout1_11 vdout1_11ck32 = 1.95 time = 330
* CHECK dout1_12 vdout1_12ck32 = 0 time = 330
* CHECK dout1_13 vdout1_13ck32 = 0 time = 330
* CHECK dout1_14 vdout1_14ck32 = 1.95 time = 330
* CHECK dout1_15 vdout1_15ck32 = 1.95 time = 330
* CHECK dout1_16 vdout1_16ck32 = 0 time = 330
* CHECK dout1_17 vdout1_17ck32 = 0 time = 330
* CHECK dout1_18 vdout1_18ck32 = 0 time = 330
* CHECK dout1_19 vdout1_19ck32 = 1.95 time = 330
* CHECK dout1_20 vdout1_20ck32 = 1.95 time = 330
* CHECK dout1_21 vdout1_21ck32 = 0 time = 330
* CHECK dout1_22 vdout1_22ck32 = 1.95 time = 330
* CHECK dout1_23 vdout1_23ck32 = 1.95 time = 330
* CHECK dout1_24 vdout1_24ck32 = 1.95 time = 330
* CHECK dout1_25 vdout1_25ck32 = 1.95 time = 330
* CHECK dout1_26 vdout1_26ck32 = 0 time = 330
* CHECK dout1_27 vdout1_27ck32 = 0 time = 330
* CHECK dout1_28 vdout1_28ck32 = 1.95 time = 330
* CHECK dout1_29 vdout1_29ck32 = 0 time = 330
* CHECK dout1_30 vdout1_30ck32 = 1.95 time = 330
* CHECK dout1_31 vdout1_31ck32 = 1.95 time = 330
* CHECK dout0_0 vdout0_0ck35 = 1.95 time = 360
* CHECK dout0_1 vdout0_1ck35 = 0 time = 360
* CHECK dout0_2 vdout0_2ck35 = 1.95 time = 360
* CHECK dout0_3 vdout0_3ck35 = 1.95 time = 360
* CHECK dout0_4 vdout0_4ck35 = 0 time = 360
* CHECK dout0_5 vdout0_5ck35 = 0 time = 360
* CHECK dout0_6 vdout0_6ck35 = 0 time = 360
* CHECK dout0_7 vdout0_7ck35 = 1.95 time = 360
* CHECK dout0_8 vdout0_8ck35 = 1.95 time = 360
* CHECK dout0_9 vdout0_9ck35 = 0 time = 360
* CHECK dout0_10 vdout0_10ck35 = 1.95 time = 360
* CHECK dout0_11 vdout0_11ck35 = 1.95 time = 360
* CHECK dout0_12 vdout0_12ck35 = 0 time = 360
* CHECK dout0_13 vdout0_13ck35 = 0 time = 360
* CHECK dout0_14 vdout0_14ck35 = 1.95 time = 360
* CHECK dout0_15 vdout0_15ck35 = 1.95 time = 360
* CHECK dout0_16 vdout0_16ck35 = 0 time = 360
* CHECK dout0_17 vdout0_17ck35 = 0 time = 360
* CHECK dout0_18 vdout0_18ck35 = 0 time = 360
* CHECK dout0_19 vdout0_19ck35 = 1.95 time = 360
* CHECK dout0_20 vdout0_20ck35 = 1.95 time = 360
* CHECK dout0_21 vdout0_21ck35 = 0 time = 360
* CHECK dout0_22 vdout0_22ck35 = 1.95 time = 360
* CHECK dout0_23 vdout0_23ck35 = 1.95 time = 360
* CHECK dout0_24 vdout0_24ck35 = 1.95 time = 360
* CHECK dout0_25 vdout0_25ck35 = 1.95 time = 360
* CHECK dout0_26 vdout0_26ck35 = 0 time = 360
* CHECK dout0_27 vdout0_27ck35 = 0 time = 360
* CHECK dout0_28 vdout0_28ck35 = 1.95 time = 360
* CHECK dout0_29 vdout0_29ck35 = 0 time = 360
* CHECK dout0_30 vdout0_30ck35 = 1.95 time = 360
* CHECK dout0_31 vdout0_31ck35 = 1.95 time = 360
* CHECK dout0_0 vdout0_0ck36 = 1.95 time = 370
* CHECK dout0_1 vdout0_1ck36 = 0 time = 370
* CHECK dout0_2 vdout0_2ck36 = 1.95 time = 370
* CHECK dout0_3 vdout0_3ck36 = 1.95 time = 370
* CHECK dout0_4 vdout0_4ck36 = 0 time = 370
* CHECK dout0_5 vdout0_5ck36 = 0 time = 370
* CHECK dout0_6 vdout0_6ck36 = 0 time = 370
* CHECK dout0_7 vdout0_7ck36 = 1.95 time = 370
* CHECK dout0_8 vdout0_8ck36 = 1.95 time = 370
* CHECK dout0_9 vdout0_9ck36 = 0 time = 370
* CHECK dout0_10 vdout0_10ck36 = 1.95 time = 370
* CHECK dout0_11 vdout0_11ck36 = 1.95 time = 370
* CHECK dout0_12 vdout0_12ck36 = 0 time = 370
* CHECK dout0_13 vdout0_13ck36 = 0 time = 370
* CHECK dout0_14 vdout0_14ck36 = 1.95 time = 370
* CHECK dout0_15 vdout0_15ck36 = 1.95 time = 370
* CHECK dout0_16 vdout0_16ck36 = 0 time = 370
* CHECK dout0_17 vdout0_17ck36 = 0 time = 370
* CHECK dout0_18 vdout0_18ck36 = 0 time = 370
* CHECK dout0_19 vdout0_19ck36 = 1.95 time = 370
* CHECK dout0_20 vdout0_20ck36 = 1.95 time = 370
* CHECK dout0_21 vdout0_21ck36 = 0 time = 370
* CHECK dout0_22 vdout0_22ck36 = 1.95 time = 370
* CHECK dout0_23 vdout0_23ck36 = 1.95 time = 370
* CHECK dout0_24 vdout0_24ck36 = 1.95 time = 370
* CHECK dout0_25 vdout0_25ck36 = 1.95 time = 370
* CHECK dout0_26 vdout0_26ck36 = 0 time = 370
* CHECK dout0_27 vdout0_27ck36 = 0 time = 370
* CHECK dout0_28 vdout0_28ck36 = 1.95 time = 370
* CHECK dout0_29 vdout0_29ck36 = 0 time = 370
* CHECK dout0_30 vdout0_30ck36 = 1.95 time = 370
* CHECK dout0_31 vdout0_31ck36 = 1.95 time = 370
* CHECK dout1_0 vdout1_0ck37 = 1.95 time = 380
* CHECK dout1_1 vdout1_1ck37 = 1.95 time = 380
* CHECK dout1_2 vdout1_2ck37 = 1.95 time = 380
* CHECK dout1_3 vdout1_3ck37 = 1.95 time = 380
* CHECK dout1_4 vdout1_4ck37 = 1.95 time = 380
* CHECK dout1_5 vdout1_5ck37 = 0 time = 380
* CHECK dout1_6 vdout1_6ck37 = 0 time = 380
* CHECK dout1_7 vdout1_7ck37 = 1.95 time = 380
* CHECK dout1_8 vdout1_8ck37 = 1.95 time = 380
* CHECK dout1_9 vdout1_9ck37 = 0 time = 380
* CHECK dout1_10 vdout1_10ck37 = 0 time = 380
* CHECK dout1_11 vdout1_11ck37 = 1.95 time = 380
* CHECK dout1_12 vdout1_12ck37 = 1.95 time = 380
* CHECK dout1_13 vdout1_13ck37 = 1.95 time = 380
* CHECK dout1_14 vdout1_14ck37 = 1.95 time = 380
* CHECK dout1_15 vdout1_15ck37 = 1.95 time = 380
* CHECK dout1_16 vdout1_16ck37 = 0 time = 380
* CHECK dout1_17 vdout1_17ck37 = 1.95 time = 380
* CHECK dout1_18 vdout1_18ck37 = 1.95 time = 380
* CHECK dout1_19 vdout1_19ck37 = 1.95 time = 380
* CHECK dout1_20 vdout1_20ck37 = 0 time = 380
* CHECK dout1_21 vdout1_21ck37 = 0 time = 380
* CHECK dout1_22 vdout1_22ck37 = 1.95 time = 380
* CHECK dout1_23 vdout1_23ck37 = 0 time = 380
* CHECK dout1_24 vdout1_24ck37 = 0 time = 380
* CHECK dout1_25 vdout1_25ck37 = 0 time = 380
* CHECK dout1_26 vdout1_26ck37 = 1.95 time = 380
* CHECK dout1_27 vdout1_27ck37 = 1.95 time = 380
* CHECK dout1_28 vdout1_28ck37 = 0 time = 380
* CHECK dout1_29 vdout1_29ck37 = 1.95 time = 380
* CHECK dout1_30 vdout1_30ck37 = 1.95 time = 380
* CHECK dout1_31 vdout1_31ck37 = 0 time = 380
* CHECK dout1_0 vdout1_0ck38 = 1.95 time = 390
* CHECK dout1_1 vdout1_1ck38 = 0 time = 390
* CHECK dout1_2 vdout1_2ck38 = 1.95 time = 390
* CHECK dout1_3 vdout1_3ck38 = 1.95 time = 390
* CHECK dout1_4 vdout1_4ck38 = 0 time = 390
* CHECK dout1_5 vdout1_5ck38 = 0 time = 390
* CHECK dout1_6 vdout1_6ck38 = 0 time = 390
* CHECK dout1_7 vdout1_7ck38 = 1.95 time = 390
* CHECK dout1_8 vdout1_8ck38 = 0 time = 390
* CHECK dout1_9 vdout1_9ck38 = 0 time = 390
* CHECK dout1_10 vdout1_10ck38 = 0 time = 390
* CHECK dout1_11 vdout1_11ck38 = 0 time = 390
* CHECK dout1_12 vdout1_12ck38 = 0 time = 390
* CHECK dout1_13 vdout1_13ck38 = 0 time = 390
* CHECK dout1_14 vdout1_14ck38 = 0 time = 390
* CHECK dout1_15 vdout1_15ck38 = 1.95 time = 390
* CHECK dout1_16 vdout1_16ck38 = 1.95 time = 390
* CHECK dout1_17 vdout1_17ck38 = 0 time = 390
* CHECK dout1_18 vdout1_18ck38 = 1.95 time = 390
* CHECK dout1_19 vdout1_19ck38 = 1.95 time = 390
* CHECK dout1_20 vdout1_20ck38 = 1.95 time = 390
* CHECK dout1_21 vdout1_21ck38 = 1.95 time = 390
* CHECK dout1_22 vdout1_22ck38 = 1.95 time = 390
* CHECK dout1_23 vdout1_23ck38 = 1.95 time = 390
* CHECK dout1_24 vdout1_24ck38 = 0 time = 390
* CHECK dout1_25 vdout1_25ck38 = 1.95 time = 390
* CHECK dout1_26 vdout1_26ck38 = 1.95 time = 390
* CHECK dout1_27 vdout1_27ck38 = 0 time = 390
* CHECK dout1_28 vdout1_28ck38 = 1.95 time = 390
* CHECK dout1_29 vdout1_29ck38 = 1.95 time = 390
* CHECK dout1_30 vdout1_30ck38 = 0 time = 390
* CHECK dout1_31 vdout1_31ck38 = 1.95 time = 390
* CHECK dout1_0 vdout1_0ck42 = 0 time = 430
* CHECK dout1_1 vdout1_1ck42 = 0 time = 430
* CHECK dout1_2 vdout1_2ck42 = 0 time = 430
* CHECK dout1_3 vdout1_3ck42 = 1.95 time = 430
* CHECK dout1_4 vdout1_4ck42 = 1.95 time = 430
* CHECK dout1_5 vdout1_5ck42 = 0 time = 430
* CHECK dout1_6 vdout1_6ck42 = 1.95 time = 430
* CHECK dout1_7 vdout1_7ck42 = 0 time = 430
* CHECK dout1_8 vdout1_8ck42 = 1.95 time = 430
* CHECK dout1_9 vdout1_9ck42 = 0 time = 430
* CHECK dout1_10 vdout1_10ck42 = 1.95 time = 430
* CHECK dout1_11 vdout1_11ck42 = 1.95 time = 430
* CHECK dout1_12 vdout1_12ck42 = 1.95 time = 430
* CHECK dout1_13 vdout1_13ck42 = 1.95 time = 430
* CHECK dout1_14 vdout1_14ck42 = 1.95 time = 430
* CHECK dout1_15 vdout1_15ck42 = 1.95 time = 430
* CHECK dout1_16 vdout1_16ck42 = 1.95 time = 430
* CHECK dout1_17 vdout1_17ck42 = 0 time = 430
* CHECK dout1_18 vdout1_18ck42 = 0 time = 430
* CHECK dout1_19 vdout1_19ck42 = 1.95 time = 430
* CHECK dout1_20 vdout1_20ck42 = 0 time = 430
* CHECK dout1_21 vdout1_21ck42 = 0 time = 430
* CHECK dout1_22 vdout1_22ck42 = 0 time = 430
* CHECK dout1_23 vdout1_23ck42 = 0 time = 430
* CHECK dout1_24 vdout1_24ck42 = 0 time = 430
* CHECK dout1_25 vdout1_25ck42 = 1.95 time = 430
* CHECK dout1_26 vdout1_26ck42 = 1.95 time = 430
* CHECK dout1_27 vdout1_27ck42 = 0 time = 430
* CHECK dout1_28 vdout1_28ck42 = 1.95 time = 430
* CHECK dout1_29 vdout1_29ck42 = 1.95 time = 430
* CHECK dout1_30 vdout1_30ck42 = 1.95 time = 430
* CHECK dout1_31 vdout1_31ck42 = 1.95 time = 430
* CHECK dout0_0 vdout0_0ck43 = 0 time = 440
* CHECK dout0_1 vdout0_1ck43 = 0 time = 440
* CHECK dout0_2 vdout0_2ck43 = 0 time = 440
* CHECK dout0_3 vdout0_3ck43 = 0 time = 440
* CHECK dout0_4 vdout0_4ck43 = 0 time = 440
* CHECK dout0_5 vdout0_5ck43 = 1.95 time = 440
* CHECK dout0_6 vdout0_6ck43 = 1.95 time = 440
* CHECK dout0_7 vdout0_7ck43 = 1.95 time = 440
* CHECK dout0_8 vdout0_8ck43 = 0 time = 440
* CHECK dout0_9 vdout0_9ck43 = 1.95 time = 440
* CHECK dout0_10 vdout0_10ck43 = 1.95 time = 440
* CHECK dout0_11 vdout0_11ck43 = 0 time = 440
* CHECK dout0_12 vdout0_12ck43 = 0 time = 440
* CHECK dout0_13 vdout0_13ck43 = 1.95 time = 440
* CHECK dout0_14 vdout0_14ck43 = 0 time = 440
* CHECK dout0_15 vdout0_15ck43 = 0 time = 440
* CHECK dout0_16 vdout0_16ck43 = 0 time = 440
* CHECK dout0_17 vdout0_17ck43 = 1.95 time = 440
* CHECK dout0_18 vdout0_18ck43 = 1.95 time = 440
* CHECK dout0_19 vdout0_19ck43 = 0 time = 440
* CHECK dout0_20 vdout0_20ck43 = 0 time = 440
* CHECK dout0_21 vdout0_21ck43 = 1.95 time = 440
* CHECK dout0_22 vdout0_22ck43 = 1.95 time = 440
* CHECK dout0_23 vdout0_23ck43 = 0 time = 440
* CHECK dout0_24 vdout0_24ck43 = 1.95 time = 440
* CHECK dout0_25 vdout0_25ck43 = 1.95 time = 440
* CHECK dout0_26 vdout0_26ck43 = 0 time = 440
* CHECK dout0_27 vdout0_27ck43 = 1.95 time = 440
* CHECK dout0_28 vdout0_28ck43 = 1.95 time = 440
* CHECK dout0_29 vdout0_29ck43 = 0 time = 440
* CHECK dout0_30 vdout0_30ck43 = 0 time = 440
* CHECK dout0_31 vdout0_31ck43 = 1.95 time = 440
* CHECK dout1_0 vdout1_0ck43 = 1.95 time = 440
* CHECK dout1_1 vdout1_1ck43 = 1.95 time = 440
* CHECK dout1_2 vdout1_2ck43 = 1.95 time = 440
* CHECK dout1_3 vdout1_3ck43 = 1.95 time = 440
* CHECK dout1_4 vdout1_4ck43 = 1.95 time = 440
* CHECK dout1_5 vdout1_5ck43 = 0 time = 440
* CHECK dout1_6 vdout1_6ck43 = 0 time = 440
* CHECK dout1_7 vdout1_7ck43 = 1.95 time = 440
* CHECK dout1_8 vdout1_8ck43 = 1.95 time = 440
* CHECK dout1_9 vdout1_9ck43 = 0 time = 440
* CHECK dout1_10 vdout1_10ck43 = 0 time = 440
* CHECK dout1_11 vdout1_11ck43 = 1.95 time = 440
* CHECK dout1_12 vdout1_12ck43 = 1.95 time = 440
* CHECK dout1_13 vdout1_13ck43 = 1.95 time = 440
* CHECK dout1_14 vdout1_14ck43 = 1.95 time = 440
* CHECK dout1_15 vdout1_15ck43 = 1.95 time = 440
* CHECK dout1_16 vdout1_16ck43 = 0 time = 440
* CHECK dout1_17 vdout1_17ck43 = 1.95 time = 440
* CHECK dout1_18 vdout1_18ck43 = 1.95 time = 440
* CHECK dout1_19 vdout1_19ck43 = 1.95 time = 440
* CHECK dout1_20 vdout1_20ck43 = 0 time = 440
* CHECK dout1_21 vdout1_21ck43 = 0 time = 440
* CHECK dout1_22 vdout1_22ck43 = 1.95 time = 440
* CHECK dout1_23 vdout1_23ck43 = 0 time = 440
* CHECK dout1_24 vdout1_24ck43 = 0 time = 440
* CHECK dout1_25 vdout1_25ck43 = 0 time = 440
* CHECK dout1_26 vdout1_26ck43 = 1.95 time = 440
* CHECK dout1_27 vdout1_27ck43 = 1.95 time = 440
* CHECK dout1_28 vdout1_28ck43 = 0 time = 440
* CHECK dout1_29 vdout1_29ck43 = 1.95 time = 440
* CHECK dout1_30 vdout1_30ck43 = 1.95 time = 440
* CHECK dout1_31 vdout1_31ck43 = 0 time = 440
* CHECK dout0_0 vdout0_0ck44 = 0 time = 450
* CHECK dout0_1 vdout0_1ck44 = 0 time = 450
* CHECK dout0_2 vdout0_2ck44 = 0 time = 450
* CHECK dout0_3 vdout0_3ck44 = 1.95 time = 450
* CHECK dout0_4 vdout0_4ck44 = 1.95 time = 450
* CHECK dout0_5 vdout0_5ck44 = 0 time = 450
* CHECK dout0_6 vdout0_6ck44 = 1.95 time = 450
* CHECK dout0_7 vdout0_7ck44 = 0 time = 450
* CHECK dout0_8 vdout0_8ck44 = 1.95 time = 450
* CHECK dout0_9 vdout0_9ck44 = 0 time = 450
* CHECK dout0_10 vdout0_10ck44 = 1.95 time = 450
* CHECK dout0_11 vdout0_11ck44 = 1.95 time = 450
* CHECK dout0_12 vdout0_12ck44 = 1.95 time = 450
* CHECK dout0_13 vdout0_13ck44 = 1.95 time = 450
* CHECK dout0_14 vdout0_14ck44 = 1.95 time = 450
* CHECK dout0_15 vdout0_15ck44 = 1.95 time = 450
* CHECK dout0_16 vdout0_16ck44 = 1.95 time = 450
* CHECK dout0_17 vdout0_17ck44 = 0 time = 450
* CHECK dout0_18 vdout0_18ck44 = 0 time = 450
* CHECK dout0_19 vdout0_19ck44 = 1.95 time = 450
* CHECK dout0_20 vdout0_20ck44 = 0 time = 450
* CHECK dout0_21 vdout0_21ck44 = 0 time = 450
* CHECK dout0_22 vdout0_22ck44 = 0 time = 450
* CHECK dout0_23 vdout0_23ck44 = 0 time = 450
* CHECK dout0_24 vdout0_24ck44 = 0 time = 450
* CHECK dout0_25 vdout0_25ck44 = 1.95 time = 450
* CHECK dout0_26 vdout0_26ck44 = 1.95 time = 450
* CHECK dout0_27 vdout0_27ck44 = 0 time = 450
* CHECK dout0_28 vdout0_28ck44 = 1.95 time = 450
* CHECK dout0_29 vdout0_29ck44 = 1.95 time = 450
* CHECK dout0_30 vdout0_30ck44 = 1.95 time = 450
* CHECK dout0_31 vdout0_31ck44 = 1.95 time = 450
* CHECK dout1_0 vdout1_0ck44 = 1.95 time = 450
* CHECK dout1_1 vdout1_1ck44 = 1.95 time = 450
* CHECK dout1_2 vdout1_2ck44 = 1.95 time = 450
* CHECK dout1_3 vdout1_3ck44 = 1.95 time = 450
* CHECK dout1_4 vdout1_4ck44 = 1.95 time = 450
* CHECK dout1_5 vdout1_5ck44 = 0 time = 450
* CHECK dout1_6 vdout1_6ck44 = 0 time = 450
* CHECK dout1_7 vdout1_7ck44 = 1.95 time = 450
* CHECK dout1_8 vdout1_8ck44 = 1.95 time = 450
* CHECK dout1_9 vdout1_9ck44 = 0 time = 450
* CHECK dout1_10 vdout1_10ck44 = 0 time = 450
* CHECK dout1_11 vdout1_11ck44 = 1.95 time = 450
* CHECK dout1_12 vdout1_12ck44 = 1.95 time = 450
* CHECK dout1_13 vdout1_13ck44 = 1.95 time = 450
* CHECK dout1_14 vdout1_14ck44 = 1.95 time = 450
* CHECK dout1_15 vdout1_15ck44 = 1.95 time = 450
* CHECK dout1_16 vdout1_16ck44 = 0 time = 450
* CHECK dout1_17 vdout1_17ck44 = 1.95 time = 450
* CHECK dout1_18 vdout1_18ck44 = 1.95 time = 450
* CHECK dout1_19 vdout1_19ck44 = 1.95 time = 450
* CHECK dout1_20 vdout1_20ck44 = 0 time = 450
* CHECK dout1_21 vdout1_21ck44 = 0 time = 450
* CHECK dout1_22 vdout1_22ck44 = 1.95 time = 450
* CHECK dout1_23 vdout1_23ck44 = 0 time = 450
* CHECK dout1_24 vdout1_24ck44 = 0 time = 450
* CHECK dout1_25 vdout1_25ck44 = 0 time = 450
* CHECK dout1_26 vdout1_26ck44 = 1.95 time = 450
* CHECK dout1_27 vdout1_27ck44 = 1.95 time = 450
* CHECK dout1_28 vdout1_28ck44 = 0 time = 450
* CHECK dout1_29 vdout1_29ck44 = 1.95 time = 450
* CHECK dout1_30 vdout1_30ck44 = 1.95 time = 450
* CHECK dout1_31 vdout1_31ck44 = 0 time = 450
* CHECK dout0_0 vdout0_0ck46 = 1.95 time = 470
* CHECK dout0_1 vdout0_1ck46 = 0 time = 470
* CHECK dout0_2 vdout0_2ck46 = 1.95 time = 470
* CHECK dout0_3 vdout0_3ck46 = 1.95 time = 470
* CHECK dout0_4 vdout0_4ck46 = 0 time = 470
* CHECK dout0_5 vdout0_5ck46 = 0 time = 470
* CHECK dout0_6 vdout0_6ck46 = 0 time = 470
* CHECK dout0_7 vdout0_7ck46 = 1.95 time = 470
* CHECK dout0_8 vdout0_8ck46 = 0 time = 470
* CHECK dout0_9 vdout0_9ck46 = 0 time = 470
* CHECK dout0_10 vdout0_10ck46 = 0 time = 470
* CHECK dout0_11 vdout0_11ck46 = 0 time = 470
* CHECK dout0_12 vdout0_12ck46 = 0 time = 470
* CHECK dout0_13 vdout0_13ck46 = 0 time = 470
* CHECK dout0_14 vdout0_14ck46 = 0 time = 470
* CHECK dout0_15 vdout0_15ck46 = 1.95 time = 470
* CHECK dout0_16 vdout0_16ck46 = 1.95 time = 470
* CHECK dout0_17 vdout0_17ck46 = 0 time = 470
* CHECK dout0_18 vdout0_18ck46 = 1.95 time = 470
* CHECK dout0_19 vdout0_19ck46 = 1.95 time = 470
* CHECK dout0_20 vdout0_20ck46 = 1.95 time = 470
* CHECK dout0_21 vdout0_21ck46 = 1.95 time = 470
* CHECK dout0_22 vdout0_22ck46 = 1.95 time = 470
* CHECK dout0_23 vdout0_23ck46 = 1.95 time = 470
* CHECK dout0_24 vdout0_24ck46 = 0 time = 470
* CHECK dout0_25 vdout0_25ck46 = 1.95 time = 470
* CHECK dout0_26 vdout0_26ck46 = 1.95 time = 470
* CHECK dout0_27 vdout0_27ck46 = 0 time = 470
* CHECK dout0_28 vdout0_28ck46 = 1.95 time = 470
* CHECK dout0_29 vdout0_29ck46 = 1.95 time = 470
* CHECK dout0_30 vdout0_30ck46 = 0 time = 470
* CHECK dout0_31 vdout0_31ck46 = 1.95 time = 470
* CHECK dout1_0 vdout1_0ck46 = 0 time = 470
* CHECK dout1_1 vdout1_1ck46 = 0 time = 470
* CHECK dout1_2 vdout1_2ck46 = 0 time = 470
* CHECK dout1_3 vdout1_3ck46 = 1.95 time = 470
* CHECK dout1_4 vdout1_4ck46 = 1.95 time = 470
* CHECK dout1_5 vdout1_5ck46 = 0 time = 470
* CHECK dout1_6 vdout1_6ck46 = 1.95 time = 470
* CHECK dout1_7 vdout1_7ck46 = 0 time = 470
* CHECK dout1_8 vdout1_8ck46 = 1.95 time = 470
* CHECK dout1_9 vdout1_9ck46 = 0 time = 470
* CHECK dout1_10 vdout1_10ck46 = 1.95 time = 470
* CHECK dout1_11 vdout1_11ck46 = 1.95 time = 470
* CHECK dout1_12 vdout1_12ck46 = 1.95 time = 470
* CHECK dout1_13 vdout1_13ck46 = 1.95 time = 470
* CHECK dout1_14 vdout1_14ck46 = 1.95 time = 470
* CHECK dout1_15 vdout1_15ck46 = 1.95 time = 470
* CHECK dout1_16 vdout1_16ck46 = 1.95 time = 470
* CHECK dout1_17 vdout1_17ck46 = 0 time = 470
* CHECK dout1_18 vdout1_18ck46 = 0 time = 470
* CHECK dout1_19 vdout1_19ck46 = 1.95 time = 470
* CHECK dout1_20 vdout1_20ck46 = 0 time = 470
* CHECK dout1_21 vdout1_21ck46 = 0 time = 470
* CHECK dout1_22 vdout1_22ck46 = 0 time = 470
* CHECK dout1_23 vdout1_23ck46 = 0 time = 470
* CHECK dout1_24 vdout1_24ck46 = 0 time = 470
* CHECK dout1_25 vdout1_25ck46 = 1.95 time = 470
* CHECK dout1_26 vdout1_26ck46 = 1.95 time = 470
* CHECK dout1_27 vdout1_27ck46 = 0 time = 470
* CHECK dout1_28 vdout1_28ck46 = 1.95 time = 470
* CHECK dout1_29 vdout1_29ck46 = 1.95 time = 470
* CHECK dout1_30 vdout1_30ck46 = 1.95 time = 470
* CHECK dout1_31 vdout1_31ck46 = 1.95 time = 470
* CHECK dout0_0 vdout0_0ck47 = 0 time = 480
* CHECK dout0_1 vdout0_1ck47 = 0 time = 480
* CHECK dout0_2 vdout0_2ck47 = 0 time = 480
* CHECK dout0_3 vdout0_3ck47 = 0 time = 480
* CHECK dout0_4 vdout0_4ck47 = 0 time = 480
* CHECK dout0_5 vdout0_5ck47 = 1.95 time = 480
* CHECK dout0_6 vdout0_6ck47 = 1.95 time = 480
* CHECK dout0_7 vdout0_7ck47 = 1.95 time = 480
* CHECK dout0_8 vdout0_8ck47 = 0 time = 480
* CHECK dout0_9 vdout0_9ck47 = 1.95 time = 480
* CHECK dout0_10 vdout0_10ck47 = 1.95 time = 480
* CHECK dout0_11 vdout0_11ck47 = 0 time = 480
* CHECK dout0_12 vdout0_12ck47 = 0 time = 480
* CHECK dout0_13 vdout0_13ck47 = 1.95 time = 480
* CHECK dout0_14 vdout0_14ck47 = 0 time = 480
* CHECK dout0_15 vdout0_15ck47 = 0 time = 480
* CHECK dout0_16 vdout0_16ck47 = 0 time = 480
* CHECK dout0_17 vdout0_17ck47 = 1.95 time = 480
* CHECK dout0_18 vdout0_18ck47 = 1.95 time = 480
* CHECK dout0_19 vdout0_19ck47 = 0 time = 480
* CHECK dout0_20 vdout0_20ck47 = 0 time = 480
* CHECK dout0_21 vdout0_21ck47 = 1.95 time = 480
* CHECK dout0_22 vdout0_22ck47 = 1.95 time = 480
* CHECK dout0_23 vdout0_23ck47 = 0 time = 480
* CHECK dout0_24 vdout0_24ck47 = 1.95 time = 480
* CHECK dout0_25 vdout0_25ck47 = 1.95 time = 480
* CHECK dout0_26 vdout0_26ck47 = 0 time = 480
* CHECK dout0_27 vdout0_27ck47 = 1.95 time = 480
* CHECK dout0_28 vdout0_28ck47 = 1.95 time = 480
* CHECK dout0_29 vdout0_29ck47 = 0 time = 480
* CHECK dout0_30 vdout0_30ck47 = 0 time = 480
* CHECK dout0_31 vdout0_31ck47 = 1.95 time = 480
* CHECK dout0_0 vdout0_0ck49 = 1.95 time = 500
* CHECK dout0_1 vdout0_1ck49 = 0 time = 500
* CHECK dout0_2 vdout0_2ck49 = 1.95 time = 500
* CHECK dout0_3 vdout0_3ck49 = 1.95 time = 500
* CHECK dout0_4 vdout0_4ck49 = 0 time = 500
* CHECK dout0_5 vdout0_5ck49 = 0 time = 500
* CHECK dout0_6 vdout0_6ck49 = 0 time = 500
* CHECK dout0_7 vdout0_7ck49 = 1.95 time = 500
* CHECK dout0_8 vdout0_8ck49 = 0 time = 500
* CHECK dout0_9 vdout0_9ck49 = 0 time = 500
* CHECK dout0_10 vdout0_10ck49 = 0 time = 500
* CHECK dout0_11 vdout0_11ck49 = 0 time = 500
* CHECK dout0_12 vdout0_12ck49 = 0 time = 500
* CHECK dout0_13 vdout0_13ck49 = 0 time = 500
* CHECK dout0_14 vdout0_14ck49 = 0 time = 500
* CHECK dout0_15 vdout0_15ck49 = 1.95 time = 500
* CHECK dout0_16 vdout0_16ck49 = 1.95 time = 500
* CHECK dout0_17 vdout0_17ck49 = 0 time = 500
* CHECK dout0_18 vdout0_18ck49 = 1.95 time = 500
* CHECK dout0_19 vdout0_19ck49 = 1.95 time = 500
* CHECK dout0_20 vdout0_20ck49 = 1.95 time = 500
* CHECK dout0_21 vdout0_21ck49 = 1.95 time = 500
* CHECK dout0_22 vdout0_22ck49 = 1.95 time = 500
* CHECK dout0_23 vdout0_23ck49 = 1.95 time = 500
* CHECK dout0_24 vdout0_24ck49 = 0 time = 500
* CHECK dout0_25 vdout0_25ck49 = 1.95 time = 500
* CHECK dout0_26 vdout0_26ck49 = 1.95 time = 500
* CHECK dout0_27 vdout0_27ck49 = 0 time = 500
* CHECK dout0_28 vdout0_28ck49 = 1.95 time = 500
* CHECK dout0_29 vdout0_29ck49 = 1.95 time = 500
* CHECK dout0_30 vdout0_30ck49 = 0 time = 500
* CHECK dout0_31 vdout0_31ck49 = 1.95 time = 500
* CHECK dout1_0 vdout1_0ck51 = 0 time = 520
* CHECK dout1_1 vdout1_1ck51 = 0 time = 520
* CHECK dout1_2 vdout1_2ck51 = 0 time = 520
* CHECK dout1_3 vdout1_3ck51 = 1.95 time = 520
* CHECK dout1_4 vdout1_4ck51 = 1.95 time = 520
* CHECK dout1_5 vdout1_5ck51 = 0 time = 520
* CHECK dout1_6 vdout1_6ck51 = 1.95 time = 520
* CHECK dout1_7 vdout1_7ck51 = 0 time = 520
* CHECK dout1_8 vdout1_8ck51 = 1.95 time = 520
* CHECK dout1_9 vdout1_9ck51 = 0 time = 520
* CHECK dout1_10 vdout1_10ck51 = 1.95 time = 520
* CHECK dout1_11 vdout1_11ck51 = 1.95 time = 520
* CHECK dout1_12 vdout1_12ck51 = 1.95 time = 520
* CHECK dout1_13 vdout1_13ck51 = 1.95 time = 520
* CHECK dout1_14 vdout1_14ck51 = 1.95 time = 520
* CHECK dout1_15 vdout1_15ck51 = 1.95 time = 520
* CHECK dout1_16 vdout1_16ck51 = 1.95 time = 520
* CHECK dout1_17 vdout1_17ck51 = 0 time = 520
* CHECK dout1_18 vdout1_18ck51 = 0 time = 520
* CHECK dout1_19 vdout1_19ck51 = 1.95 time = 520
* CHECK dout1_20 vdout1_20ck51 = 0 time = 520
* CHECK dout1_21 vdout1_21ck51 = 0 time = 520
* CHECK dout1_22 vdout1_22ck51 = 0 time = 520
* CHECK dout1_23 vdout1_23ck51 = 0 time = 520
* CHECK dout1_24 vdout1_24ck51 = 0 time = 520
* CHECK dout1_25 vdout1_25ck51 = 1.95 time = 520
* CHECK dout1_26 vdout1_26ck51 = 1.95 time = 520
* CHECK dout1_27 vdout1_27ck51 = 0 time = 520
* CHECK dout1_28 vdout1_28ck51 = 1.95 time = 520
* CHECK dout1_29 vdout1_29ck51 = 1.95 time = 520
* CHECK dout1_30 vdout1_30ck51 = 1.95 time = 520
* CHECK dout1_31 vdout1_31ck51 = 1.95 time = 520
* CHECK dout0_0 vdout0_0ck52 = 1.95 time = 530
* CHECK dout0_1 vdout0_1ck52 = 0 time = 530
* CHECK dout0_2 vdout0_2ck52 = 1.95 time = 530
* CHECK dout0_3 vdout0_3ck52 = 1.95 time = 530
* CHECK dout0_4 vdout0_4ck52 = 1.95 time = 530
* CHECK dout0_5 vdout0_5ck52 = 0 time = 530
* CHECK dout0_6 vdout0_6ck52 = 0 time = 530
* CHECK dout0_7 vdout0_7ck52 = 0 time = 530
* CHECK dout0_8 vdout0_8ck52 = 0 time = 530
* CHECK dout0_9 vdout0_9ck52 = 0 time = 530
* CHECK dout0_10 vdout0_10ck52 = 1.95 time = 530
* CHECK dout0_11 vdout0_11ck52 = 1.95 time = 530
* CHECK dout0_12 vdout0_12ck52 = 1.95 time = 530
* CHECK dout0_13 vdout0_13ck52 = 0 time = 530
* CHECK dout0_14 vdout0_14ck52 = 0 time = 530
* CHECK dout0_15 vdout0_15ck52 = 1.95 time = 530
* CHECK dout0_16 vdout0_16ck52 = 1.95 time = 530
* CHECK dout0_17 vdout0_17ck52 = 1.95 time = 530
* CHECK dout0_18 vdout0_18ck52 = 0 time = 530
* CHECK dout0_19 vdout0_19ck52 = 1.95 time = 530
* CHECK dout0_20 vdout0_20ck52 = 0 time = 530
* CHECK dout0_21 vdout0_21ck52 = 0 time = 530
* CHECK dout0_22 vdout0_22ck52 = 1.95 time = 530
* CHECK dout0_23 vdout0_23ck52 = 0 time = 530
* CHECK dout0_24 vdout0_24ck52 = 1.95 time = 530
* CHECK dout0_25 vdout0_25ck52 = 1.95 time = 530
* CHECK dout0_26 vdout0_26ck52 = 1.95 time = 530
* CHECK dout0_27 vdout0_27ck52 = 0 time = 530
* CHECK dout0_28 vdout0_28ck52 = 1.95 time = 530
* CHECK dout0_29 vdout0_29ck52 = 1.95 time = 530
* CHECK dout0_30 vdout0_30ck52 = 1.95 time = 530
* CHECK dout0_31 vdout0_31ck52 = 0 time = 530
* CHECK dout0_0 vdout0_0ck56 = 0 time = 570
* CHECK dout0_1 vdout0_1ck56 = 0 time = 570
* CHECK dout0_2 vdout0_2ck56 = 1.95 time = 570
* CHECK dout0_3 vdout0_3ck56 = 0 time = 570
* CHECK dout0_4 vdout0_4ck56 = 0 time = 570
* CHECK dout0_5 vdout0_5ck56 = 1.95 time = 570
* CHECK dout0_6 vdout0_6ck56 = 0 time = 570
* CHECK dout0_7 vdout0_7ck56 = 1.95 time = 570
* CHECK dout0_8 vdout0_8ck56 = 1.95 time = 570
* CHECK dout0_9 vdout0_9ck56 = 0 time = 570
* CHECK dout0_10 vdout0_10ck56 = 1.95 time = 570
* CHECK dout0_11 vdout0_11ck56 = 1.95 time = 570
* CHECK dout0_12 vdout0_12ck56 = 1.95 time = 570
* CHECK dout0_13 vdout0_13ck56 = 1.95 time = 570
* CHECK dout0_14 vdout0_14ck56 = 1.95 time = 570
* CHECK dout0_15 vdout0_15ck56 = 1.95 time = 570
* CHECK dout0_16 vdout0_16ck56 = 1.95 time = 570
* CHECK dout0_17 vdout0_17ck56 = 1.95 time = 570
* CHECK dout0_18 vdout0_18ck56 = 1.95 time = 570
* CHECK dout0_19 vdout0_19ck56 = 0 time = 570
* CHECK dout0_20 vdout0_20ck56 = 0 time = 570
* CHECK dout0_21 vdout0_21ck56 = 1.95 time = 570
* CHECK dout0_22 vdout0_22ck56 = 1.95 time = 570
* CHECK dout0_23 vdout0_23ck56 = 1.95 time = 570
* CHECK dout0_24 vdout0_24ck56 = 1.95 time = 570
* CHECK dout0_25 vdout0_25ck56 = 1.95 time = 570
* CHECK dout0_26 vdout0_26ck56 = 1.95 time = 570
* CHECK dout0_27 vdout0_27ck56 = 0 time = 570
* CHECK dout0_28 vdout0_28ck56 = 1.95 time = 570
* CHECK dout0_29 vdout0_29ck56 = 1.95 time = 570
* CHECK dout0_30 vdout0_30ck56 = 0 time = 570
* CHECK dout0_31 vdout0_31ck56 = 1.95 time = 570
* CHECK dout0_0 vdout0_0ck58 = 0 time = 590
* CHECK dout0_1 vdout0_1ck58 = 0 time = 590
* CHECK dout0_2 vdout0_2ck58 = 1.95 time = 590
* CHECK dout0_3 vdout0_3ck58 = 0 time = 590
* CHECK dout0_4 vdout0_4ck58 = 0 time = 590
* CHECK dout0_5 vdout0_5ck58 = 1.95 time = 590
* CHECK dout0_6 vdout0_6ck58 = 0 time = 590
* CHECK dout0_7 vdout0_7ck58 = 1.95 time = 590
* CHECK dout0_8 vdout0_8ck58 = 1.95 time = 590
* CHECK dout0_9 vdout0_9ck58 = 0 time = 590
* CHECK dout0_10 vdout0_10ck58 = 1.95 time = 590
* CHECK dout0_11 vdout0_11ck58 = 1.95 time = 590
* CHECK dout0_12 vdout0_12ck58 = 1.95 time = 590
* CHECK dout0_13 vdout0_13ck58 = 1.95 time = 590
* CHECK dout0_14 vdout0_14ck58 = 1.95 time = 590
* CHECK dout0_15 vdout0_15ck58 = 1.95 time = 590
* CHECK dout0_16 vdout0_16ck58 = 1.95 time = 590
* CHECK dout0_17 vdout0_17ck58 = 1.95 time = 590
* CHECK dout0_18 vdout0_18ck58 = 1.95 time = 590
* CHECK dout0_19 vdout0_19ck58 = 0 time = 590
* CHECK dout0_20 vdout0_20ck58 = 0 time = 590
* CHECK dout0_21 vdout0_21ck58 = 1.95 time = 590
* CHECK dout0_22 vdout0_22ck58 = 1.95 time = 590
* CHECK dout0_23 vdout0_23ck58 = 1.95 time = 590
* CHECK dout0_24 vdout0_24ck58 = 1.95 time = 590
* CHECK dout0_25 vdout0_25ck58 = 1.95 time = 590
* CHECK dout0_26 vdout0_26ck58 = 1.95 time = 590
* CHECK dout0_27 vdout0_27ck58 = 0 time = 590
* CHECK dout0_28 vdout0_28ck58 = 1.95 time = 590
* CHECK dout0_29 vdout0_29ck58 = 1.95 time = 590
* CHECK dout0_30 vdout0_30ck58 = 0 time = 590
* CHECK dout0_31 vdout0_31ck58 = 1.95 time = 590
* CHECK dout1_0 vdout1_0ck58 = 0 time = 590
* CHECK dout1_1 vdout1_1ck58 = 0 time = 590
* CHECK dout1_2 vdout1_2ck58 = 1.95 time = 590
* CHECK dout1_3 vdout1_3ck58 = 0 time = 590
* CHECK dout1_4 vdout1_4ck58 = 0 time = 590
* CHECK dout1_5 vdout1_5ck58 = 1.95 time = 590
* CHECK dout1_6 vdout1_6ck58 = 0 time = 590
* CHECK dout1_7 vdout1_7ck58 = 1.95 time = 590
* CHECK dout1_8 vdout1_8ck58 = 1.95 time = 590
* CHECK dout1_9 vdout1_9ck58 = 0 time = 590
* CHECK dout1_10 vdout1_10ck58 = 1.95 time = 590
* CHECK dout1_11 vdout1_11ck58 = 1.95 time = 590
* CHECK dout1_12 vdout1_12ck58 = 1.95 time = 590
* CHECK dout1_13 vdout1_13ck58 = 1.95 time = 590
* CHECK dout1_14 vdout1_14ck58 = 1.95 time = 590
* CHECK dout1_15 vdout1_15ck58 = 1.95 time = 590
* CHECK dout1_16 vdout1_16ck58 = 1.95 time = 590
* CHECK dout1_17 vdout1_17ck58 = 1.95 time = 590
* CHECK dout1_18 vdout1_18ck58 = 1.95 time = 590
* CHECK dout1_19 vdout1_19ck58 = 0 time = 590
* CHECK dout1_20 vdout1_20ck58 = 0 time = 590
* CHECK dout1_21 vdout1_21ck58 = 1.95 time = 590
* CHECK dout1_22 vdout1_22ck58 = 1.95 time = 590
* CHECK dout1_23 vdout1_23ck58 = 1.95 time = 590
* CHECK dout1_24 vdout1_24ck58 = 1.95 time = 590
* CHECK dout1_25 vdout1_25ck58 = 1.95 time = 590
* CHECK dout1_26 vdout1_26ck58 = 1.95 time = 590
* CHECK dout1_27 vdout1_27ck58 = 0 time = 590
* CHECK dout1_28 vdout1_28ck58 = 1.95 time = 590
* CHECK dout1_29 vdout1_29ck58 = 1.95 time = 590
* CHECK dout1_30 vdout1_30ck58 = 0 time = 590
* CHECK dout1_31 vdout1_31ck58 = 1.95 time = 590
* CHECK dout0_0 vdout0_0ck60 = 1.95 time = 610
* CHECK dout0_1 vdout0_1ck60 = 1.95 time = 610
* CHECK dout0_2 vdout0_2ck60 = 0 time = 610
* CHECK dout0_3 vdout0_3ck60 = 0 time = 610
* CHECK dout0_4 vdout0_4ck60 = 1.95 time = 610
* CHECK dout0_5 vdout0_5ck60 = 0 time = 610
* CHECK dout0_6 vdout0_6ck60 = 1.95 time = 610
* CHECK dout0_7 vdout0_7ck60 = 1.95 time = 610
* CHECK dout0_8 vdout0_8ck60 = 1.95 time = 610
* CHECK dout0_9 vdout0_9ck60 = 1.95 time = 610
* CHECK dout0_10 vdout0_10ck60 = 1.95 time = 610
* CHECK dout0_11 vdout0_11ck60 = 1.95 time = 610
* CHECK dout0_12 vdout0_12ck60 = 1.95 time = 610
* CHECK dout0_13 vdout0_13ck60 = 1.95 time = 610
* CHECK dout0_14 vdout0_14ck60 = 1.95 time = 610
* CHECK dout0_15 vdout0_15ck60 = 0 time = 610
* CHECK dout0_16 vdout0_16ck60 = 0 time = 610
* CHECK dout0_17 vdout0_17ck60 = 1.95 time = 610
* CHECK dout0_18 vdout0_18ck60 = 1.95 time = 610
* CHECK dout0_19 vdout0_19ck60 = 0 time = 610
* CHECK dout0_20 vdout0_20ck60 = 0 time = 610
* CHECK dout0_21 vdout0_21ck60 = 0 time = 610
* CHECK dout0_22 vdout0_22ck60 = 0 time = 610
* CHECK dout0_23 vdout0_23ck60 = 1.95 time = 610
* CHECK dout0_24 vdout0_24ck60 = 1.95 time = 610
* CHECK dout0_25 vdout0_25ck60 = 0 time = 610
* CHECK dout0_26 vdout0_26ck60 = 0 time = 610
* CHECK dout0_27 vdout0_27ck60 = 0 time = 610
* CHECK dout0_28 vdout0_28ck60 = 0 time = 610
* CHECK dout0_29 vdout0_29ck60 = 0 time = 610
* CHECK dout0_30 vdout0_30ck60 = 1.95 time = 610
* CHECK dout0_31 vdout0_31ck60 = 1.95 time = 610
* CHECK dout1_0 vdout1_0ck60 = 1.95 time = 610
* CHECK dout1_1 vdout1_1ck60 = 1.95 time = 610
* CHECK dout1_2 vdout1_2ck60 = 0 time = 610
* CHECK dout1_3 vdout1_3ck60 = 0 time = 610
* CHECK dout1_4 vdout1_4ck60 = 1.95 time = 610
* CHECK dout1_5 vdout1_5ck60 = 0 time = 610
* CHECK dout1_6 vdout1_6ck60 = 1.95 time = 610
* CHECK dout1_7 vdout1_7ck60 = 1.95 time = 610
* CHECK dout1_8 vdout1_8ck60 = 1.95 time = 610
* CHECK dout1_9 vdout1_9ck60 = 1.95 time = 610
* CHECK dout1_10 vdout1_10ck60 = 1.95 time = 610
* CHECK dout1_11 vdout1_11ck60 = 1.95 time = 610
* CHECK dout1_12 vdout1_12ck60 = 1.95 time = 610
* CHECK dout1_13 vdout1_13ck60 = 1.95 time = 610
* CHECK dout1_14 vdout1_14ck60 = 1.95 time = 610
* CHECK dout1_15 vdout1_15ck60 = 0 time = 610
* CHECK dout1_16 vdout1_16ck60 = 0 time = 610
* CHECK dout1_17 vdout1_17ck60 = 1.95 time = 610
* CHECK dout1_18 vdout1_18ck60 = 1.95 time = 610
* CHECK dout1_19 vdout1_19ck60 = 0 time = 610
* CHECK dout1_20 vdout1_20ck60 = 0 time = 610
* CHECK dout1_21 vdout1_21ck60 = 0 time = 610
* CHECK dout1_22 vdout1_22ck60 = 0 time = 610
* CHECK dout1_23 vdout1_23ck60 = 1.95 time = 610
* CHECK dout1_24 vdout1_24ck60 = 1.95 time = 610
* CHECK dout1_25 vdout1_25ck60 = 0 time = 610
* CHECK dout1_26 vdout1_26ck60 = 0 time = 610
* CHECK dout1_27 vdout1_27ck60 = 0 time = 610
* CHECK dout1_28 vdout1_28ck60 = 0 time = 610
* CHECK dout1_29 vdout1_29ck60 = 0 time = 610
* CHECK dout1_30 vdout1_30ck60 = 1.95 time = 610
* CHECK dout1_31 vdout1_31ck60 = 1.95 time = 610
* CHECK dout0_0 vdout0_0ck61 = 0 time = 620
* CHECK dout0_1 vdout0_1ck61 = 0 time = 620
* CHECK dout0_2 vdout0_2ck61 = 1.95 time = 620
* CHECK dout0_3 vdout0_3ck61 = 0 time = 620
* CHECK dout0_4 vdout0_4ck61 = 0 time = 620
* CHECK dout0_5 vdout0_5ck61 = 1.95 time = 620
* CHECK dout0_6 vdout0_6ck61 = 0 time = 620
* CHECK dout0_7 vdout0_7ck61 = 1.95 time = 620
* CHECK dout0_8 vdout0_8ck61 = 1.95 time = 620
* CHECK dout0_9 vdout0_9ck61 = 0 time = 620
* CHECK dout0_10 vdout0_10ck61 = 1.95 time = 620
* CHECK dout0_11 vdout0_11ck61 = 1.95 time = 620
* CHECK dout0_12 vdout0_12ck61 = 1.95 time = 620
* CHECK dout0_13 vdout0_13ck61 = 1.95 time = 620
* CHECK dout0_14 vdout0_14ck61 = 1.95 time = 620
* CHECK dout0_15 vdout0_15ck61 = 1.95 time = 620
* CHECK dout0_16 vdout0_16ck61 = 1.95 time = 620
* CHECK dout0_17 vdout0_17ck61 = 1.95 time = 620
* CHECK dout0_18 vdout0_18ck61 = 1.95 time = 620
* CHECK dout0_19 vdout0_19ck61 = 0 time = 620
* CHECK dout0_20 vdout0_20ck61 = 0 time = 620
* CHECK dout0_21 vdout0_21ck61 = 1.95 time = 620
* CHECK dout0_22 vdout0_22ck61 = 1.95 time = 620
* CHECK dout0_23 vdout0_23ck61 = 1.95 time = 620
* CHECK dout0_24 vdout0_24ck61 = 1.95 time = 620
* CHECK dout0_25 vdout0_25ck61 = 1.95 time = 620
* CHECK dout0_26 vdout0_26ck61 = 1.95 time = 620
* CHECK dout0_27 vdout0_27ck61 = 0 time = 620
* CHECK dout0_28 vdout0_28ck61 = 1.95 time = 620
* CHECK dout0_29 vdout0_29ck61 = 1.95 time = 620
* CHECK dout0_30 vdout0_30ck61 = 0 time = 620
* CHECK dout0_31 vdout0_31ck61 = 1.95 time = 620
* CHECK dout0_0 vdout0_0ck62 = 0 time = 630
* CHECK dout0_1 vdout0_1ck62 = 0 time = 630
* CHECK dout0_2 vdout0_2ck62 = 1.95 time = 630
* CHECK dout0_3 vdout0_3ck62 = 0 time = 630
* CHECK dout0_4 vdout0_4ck62 = 0 time = 630
* CHECK dout0_5 vdout0_5ck62 = 1.95 time = 630
* CHECK dout0_6 vdout0_6ck62 = 0 time = 630
* CHECK dout0_7 vdout0_7ck62 = 1.95 time = 630
* CHECK dout0_8 vdout0_8ck62 = 1.95 time = 630
* CHECK dout0_9 vdout0_9ck62 = 0 time = 630
* CHECK dout0_10 vdout0_10ck62 = 1.95 time = 630
* CHECK dout0_11 vdout0_11ck62 = 1.95 time = 630
* CHECK dout0_12 vdout0_12ck62 = 1.95 time = 630
* CHECK dout0_13 vdout0_13ck62 = 1.95 time = 630
* CHECK dout0_14 vdout0_14ck62 = 1.95 time = 630
* CHECK dout0_15 vdout0_15ck62 = 1.95 time = 630
* CHECK dout0_16 vdout0_16ck62 = 1.95 time = 630
* CHECK dout0_17 vdout0_17ck62 = 1.95 time = 630
* CHECK dout0_18 vdout0_18ck62 = 1.95 time = 630
* CHECK dout0_19 vdout0_19ck62 = 0 time = 630
* CHECK dout0_20 vdout0_20ck62 = 0 time = 630
* CHECK dout0_21 vdout0_21ck62 = 1.95 time = 630
* CHECK dout0_22 vdout0_22ck62 = 1.95 time = 630
* CHECK dout0_23 vdout0_23ck62 = 1.95 time = 630
* CHECK dout0_24 vdout0_24ck62 = 1.95 time = 630
* CHECK dout0_25 vdout0_25ck62 = 1.95 time = 630
* CHECK dout0_26 vdout0_26ck62 = 1.95 time = 630
* CHECK dout0_27 vdout0_27ck62 = 0 time = 630
* CHECK dout0_28 vdout0_28ck62 = 1.95 time = 630
* CHECK dout0_29 vdout0_29ck62 = 1.95 time = 630
* CHECK dout0_30 vdout0_30ck62 = 0 time = 630
* CHECK dout0_31 vdout0_31ck62 = 1.95 time = 630
* CHECK dout1_0 vdout1_0ck62 = 0 time = 630
* CHECK dout1_1 vdout1_1ck62 = 0 time = 630
* CHECK dout1_2 vdout1_2ck62 = 0 time = 630
* CHECK dout1_3 vdout1_3ck62 = 0 time = 630
* CHECK dout1_4 vdout1_4ck62 = 1.95 time = 630
* CHECK dout1_5 vdout1_5ck62 = 1.95 time = 630
* CHECK dout1_6 vdout1_6ck62 = 1.95 time = 630
* CHECK dout1_7 vdout1_7ck62 = 1.95 time = 630
* CHECK dout1_8 vdout1_8ck62 = 0 time = 630
* CHECK dout1_9 vdout1_9ck62 = 1.95 time = 630
* CHECK dout1_10 vdout1_10ck62 = 0 time = 630
* CHECK dout1_11 vdout1_11ck62 = 1.95 time = 630
* CHECK dout1_12 vdout1_12ck62 = 1.95 time = 630
* CHECK dout1_13 vdout1_13ck62 = 1.95 time = 630
* CHECK dout1_14 vdout1_14ck62 = 1.95 time = 630
* CHECK dout1_15 vdout1_15ck62 = 0 time = 630
* CHECK dout1_16 vdout1_16ck62 = 0 time = 630
* CHECK dout1_17 vdout1_17ck62 = 0 time = 630
* CHECK dout1_18 vdout1_18ck62 = 1.95 time = 630
* CHECK dout1_19 vdout1_19ck62 = 0 time = 630
* CHECK dout1_20 vdout1_20ck62 = 1.95 time = 630
* CHECK dout1_21 vdout1_21ck62 = 1.95 time = 630
* CHECK dout1_22 vdout1_22ck62 = 1.95 time = 630
* CHECK dout1_23 vdout1_23ck62 = 0 time = 630
* CHECK dout1_24 vdout1_24ck62 = 1.95 time = 630
* CHECK dout1_25 vdout1_25ck62 = 1.95 time = 630
* CHECK dout1_26 vdout1_26ck62 = 1.95 time = 630
* CHECK dout1_27 vdout1_27ck62 = 0 time = 630
* CHECK dout1_28 vdout1_28ck62 = 1.95 time = 630
* CHECK dout1_29 vdout1_29ck62 = 1.95 time = 630
* CHECK dout1_30 vdout1_30ck62 = 0 time = 630
* CHECK dout1_31 vdout1_31ck62 = 0 time = 630
* CHECK dout1_0 vdout1_0ck63 = 0 time = 640
* CHECK dout1_1 vdout1_1ck63 = 0 time = 640
* CHECK dout1_2 vdout1_2ck63 = 0 time = 640
* CHECK dout1_3 vdout1_3ck63 = 0 time = 640
* CHECK dout1_4 vdout1_4ck63 = 1.95 time = 640
* CHECK dout1_5 vdout1_5ck63 = 1.95 time = 640
* CHECK dout1_6 vdout1_6ck63 = 1.95 time = 640
* CHECK dout1_7 vdout1_7ck63 = 1.95 time = 640
* CHECK dout1_8 vdout1_8ck63 = 0 time = 640
* CHECK dout1_9 vdout1_9ck63 = 1.95 time = 640
* CHECK dout1_10 vdout1_10ck63 = 0 time = 640
* CHECK dout1_11 vdout1_11ck63 = 1.95 time = 640
* CHECK dout1_12 vdout1_12ck63 = 1.95 time = 640
* CHECK dout1_13 vdout1_13ck63 = 1.95 time = 640
* CHECK dout1_14 vdout1_14ck63 = 1.95 time = 640
* CHECK dout1_15 vdout1_15ck63 = 0 time = 640
* CHECK dout1_16 vdout1_16ck63 = 0 time = 640
* CHECK dout1_17 vdout1_17ck63 = 0 time = 640
* CHECK dout1_18 vdout1_18ck63 = 1.95 time = 640
* CHECK dout1_19 vdout1_19ck63 = 0 time = 640
* CHECK dout1_20 vdout1_20ck63 = 1.95 time = 640
* CHECK dout1_21 vdout1_21ck63 = 1.95 time = 640
* CHECK dout1_22 vdout1_22ck63 = 1.95 time = 640
* CHECK dout1_23 vdout1_23ck63 = 0 time = 640
* CHECK dout1_24 vdout1_24ck63 = 1.95 time = 640
* CHECK dout1_25 vdout1_25ck63 = 1.95 time = 640
* CHECK dout1_26 vdout1_26ck63 = 1.95 time = 640
* CHECK dout1_27 vdout1_27ck63 = 0 time = 640
* CHECK dout1_28 vdout1_28ck63 = 1.95 time = 640
* CHECK dout1_29 vdout1_29ck63 = 1.95 time = 640
* CHECK dout1_30 vdout1_30ck63 = 0 time = 640
* CHECK dout1_31 vdout1_31ck63 = 0 time = 640
* CHECK dout1_0 vdout1_0ck65 = 1.95 time = 660
* CHECK dout1_1 vdout1_1ck65 = 1.95 time = 660
* CHECK dout1_2 vdout1_2ck65 = 0 time = 660
* CHECK dout1_3 vdout1_3ck65 = 0 time = 660
* CHECK dout1_4 vdout1_4ck65 = 1.95 time = 660
* CHECK dout1_5 vdout1_5ck65 = 0 time = 660
* CHECK dout1_6 vdout1_6ck65 = 1.95 time = 660
* CHECK dout1_7 vdout1_7ck65 = 1.95 time = 660
* CHECK dout1_8 vdout1_8ck65 = 0 time = 660
* CHECK dout1_9 vdout1_9ck65 = 1.95 time = 660
* CHECK dout1_10 vdout1_10ck65 = 0 time = 660
* CHECK dout1_11 vdout1_11ck65 = 1.95 time = 660
* CHECK dout1_12 vdout1_12ck65 = 1.95 time = 660
* CHECK dout1_13 vdout1_13ck65 = 1.95 time = 660
* CHECK dout1_14 vdout1_14ck65 = 0 time = 660
* CHECK dout1_15 vdout1_15ck65 = 0 time = 660
* CHECK dout1_16 vdout1_16ck65 = 0 time = 660
* CHECK dout1_17 vdout1_17ck65 = 0 time = 660
* CHECK dout1_18 vdout1_18ck65 = 0 time = 660
* CHECK dout1_19 vdout1_19ck65 = 1.95 time = 660
* CHECK dout1_20 vdout1_20ck65 = 0 time = 660
* CHECK dout1_21 vdout1_21ck65 = 0 time = 660
* CHECK dout1_22 vdout1_22ck65 = 1.95 time = 660
* CHECK dout1_23 vdout1_23ck65 = 0 time = 660
* CHECK dout1_24 vdout1_24ck65 = 1.95 time = 660
* CHECK dout1_25 vdout1_25ck65 = 1.95 time = 660
* CHECK dout1_26 vdout1_26ck65 = 1.95 time = 660
* CHECK dout1_27 vdout1_27ck65 = 1.95 time = 660
* CHECK dout1_28 vdout1_28ck65 = 0 time = 660
* CHECK dout1_29 vdout1_29ck65 = 0 time = 660
* CHECK dout1_30 vdout1_30ck65 = 0 time = 660
* CHECK dout1_31 vdout1_31ck65 = 0 time = 660
* CHECK dout0_0 vdout0_0ck66 = 1.95 time = 670
* CHECK dout0_1 vdout0_1ck66 = 1.95 time = 670
* CHECK dout0_2 vdout0_2ck66 = 0 time = 670
* CHECK dout0_3 vdout0_3ck66 = 0 time = 670
* CHECK dout0_4 vdout0_4ck66 = 1.95 time = 670
* CHECK dout0_5 vdout0_5ck66 = 0 time = 670
* CHECK dout0_6 vdout0_6ck66 = 1.95 time = 670
* CHECK dout0_7 vdout0_7ck66 = 1.95 time = 670
* CHECK dout0_8 vdout0_8ck66 = 0 time = 670
* CHECK dout0_9 vdout0_9ck66 = 1.95 time = 670
* CHECK dout0_10 vdout0_10ck66 = 0 time = 670
* CHECK dout0_11 vdout0_11ck66 = 1.95 time = 670
* CHECK dout0_12 vdout0_12ck66 = 1.95 time = 670
* CHECK dout0_13 vdout0_13ck66 = 1.95 time = 670
* CHECK dout0_14 vdout0_14ck66 = 0 time = 670
* CHECK dout0_15 vdout0_15ck66 = 0 time = 670
* CHECK dout0_16 vdout0_16ck66 = 0 time = 670
* CHECK dout0_17 vdout0_17ck66 = 0 time = 670
* CHECK dout0_18 vdout0_18ck66 = 0 time = 670
* CHECK dout0_19 vdout0_19ck66 = 1.95 time = 670
* CHECK dout0_20 vdout0_20ck66 = 0 time = 670
* CHECK dout0_21 vdout0_21ck66 = 0 time = 670
* CHECK dout0_22 vdout0_22ck66 = 1.95 time = 670
* CHECK dout0_23 vdout0_23ck66 = 0 time = 670
* CHECK dout0_24 vdout0_24ck66 = 1.95 time = 670
* CHECK dout0_25 vdout0_25ck66 = 1.95 time = 670
* CHECK dout0_26 vdout0_26ck66 = 1.95 time = 670
* CHECK dout0_27 vdout0_27ck66 = 1.95 time = 670
* CHECK dout0_28 vdout0_28ck66 = 0 time = 670
* CHECK dout0_29 vdout0_29ck66 = 0 time = 670
* CHECK dout0_30 vdout0_30ck66 = 0 time = 670
* CHECK dout0_31 vdout0_31ck66 = 0 time = 670
* CHECK dout1_0 vdout1_0ck66 = 0 time = 670
* CHECK dout1_1 vdout1_1ck66 = 0 time = 670
* CHECK dout1_2 vdout1_2ck66 = 0 time = 670
* CHECK dout1_3 vdout1_3ck66 = 0 time = 670
* CHECK dout1_4 vdout1_4ck66 = 1.95 time = 670
* CHECK dout1_5 vdout1_5ck66 = 1.95 time = 670
* CHECK dout1_6 vdout1_6ck66 = 1.95 time = 670
* CHECK dout1_7 vdout1_7ck66 = 1.95 time = 670
* CHECK dout1_8 vdout1_8ck66 = 0 time = 670
* CHECK dout1_9 vdout1_9ck66 = 1.95 time = 670
* CHECK dout1_10 vdout1_10ck66 = 0 time = 670
* CHECK dout1_11 vdout1_11ck66 = 1.95 time = 670
* CHECK dout1_12 vdout1_12ck66 = 1.95 time = 670
* CHECK dout1_13 vdout1_13ck66 = 1.95 time = 670
* CHECK dout1_14 vdout1_14ck66 = 1.95 time = 670
* CHECK dout1_15 vdout1_15ck66 = 0 time = 670
* CHECK dout1_16 vdout1_16ck66 = 0 time = 670
* CHECK dout1_17 vdout1_17ck66 = 0 time = 670
* CHECK dout1_18 vdout1_18ck66 = 1.95 time = 670
* CHECK dout1_19 vdout1_19ck66 = 0 time = 670
* CHECK dout1_20 vdout1_20ck66 = 1.95 time = 670
* CHECK dout1_21 vdout1_21ck66 = 1.95 time = 670
* CHECK dout1_22 vdout1_22ck66 = 1.95 time = 670
* CHECK dout1_23 vdout1_23ck66 = 0 time = 670
* CHECK dout1_24 vdout1_24ck66 = 1.95 time = 670
* CHECK dout1_25 vdout1_25ck66 = 1.95 time = 670
* CHECK dout1_26 vdout1_26ck66 = 1.95 time = 670
* CHECK dout1_27 vdout1_27ck66 = 0 time = 670
* CHECK dout1_28 vdout1_28ck66 = 1.95 time = 670
* CHECK dout1_29 vdout1_29ck66 = 1.95 time = 670
* CHECK dout1_30 vdout1_30ck66 = 0 time = 670
* CHECK dout1_31 vdout1_31ck66 = 0 time = 670
* CHECK dout0_0 vdout0_0ck68 = 0 time = 690
* CHECK dout0_1 vdout0_1ck68 = 1.95 time = 690
* CHECK dout0_2 vdout0_2ck68 = 0 time = 690
* CHECK dout0_3 vdout0_3ck68 = 1.95 time = 690
* CHECK dout0_4 vdout0_4ck68 = 0 time = 690
* CHECK dout0_5 vdout0_5ck68 = 1.95 time = 690
* CHECK dout0_6 vdout0_6ck68 = 0 time = 690
* CHECK dout0_7 vdout0_7ck68 = 0 time = 690
* CHECK dout0_8 vdout0_8ck68 = 0 time = 690
* CHECK dout0_9 vdout0_9ck68 = 1.95 time = 690
* CHECK dout0_10 vdout0_10ck68 = 0 time = 690
* CHECK dout0_11 vdout0_11ck68 = 1.95 time = 690
* CHECK dout0_12 vdout0_12ck68 = 0 time = 690
* CHECK dout0_13 vdout0_13ck68 = 1.95 time = 690
* CHECK dout0_14 vdout0_14ck68 = 1.95 time = 690
* CHECK dout0_15 vdout0_15ck68 = 0 time = 690
* CHECK dout0_16 vdout0_16ck68 = 0 time = 690
* CHECK dout0_17 vdout0_17ck68 = 0 time = 690
* CHECK dout0_18 vdout0_18ck68 = 0 time = 690
* CHECK dout0_19 vdout0_19ck68 = 0 time = 690
* CHECK dout0_20 vdout0_20ck68 = 1.95 time = 690
* CHECK dout0_21 vdout0_21ck68 = 1.95 time = 690
* CHECK dout0_22 vdout0_22ck68 = 0 time = 690
* CHECK dout0_23 vdout0_23ck68 = 1.95 time = 690
* CHECK dout0_24 vdout0_24ck68 = 1.95 time = 690
* CHECK dout0_25 vdout0_25ck68 = 1.95 time = 690
* CHECK dout0_26 vdout0_26ck68 = 0 time = 690
* CHECK dout0_27 vdout0_27ck68 = 0 time = 690
* CHECK dout0_28 vdout0_28ck68 = 1.95 time = 690
* CHECK dout0_29 vdout0_29ck68 = 0 time = 690
* CHECK dout0_30 vdout0_30ck68 = 0 time = 690
* CHECK dout0_31 vdout0_31ck68 = 0 time = 690
* CHECK dout0_0 vdout0_0ck69 = 0 time = 700
* CHECK dout0_1 vdout0_1ck69 = 0 time = 700
* CHECK dout0_2 vdout0_2ck69 = 1.95 time = 700
* CHECK dout0_3 vdout0_3ck69 = 0 time = 700
* CHECK dout0_4 vdout0_4ck69 = 0 time = 700
* CHECK dout0_5 vdout0_5ck69 = 1.95 time = 700
* CHECK dout0_6 vdout0_6ck69 = 0 time = 700
* CHECK dout0_7 vdout0_7ck69 = 1.95 time = 700
* CHECK dout0_8 vdout0_8ck69 = 1.95 time = 700
* CHECK dout0_9 vdout0_9ck69 = 0 time = 700
* CHECK dout0_10 vdout0_10ck69 = 1.95 time = 700
* CHECK dout0_11 vdout0_11ck69 = 1.95 time = 700
* CHECK dout0_12 vdout0_12ck69 = 1.95 time = 700
* CHECK dout0_13 vdout0_13ck69 = 1.95 time = 700
* CHECK dout0_14 vdout0_14ck69 = 1.95 time = 700
* CHECK dout0_15 vdout0_15ck69 = 1.95 time = 700
* CHECK dout0_16 vdout0_16ck69 = 1.95 time = 700
* CHECK dout0_17 vdout0_17ck69 = 1.95 time = 700
* CHECK dout0_18 vdout0_18ck69 = 1.95 time = 700
* CHECK dout0_19 vdout0_19ck69 = 0 time = 700
* CHECK dout0_20 vdout0_20ck69 = 0 time = 700
* CHECK dout0_21 vdout0_21ck69 = 1.95 time = 700
* CHECK dout0_22 vdout0_22ck69 = 1.95 time = 700
* CHECK dout0_23 vdout0_23ck69 = 1.95 time = 700
* CHECK dout0_24 vdout0_24ck69 = 1.95 time = 700
* CHECK dout0_25 vdout0_25ck69 = 1.95 time = 700
* CHECK dout0_26 vdout0_26ck69 = 1.95 time = 700
* CHECK dout0_27 vdout0_27ck69 = 0 time = 700
* CHECK dout0_28 vdout0_28ck69 = 1.95 time = 700
* CHECK dout0_29 vdout0_29ck69 = 1.95 time = 700
* CHECK dout0_30 vdout0_30ck69 = 0 time = 700
* CHECK dout0_31 vdout0_31ck69 = 1.95 time = 700
* CHECK dout1_0 vdout1_0ck69 = 1.95 time = 700
* CHECK dout1_1 vdout1_1ck69 = 1.95 time = 700
* CHECK dout1_2 vdout1_2ck69 = 0 time = 700
* CHECK dout1_3 vdout1_3ck69 = 0 time = 700
* CHECK dout1_4 vdout1_4ck69 = 1.95 time = 700
* CHECK dout1_5 vdout1_5ck69 = 0 time = 700
* CHECK dout1_6 vdout1_6ck69 = 1.95 time = 700
* CHECK dout1_7 vdout1_7ck69 = 1.95 time = 700
* CHECK dout1_8 vdout1_8ck69 = 0 time = 700
* CHECK dout1_9 vdout1_9ck69 = 1.95 time = 700
* CHECK dout1_10 vdout1_10ck69 = 0 time = 700
* CHECK dout1_11 vdout1_11ck69 = 1.95 time = 700
* CHECK dout1_12 vdout1_12ck69 = 1.95 time = 700
* CHECK dout1_13 vdout1_13ck69 = 1.95 time = 700
* CHECK dout1_14 vdout1_14ck69 = 0 time = 700
* CHECK dout1_15 vdout1_15ck69 = 0 time = 700
* CHECK dout1_16 vdout1_16ck69 = 0 time = 700
* CHECK dout1_17 vdout1_17ck69 = 0 time = 700
* CHECK dout1_18 vdout1_18ck69 = 0 time = 700
* CHECK dout1_19 vdout1_19ck69 = 1.95 time = 700
* CHECK dout1_20 vdout1_20ck69 = 0 time = 700
* CHECK dout1_21 vdout1_21ck69 = 0 time = 700
* CHECK dout1_22 vdout1_22ck69 = 1.95 time = 700
* CHECK dout1_23 vdout1_23ck69 = 0 time = 700
* CHECK dout1_24 vdout1_24ck69 = 1.95 time = 700
* CHECK dout1_25 vdout1_25ck69 = 1.95 time = 700
* CHECK dout1_26 vdout1_26ck69 = 1.95 time = 700
* CHECK dout1_27 vdout1_27ck69 = 1.95 time = 700
* CHECK dout1_28 vdout1_28ck69 = 0 time = 700
* CHECK dout1_29 vdout1_29ck69 = 0 time = 700
* CHECK dout1_30 vdout1_30ck69 = 0 time = 700
* CHECK dout1_31 vdout1_31ck69 = 0 time = 700
* CHECK dout1_0 vdout1_0ck70 = 0 time = 710
* CHECK dout1_1 vdout1_1ck70 = 0 time = 710
* CHECK dout1_2 vdout1_2ck70 = 1.95 time = 710
* CHECK dout1_3 vdout1_3ck70 = 0 time = 710
* CHECK dout1_4 vdout1_4ck70 = 0 time = 710
* CHECK dout1_5 vdout1_5ck70 = 1.95 time = 710
* CHECK dout1_6 vdout1_6ck70 = 0 time = 710
* CHECK dout1_7 vdout1_7ck70 = 1.95 time = 710
* CHECK dout1_8 vdout1_8ck70 = 1.95 time = 710
* CHECK dout1_9 vdout1_9ck70 = 0 time = 710
* CHECK dout1_10 vdout1_10ck70 = 1.95 time = 710
* CHECK dout1_11 vdout1_11ck70 = 1.95 time = 710
* CHECK dout1_12 vdout1_12ck70 = 1.95 time = 710
* CHECK dout1_13 vdout1_13ck70 = 1.95 time = 710
* CHECK dout1_14 vdout1_14ck70 = 1.95 time = 710
* CHECK dout1_15 vdout1_15ck70 = 1.95 time = 710
* CHECK dout1_16 vdout1_16ck70 = 1.95 time = 710
* CHECK dout1_17 vdout1_17ck70 = 1.95 time = 710
* CHECK dout1_18 vdout1_18ck70 = 1.95 time = 710
* CHECK dout1_19 vdout1_19ck70 = 0 time = 710
* CHECK dout1_20 vdout1_20ck70 = 0 time = 710
* CHECK dout1_21 vdout1_21ck70 = 1.95 time = 710
* CHECK dout1_22 vdout1_22ck70 = 1.95 time = 710
* CHECK dout1_23 vdout1_23ck70 = 1.95 time = 710
* CHECK dout1_24 vdout1_24ck70 = 1.95 time = 710
* CHECK dout1_25 vdout1_25ck70 = 1.95 time = 710
* CHECK dout1_26 vdout1_26ck70 = 1.95 time = 710
* CHECK dout1_27 vdout1_27ck70 = 0 time = 710
* CHECK dout1_28 vdout1_28ck70 = 1.95 time = 710
* CHECK dout1_29 vdout1_29ck70 = 1.95 time = 710
* CHECK dout1_30 vdout1_30ck70 = 0 time = 710
* CHECK dout1_31 vdout1_31ck70 = 1.95 time = 710
* CHECK dout0_0 vdout0_0ck74 = 0 time = 750
* CHECK dout0_1 vdout0_1ck74 = 1.95 time = 750
* CHECK dout0_2 vdout0_2ck74 = 1.95 time = 750
* CHECK dout0_3 vdout0_3ck74 = 0 time = 750
* CHECK dout0_4 vdout0_4ck74 = 1.95 time = 750
* CHECK dout0_5 vdout0_5ck74 = 1.95 time = 750
* CHECK dout0_6 vdout0_6ck74 = 0 time = 750
* CHECK dout0_7 vdout0_7ck74 = 0 time = 750
* CHECK dout0_8 vdout0_8ck74 = 0 time = 750
* CHECK dout0_9 vdout0_9ck74 = 0 time = 750
* CHECK dout0_10 vdout0_10ck74 = 0 time = 750
* CHECK dout0_11 vdout0_11ck74 = 1.95 time = 750
* CHECK dout0_12 vdout0_12ck74 = 0 time = 750
* CHECK dout0_13 vdout0_13ck74 = 1.95 time = 750
* CHECK dout0_14 vdout0_14ck74 = 0 time = 750
* CHECK dout0_15 vdout0_15ck74 = 0 time = 750
* CHECK dout0_16 vdout0_16ck74 = 1.95 time = 750
* CHECK dout0_17 vdout0_17ck74 = 0 time = 750
* CHECK dout0_18 vdout0_18ck74 = 1.95 time = 750
* CHECK dout0_19 vdout0_19ck74 = 1.95 time = 750
* CHECK dout0_20 vdout0_20ck74 = 1.95 time = 750
* CHECK dout0_21 vdout0_21ck74 = 1.95 time = 750
* CHECK dout0_22 vdout0_22ck74 = 0 time = 750
* CHECK dout0_23 vdout0_23ck74 = 1.95 time = 750
* CHECK dout0_24 vdout0_24ck74 = 1.95 time = 750
* CHECK dout0_25 vdout0_25ck74 = 0 time = 750
* CHECK dout0_26 vdout0_26ck74 = 1.95 time = 750
* CHECK dout0_27 vdout0_27ck74 = 0 time = 750
* CHECK dout0_28 vdout0_28ck74 = 0 time = 750
* CHECK dout0_29 vdout0_29ck74 = 1.95 time = 750
* CHECK dout0_30 vdout0_30ck74 = 1.95 time = 750
* CHECK dout0_31 vdout0_31ck74 = 1.95 time = 750
* CHECK dout1_0 vdout1_0ck74 = 0 time = 750
* CHECK dout1_1 vdout1_1ck74 = 0 time = 750
* CHECK dout1_2 vdout1_2ck74 = 1.95 time = 750
* CHECK dout1_3 vdout1_3ck74 = 0 time = 750
* CHECK dout1_4 vdout1_4ck74 = 1.95 time = 750
* CHECK dout1_5 vdout1_5ck74 = 0 time = 750
* CHECK dout1_6 vdout1_6ck74 = 0 time = 750
* CHECK dout1_7 vdout1_7ck74 = 1.95 time = 750
* CHECK dout1_8 vdout1_8ck74 = 0 time = 750
* CHECK dout1_9 vdout1_9ck74 = 1.95 time = 750
* CHECK dout1_10 vdout1_10ck74 = 0 time = 750
* CHECK dout1_11 vdout1_11ck74 = 1.95 time = 750
* CHECK dout1_12 vdout1_12ck74 = 0 time = 750
* CHECK dout1_13 vdout1_13ck74 = 1.95 time = 750
* CHECK dout1_14 vdout1_14ck74 = 1.95 time = 750
* CHECK dout1_15 vdout1_15ck74 = 0 time = 750
* CHECK dout1_16 vdout1_16ck74 = 0 time = 750
* CHECK dout1_17 vdout1_17ck74 = 0 time = 750
* CHECK dout1_18 vdout1_18ck74 = 0 time = 750
* CHECK dout1_19 vdout1_19ck74 = 1.95 time = 750
* CHECK dout1_20 vdout1_20ck74 = 1.95 time = 750
* CHECK dout1_21 vdout1_21ck74 = 1.95 time = 750
* CHECK dout1_22 vdout1_22ck74 = 1.95 time = 750
* CHECK dout1_23 vdout1_23ck74 = 0 time = 750
* CHECK dout1_24 vdout1_24ck74 = 1.95 time = 750
* CHECK dout1_25 vdout1_25ck74 = 1.95 time = 750
* CHECK dout1_26 vdout1_26ck74 = 0 time = 750
* CHECK dout1_27 vdout1_27ck74 = 0 time = 750
* CHECK dout1_28 vdout1_28ck74 = 1.95 time = 750
* CHECK dout1_29 vdout1_29ck74 = 0 time = 750
* CHECK dout1_30 vdout1_30ck74 = 0 time = 750
* CHECK dout1_31 vdout1_31ck74 = 0 time = 750
* CHECK dout0_0 vdout0_0ck76 = 0 time = 770
* CHECK dout0_1 vdout0_1ck76 = 1.95 time = 770
* CHECK dout0_2 vdout0_2ck76 = 1.95 time = 770
* CHECK dout0_3 vdout0_3ck76 = 0 time = 770
* CHECK dout0_4 vdout0_4ck76 = 1.95 time = 770
* CHECK dout0_5 vdout0_5ck76 = 1.95 time = 770
* CHECK dout0_6 vdout0_6ck76 = 0 time = 770
* CHECK dout0_7 vdout0_7ck76 = 0 time = 770
* CHECK dout0_8 vdout0_8ck76 = 0 time = 770
* CHECK dout0_9 vdout0_9ck76 = 0 time = 770
* CHECK dout0_10 vdout0_10ck76 = 0 time = 770
* CHECK dout0_11 vdout0_11ck76 = 1.95 time = 770
* CHECK dout0_12 vdout0_12ck76 = 0 time = 770
* CHECK dout0_13 vdout0_13ck76 = 1.95 time = 770
* CHECK dout0_14 vdout0_14ck76 = 0 time = 770
* CHECK dout0_15 vdout0_15ck76 = 0 time = 770
* CHECK dout0_16 vdout0_16ck76 = 1.95 time = 770
* CHECK dout0_17 vdout0_17ck76 = 0 time = 770
* CHECK dout0_18 vdout0_18ck76 = 1.95 time = 770
* CHECK dout0_19 vdout0_19ck76 = 1.95 time = 770
* CHECK dout0_20 vdout0_20ck76 = 1.95 time = 770
* CHECK dout0_21 vdout0_21ck76 = 1.95 time = 770
* CHECK dout0_22 vdout0_22ck76 = 0 time = 770
* CHECK dout0_23 vdout0_23ck76 = 1.95 time = 770
* CHECK dout0_24 vdout0_24ck76 = 1.95 time = 770
* CHECK dout0_25 vdout0_25ck76 = 0 time = 770
* CHECK dout0_26 vdout0_26ck76 = 1.95 time = 770
* CHECK dout0_27 vdout0_27ck76 = 0 time = 770
* CHECK dout0_28 vdout0_28ck76 = 0 time = 770
* CHECK dout0_29 vdout0_29ck76 = 1.95 time = 770
* CHECK dout0_30 vdout0_30ck76 = 1.95 time = 770
* CHECK dout0_31 vdout0_31ck76 = 1.95 time = 770
* CHECK dout1_0 vdout1_0ck78 = 0 time = 790
* CHECK dout1_1 vdout1_1ck78 = 1.95 time = 790
* CHECK dout1_2 vdout1_2ck78 = 0 time = 790
* CHECK dout1_3 vdout1_3ck78 = 0 time = 790
* CHECK dout1_4 vdout1_4ck78 = 0 time = 790
* CHECK dout1_5 vdout1_5ck78 = 0 time = 790
* CHECK dout1_6 vdout1_6ck78 = 0 time = 790
* CHECK dout1_7 vdout1_7ck78 = 0 time = 790
* CHECK dout1_8 vdout1_8ck78 = 0 time = 790
* CHECK dout1_9 vdout1_9ck78 = 1.95 time = 790
* CHECK dout1_10 vdout1_10ck78 = 0 time = 790
* CHECK dout1_11 vdout1_11ck78 = 1.95 time = 790
* CHECK dout1_12 vdout1_12ck78 = 1.95 time = 790
* CHECK dout1_13 vdout1_13ck78 = 1.95 time = 790
* CHECK dout1_14 vdout1_14ck78 = 0 time = 790
* CHECK dout1_15 vdout1_15ck78 = 0 time = 790
* CHECK dout1_16 vdout1_16ck78 = 1.95 time = 790
* CHECK dout1_17 vdout1_17ck78 = 0 time = 790
* CHECK dout1_18 vdout1_18ck78 = 0 time = 790
* CHECK dout1_19 vdout1_19ck78 = 1.95 time = 790
* CHECK dout1_20 vdout1_20ck78 = 1.95 time = 790
* CHECK dout1_21 vdout1_21ck78 = 1.95 time = 790
* CHECK dout1_22 vdout1_22ck78 = 1.95 time = 790
* CHECK dout1_23 vdout1_23ck78 = 0 time = 790
* CHECK dout1_24 vdout1_24ck78 = 1.95 time = 790
* CHECK dout1_25 vdout1_25ck78 = 0 time = 790
* CHECK dout1_26 vdout1_26ck78 = 1.95 time = 790
* CHECK dout1_27 vdout1_27ck78 = 0 time = 790
* CHECK dout1_28 vdout1_28ck78 = 1.95 time = 790
* CHECK dout1_29 vdout1_29ck78 = 1.95 time = 790
* CHECK dout1_30 vdout1_30ck78 = 0 time = 790
* CHECK dout1_31 vdout1_31ck78 = 1.95 time = 790
* CHECK dout0_0 vdout0_0ck82 = 0 time = 830
* CHECK dout0_1 vdout0_1ck82 = 0 time = 830
* CHECK dout0_2 vdout0_2ck82 = 0 time = 830
* CHECK dout0_3 vdout0_3ck82 = 1.95 time = 830
* CHECK dout0_4 vdout0_4ck82 = 0 time = 830
* CHECK dout0_5 vdout0_5ck82 = 0 time = 830
* CHECK dout0_6 vdout0_6ck82 = 0 time = 830
* CHECK dout0_7 vdout0_7ck82 = 1.95 time = 830
* CHECK dout0_8 vdout0_8ck82 = 1.95 time = 830
* CHECK dout0_9 vdout0_9ck82 = 0 time = 830
* CHECK dout0_10 vdout0_10ck82 = 1.95 time = 830
* CHECK dout0_11 vdout0_11ck82 = 1.95 time = 830
* CHECK dout0_12 vdout0_12ck82 = 1.95 time = 830
* CHECK dout0_13 vdout0_13ck82 = 1.95 time = 830
* CHECK dout0_14 vdout0_14ck82 = 1.95 time = 830
* CHECK dout0_15 vdout0_15ck82 = 1.95 time = 830
* CHECK dout0_16 vdout0_16ck82 = 1.95 time = 830
* CHECK dout0_17 vdout0_17ck82 = 1.95 time = 830
* CHECK dout0_18 vdout0_18ck82 = 1.95 time = 830
* CHECK dout0_19 vdout0_19ck82 = 1.95 time = 830
* CHECK dout0_20 vdout0_20ck82 = 0 time = 830
* CHECK dout0_21 vdout0_21ck82 = 0 time = 830
* CHECK dout0_22 vdout0_22ck82 = 0 time = 830
* CHECK dout0_23 vdout0_23ck82 = 0 time = 830
* CHECK dout0_24 vdout0_24ck82 = 1.95 time = 830
* CHECK dout0_25 vdout0_25ck82 = 1.95 time = 830
* CHECK dout0_26 vdout0_26ck82 = 1.95 time = 830
* CHECK dout0_27 vdout0_27ck82 = 0 time = 830
* CHECK dout0_28 vdout0_28ck82 = 1.95 time = 830
* CHECK dout0_29 vdout0_29ck82 = 1.95 time = 830
* CHECK dout0_30 vdout0_30ck82 = 0 time = 830
* CHECK dout0_31 vdout0_31ck82 = 1.95 time = 830
* CHECK dout1_0 vdout1_0ck82 = 0 time = 830
* CHECK dout1_1 vdout1_1ck82 = 0 time = 830
* CHECK dout1_2 vdout1_2ck82 = 0 time = 830
* CHECK dout1_3 vdout1_3ck82 = 1.95 time = 830
* CHECK dout1_4 vdout1_4ck82 = 0 time = 830
* CHECK dout1_5 vdout1_5ck82 = 0 time = 830
* CHECK dout1_6 vdout1_6ck82 = 0 time = 830
* CHECK dout1_7 vdout1_7ck82 = 1.95 time = 830
* CHECK dout1_8 vdout1_8ck82 = 1.95 time = 830
* CHECK dout1_9 vdout1_9ck82 = 0 time = 830
* CHECK dout1_10 vdout1_10ck82 = 1.95 time = 830
* CHECK dout1_11 vdout1_11ck82 = 1.95 time = 830
* CHECK dout1_12 vdout1_12ck82 = 1.95 time = 830
* CHECK dout1_13 vdout1_13ck82 = 1.95 time = 830
* CHECK dout1_14 vdout1_14ck82 = 1.95 time = 830
* CHECK dout1_15 vdout1_15ck82 = 1.95 time = 830
* CHECK dout1_16 vdout1_16ck82 = 1.95 time = 830
* CHECK dout1_17 vdout1_17ck82 = 1.95 time = 830
* CHECK dout1_18 vdout1_18ck82 = 1.95 time = 830
* CHECK dout1_19 vdout1_19ck82 = 1.95 time = 830
* CHECK dout1_20 vdout1_20ck82 = 0 time = 830
* CHECK dout1_21 vdout1_21ck82 = 0 time = 830
* CHECK dout1_22 vdout1_22ck82 = 0 time = 830
* CHECK dout1_23 vdout1_23ck82 = 0 time = 830
* CHECK dout1_24 vdout1_24ck82 = 1.95 time = 830
* CHECK dout1_25 vdout1_25ck82 = 1.95 time = 830
* CHECK dout1_26 vdout1_26ck82 = 1.95 time = 830
* CHECK dout1_27 vdout1_27ck82 = 0 time = 830
* CHECK dout1_28 vdout1_28ck82 = 1.95 time = 830
* CHECK dout1_29 vdout1_29ck82 = 1.95 time = 830
* CHECK dout1_30 vdout1_30ck82 = 0 time = 830
* CHECK dout1_31 vdout1_31ck82 = 1.95 time = 830
* CHECK dout1_0 vdout1_0ck83 = 0 time = 840
* CHECK dout1_1 vdout1_1ck83 = 0 time = 840
* CHECK dout1_2 vdout1_2ck83 = 0 time = 840
* CHECK dout1_3 vdout1_3ck83 = 1.95 time = 840
* CHECK dout1_4 vdout1_4ck83 = 0 time = 840
* CHECK dout1_5 vdout1_5ck83 = 0 time = 840
* CHECK dout1_6 vdout1_6ck83 = 0 time = 840
* CHECK dout1_7 vdout1_7ck83 = 1.95 time = 840
* CHECK dout1_8 vdout1_8ck83 = 1.95 time = 840
* CHECK dout1_9 vdout1_9ck83 = 0 time = 840
* CHECK dout1_10 vdout1_10ck83 = 1.95 time = 840
* CHECK dout1_11 vdout1_11ck83 = 1.95 time = 840
* CHECK dout1_12 vdout1_12ck83 = 1.95 time = 840
* CHECK dout1_13 vdout1_13ck83 = 1.95 time = 840
* CHECK dout1_14 vdout1_14ck83 = 1.95 time = 840
* CHECK dout1_15 vdout1_15ck83 = 1.95 time = 840
* CHECK dout1_16 vdout1_16ck83 = 1.95 time = 840
* CHECK dout1_17 vdout1_17ck83 = 1.95 time = 840
* CHECK dout1_18 vdout1_18ck83 = 1.95 time = 840
* CHECK dout1_19 vdout1_19ck83 = 1.95 time = 840
* CHECK dout1_20 vdout1_20ck83 = 0 time = 840
* CHECK dout1_21 vdout1_21ck83 = 0 time = 840
* CHECK dout1_22 vdout1_22ck83 = 0 time = 840
* CHECK dout1_23 vdout1_23ck83 = 0 time = 840
* CHECK dout1_24 vdout1_24ck83 = 1.95 time = 840
* CHECK dout1_25 vdout1_25ck83 = 1.95 time = 840
* CHECK dout1_26 vdout1_26ck83 = 1.95 time = 840
* CHECK dout1_27 vdout1_27ck83 = 0 time = 840
* CHECK dout1_28 vdout1_28ck83 = 1.95 time = 840
* CHECK dout1_29 vdout1_29ck83 = 1.95 time = 840
* CHECK dout1_30 vdout1_30ck83 = 0 time = 840
* CHECK dout1_31 vdout1_31ck83 = 1.95 time = 840
* CHECK dout1_0 vdout1_0ck85 = 0 time = 860
* CHECK dout1_1 vdout1_1ck85 = 0 time = 860
* CHECK dout1_2 vdout1_2ck85 = 1.95 time = 860
* CHECK dout1_3 vdout1_3ck85 = 0 time = 860
* CHECK dout1_4 vdout1_4ck85 = 1.95 time = 860
* CHECK dout1_5 vdout1_5ck85 = 0 time = 860
* CHECK dout1_6 vdout1_6ck85 = 0 time = 860
* CHECK dout1_7 vdout1_7ck85 = 1.95 time = 860
* CHECK dout1_8 vdout1_8ck85 = 0 time = 860
* CHECK dout1_9 vdout1_9ck85 = 1.95 time = 860
* CHECK dout1_10 vdout1_10ck85 = 0 time = 860
* CHECK dout1_11 vdout1_11ck85 = 1.95 time = 860
* CHECK dout1_12 vdout1_12ck85 = 0 time = 860
* CHECK dout1_13 vdout1_13ck85 = 1.95 time = 860
* CHECK dout1_14 vdout1_14ck85 = 1.95 time = 860
* CHECK dout1_15 vdout1_15ck85 = 0 time = 860
* CHECK dout1_16 vdout1_16ck85 = 0 time = 860
* CHECK dout1_17 vdout1_17ck85 = 0 time = 860
* CHECK dout1_18 vdout1_18ck85 = 0 time = 860
* CHECK dout1_19 vdout1_19ck85 = 1.95 time = 860
* CHECK dout1_20 vdout1_20ck85 = 1.95 time = 860
* CHECK dout1_21 vdout1_21ck85 = 1.95 time = 860
* CHECK dout1_22 vdout1_22ck85 = 1.95 time = 860
* CHECK dout1_23 vdout1_23ck85 = 0 time = 860
* CHECK dout1_24 vdout1_24ck85 = 1.95 time = 860
* CHECK dout1_25 vdout1_25ck85 = 1.95 time = 860
* CHECK dout1_26 vdout1_26ck85 = 0 time = 860
* CHECK dout1_27 vdout1_27ck85 = 0 time = 860
* CHECK dout1_28 vdout1_28ck85 = 1.95 time = 860
* CHECK dout1_29 vdout1_29ck85 = 0 time = 860
* CHECK dout1_30 vdout1_30ck85 = 0 time = 860
* CHECK dout1_31 vdout1_31ck85 = 0 time = 860
* CHECK dout0_0 vdout0_0ck86 = 0 time = 870
* CHECK dout0_1 vdout0_1ck86 = 0 time = 870
* CHECK dout0_2 vdout0_2ck86 = 1.95 time = 870
* CHECK dout0_3 vdout0_3ck86 = 0 time = 870
* CHECK dout0_4 vdout0_4ck86 = 1.95 time = 870
* CHECK dout0_5 vdout0_5ck86 = 0 time = 870
* CHECK dout0_6 vdout0_6ck86 = 0 time = 870
* CHECK dout0_7 vdout0_7ck86 = 1.95 time = 870
* CHECK dout0_8 vdout0_8ck86 = 0 time = 870
* CHECK dout0_9 vdout0_9ck86 = 1.95 time = 870
* CHECK dout0_10 vdout0_10ck86 = 0 time = 870
* CHECK dout0_11 vdout0_11ck86 = 1.95 time = 870
* CHECK dout0_12 vdout0_12ck86 = 0 time = 870
* CHECK dout0_13 vdout0_13ck86 = 1.95 time = 870
* CHECK dout0_14 vdout0_14ck86 = 1.95 time = 870
* CHECK dout0_15 vdout0_15ck86 = 0 time = 870
* CHECK dout0_16 vdout0_16ck86 = 0 time = 870
* CHECK dout0_17 vdout0_17ck86 = 0 time = 870
* CHECK dout0_18 vdout0_18ck86 = 0 time = 870
* CHECK dout0_19 vdout0_19ck86 = 1.95 time = 870
* CHECK dout0_20 vdout0_20ck86 = 1.95 time = 870
* CHECK dout0_21 vdout0_21ck86 = 1.95 time = 870
* CHECK dout0_22 vdout0_22ck86 = 1.95 time = 870
* CHECK dout0_23 vdout0_23ck86 = 0 time = 870
* CHECK dout0_24 vdout0_24ck86 = 1.95 time = 870
* CHECK dout0_25 vdout0_25ck86 = 1.95 time = 870
* CHECK dout0_26 vdout0_26ck86 = 0 time = 870
* CHECK dout0_27 vdout0_27ck86 = 0 time = 870
* CHECK dout0_28 vdout0_28ck86 = 1.95 time = 870
* CHECK dout0_29 vdout0_29ck86 = 0 time = 870
* CHECK dout0_30 vdout0_30ck86 = 0 time = 870
* CHECK dout0_31 vdout0_31ck86 = 0 time = 870
* CHECK dout1_0 vdout1_0ck86 = 0 time = 870
* CHECK dout1_1 vdout1_1ck86 = 0 time = 870
* CHECK dout1_2 vdout1_2ck86 = 1.95 time = 870
* CHECK dout1_3 vdout1_3ck86 = 0 time = 870
* CHECK dout1_4 vdout1_4ck86 = 1.95 time = 870
* CHECK dout1_5 vdout1_5ck86 = 0 time = 870
* CHECK dout1_6 vdout1_6ck86 = 0 time = 870
* CHECK dout1_7 vdout1_7ck86 = 1.95 time = 870
* CHECK dout1_8 vdout1_8ck86 = 0 time = 870
* CHECK dout1_9 vdout1_9ck86 = 1.95 time = 870
* CHECK dout1_10 vdout1_10ck86 = 0 time = 870
* CHECK dout1_11 vdout1_11ck86 = 1.95 time = 870
* CHECK dout1_12 vdout1_12ck86 = 0 time = 870
* CHECK dout1_13 vdout1_13ck86 = 1.95 time = 870
* CHECK dout1_14 vdout1_14ck86 = 1.95 time = 870
* CHECK dout1_15 vdout1_15ck86 = 0 time = 870
* CHECK dout1_16 vdout1_16ck86 = 0 time = 870
* CHECK dout1_17 vdout1_17ck86 = 0 time = 870
* CHECK dout1_18 vdout1_18ck86 = 0 time = 870
* CHECK dout1_19 vdout1_19ck86 = 1.95 time = 870
* CHECK dout1_20 vdout1_20ck86 = 1.95 time = 870
* CHECK dout1_21 vdout1_21ck86 = 1.95 time = 870
* CHECK dout1_22 vdout1_22ck86 = 1.95 time = 870
* CHECK dout1_23 vdout1_23ck86 = 0 time = 870
* CHECK dout1_24 vdout1_24ck86 = 1.95 time = 870
* CHECK dout1_25 vdout1_25ck86 = 1.95 time = 870
* CHECK dout1_26 vdout1_26ck86 = 0 time = 870
* CHECK dout1_27 vdout1_27ck86 = 0 time = 870
* CHECK dout1_28 vdout1_28ck86 = 1.95 time = 870
* CHECK dout1_29 vdout1_29ck86 = 0 time = 870
* CHECK dout1_30 vdout1_30ck86 = 0 time = 870
* CHECK dout1_31 vdout1_31ck86 = 0 time = 870
* CHECK dout1_0 vdout1_0ck87 = 0 time = 880
* CHECK dout1_1 vdout1_1ck87 = 0 time = 880
* CHECK dout1_2 vdout1_2ck87 = 0 time = 880
* CHECK dout1_3 vdout1_3ck87 = 1.95 time = 880
* CHECK dout1_4 vdout1_4ck87 = 1.95 time = 880
* CHECK dout1_5 vdout1_5ck87 = 0 time = 880
* CHECK dout1_6 vdout1_6ck87 = 1.95 time = 880
* CHECK dout1_7 vdout1_7ck87 = 1.95 time = 880
* CHECK dout1_8 vdout1_8ck87 = 0 time = 880
* CHECK dout1_9 vdout1_9ck87 = 1.95 time = 880
* CHECK dout1_10 vdout1_10ck87 = 1.95 time = 880
* CHECK dout1_11 vdout1_11ck87 = 1.95 time = 880
* CHECK dout1_12 vdout1_12ck87 = 0 time = 880
* CHECK dout1_13 vdout1_13ck87 = 0 time = 880
* CHECK dout1_14 vdout1_14ck87 = 1.95 time = 880
* CHECK dout1_15 vdout1_15ck87 = 1.95 time = 880
* CHECK dout1_16 vdout1_16ck87 = 0 time = 880
* CHECK dout1_17 vdout1_17ck87 = 1.95 time = 880
* CHECK dout1_18 vdout1_18ck87 = 0 time = 880
* CHECK dout1_19 vdout1_19ck87 = 0 time = 880
* CHECK dout1_20 vdout1_20ck87 = 0 time = 880
* CHECK dout1_21 vdout1_21ck87 = 0 time = 880
* CHECK dout1_22 vdout1_22ck87 = 0 time = 880
* CHECK dout1_23 vdout1_23ck87 = 0 time = 880
* CHECK dout1_24 vdout1_24ck87 = 0 time = 880
* CHECK dout1_25 vdout1_25ck87 = 1.95 time = 880
* CHECK dout1_26 vdout1_26ck87 = 1.95 time = 880
* CHECK dout1_27 vdout1_27ck87 = 0 time = 880
* CHECK dout1_28 vdout1_28ck87 = 1.95 time = 880
* CHECK dout1_29 vdout1_29ck87 = 0 time = 880
* CHECK dout1_30 vdout1_30ck87 = 1.95 time = 880
* CHECK dout1_31 vdout1_31ck87 = 1.95 time = 880
* CHECK dout0_0 vdout0_0ck88 = 0 time = 890
* CHECK dout0_1 vdout0_1ck88 = 1.95 time = 890
* CHECK dout0_2 vdout0_2ck88 = 0 time = 890
* CHECK dout0_3 vdout0_3ck88 = 0 time = 890
* CHECK dout0_4 vdout0_4ck88 = 0 time = 890
* CHECK dout0_5 vdout0_5ck88 = 0 time = 890
* CHECK dout0_6 vdout0_6ck88 = 0 time = 890
* CHECK dout0_7 vdout0_7ck88 = 0 time = 890
* CHECK dout0_8 vdout0_8ck88 = 1.95 time = 890
* CHECK dout0_9 vdout0_9ck88 = 0 time = 890
* CHECK dout0_10 vdout0_10ck88 = 1.95 time = 890
* CHECK dout0_11 vdout0_11ck88 = 1.95 time = 890
* CHECK dout0_12 vdout0_12ck88 = 0 time = 890
* CHECK dout0_13 vdout0_13ck88 = 0 time = 890
* CHECK dout0_14 vdout0_14ck88 = 1.95 time = 890
* CHECK dout0_15 vdout0_15ck88 = 1.95 time = 890
* CHECK dout0_16 vdout0_16ck88 = 1.95 time = 890
* CHECK dout0_17 vdout0_17ck88 = 0 time = 890
* CHECK dout0_18 vdout0_18ck88 = 0 time = 890
* CHECK dout0_19 vdout0_19ck88 = 1.95 time = 890
* CHECK dout0_20 vdout0_20ck88 = 1.95 time = 890
* CHECK dout0_21 vdout0_21ck88 = 1.95 time = 890
* CHECK dout0_22 vdout0_22ck88 = 1.95 time = 890
* CHECK dout0_23 vdout0_23ck88 = 0 time = 890
* CHECK dout0_24 vdout0_24ck88 = 0 time = 890
* CHECK dout0_25 vdout0_25ck88 = 1.95 time = 890
* CHECK dout0_26 vdout0_26ck88 = 0 time = 890
* CHECK dout0_27 vdout0_27ck88 = 0 time = 890
* CHECK dout0_28 vdout0_28ck88 = 0 time = 890
* CHECK dout0_29 vdout0_29ck88 = 1.95 time = 890
* CHECK dout0_30 vdout0_30ck88 = 1.95 time = 890
* CHECK dout0_31 vdout0_31ck88 = 0 time = 890
* CHECK dout1_0 vdout1_0ck88 = 0 time = 890
* CHECK dout1_1 vdout1_1ck88 = 1.95 time = 890
* CHECK dout1_2 vdout1_2ck88 = 0 time = 890
* CHECK dout1_3 vdout1_3ck88 = 0 time = 890
* CHECK dout1_4 vdout1_4ck88 = 0 time = 890
* CHECK dout1_5 vdout1_5ck88 = 0 time = 890
* CHECK dout1_6 vdout1_6ck88 = 0 time = 890
* CHECK dout1_7 vdout1_7ck88 = 0 time = 890
* CHECK dout1_8 vdout1_8ck88 = 1.95 time = 890
* CHECK dout1_9 vdout1_9ck88 = 0 time = 890
* CHECK dout1_10 vdout1_10ck88 = 1.95 time = 890
* CHECK dout1_11 vdout1_11ck88 = 1.95 time = 890
* CHECK dout1_12 vdout1_12ck88 = 0 time = 890
* CHECK dout1_13 vdout1_13ck88 = 0 time = 890
* CHECK dout1_14 vdout1_14ck88 = 1.95 time = 890
* CHECK dout1_15 vdout1_15ck88 = 1.95 time = 890
* CHECK dout1_16 vdout1_16ck88 = 1.95 time = 890
* CHECK dout1_17 vdout1_17ck88 = 0 time = 890
* CHECK dout1_18 vdout1_18ck88 = 0 time = 890
* CHECK dout1_19 vdout1_19ck88 = 1.95 time = 890
* CHECK dout1_20 vdout1_20ck88 = 1.95 time = 890
* CHECK dout1_21 vdout1_21ck88 = 1.95 time = 890
* CHECK dout1_22 vdout1_22ck88 = 1.95 time = 890
* CHECK dout1_23 vdout1_23ck88 = 0 time = 890
* CHECK dout1_24 vdout1_24ck88 = 0 time = 890
* CHECK dout1_25 vdout1_25ck88 = 1.95 time = 890
* CHECK dout1_26 vdout1_26ck88 = 0 time = 890
* CHECK dout1_27 vdout1_27ck88 = 0 time = 890
* CHECK dout1_28 vdout1_28ck88 = 0 time = 890
* CHECK dout1_29 vdout1_29ck88 = 1.95 time = 890
* CHECK dout1_30 vdout1_30ck88 = 1.95 time = 890
* CHECK dout1_31 vdout1_31ck88 = 0 time = 890
* CHECK dout0_0 vdout0_0ck89 = 0 time = 900
* CHECK dout0_1 vdout0_1ck89 = 0 time = 900
* CHECK dout0_2 vdout0_2ck89 = 1.95 time = 900
* CHECK dout0_3 vdout0_3ck89 = 0 time = 900
* CHECK dout0_4 vdout0_4ck89 = 1.95 time = 900
* CHECK dout0_5 vdout0_5ck89 = 0 time = 900
* CHECK dout0_6 vdout0_6ck89 = 0 time = 900
* CHECK dout0_7 vdout0_7ck89 = 1.95 time = 900
* CHECK dout0_8 vdout0_8ck89 = 0 time = 900
* CHECK dout0_9 vdout0_9ck89 = 1.95 time = 900
* CHECK dout0_10 vdout0_10ck89 = 0 time = 900
* CHECK dout0_11 vdout0_11ck89 = 1.95 time = 900
* CHECK dout0_12 vdout0_12ck89 = 0 time = 900
* CHECK dout0_13 vdout0_13ck89 = 1.95 time = 900
* CHECK dout0_14 vdout0_14ck89 = 1.95 time = 900
* CHECK dout0_15 vdout0_15ck89 = 0 time = 900
* CHECK dout0_16 vdout0_16ck89 = 0 time = 900
* CHECK dout0_17 vdout0_17ck89 = 0 time = 900
* CHECK dout0_18 vdout0_18ck89 = 0 time = 900
* CHECK dout0_19 vdout0_19ck89 = 1.95 time = 900
* CHECK dout0_20 vdout0_20ck89 = 1.95 time = 900
* CHECK dout0_21 vdout0_21ck89 = 1.95 time = 900
* CHECK dout0_22 vdout0_22ck89 = 1.95 time = 900
* CHECK dout0_23 vdout0_23ck89 = 0 time = 900
* CHECK dout0_24 vdout0_24ck89 = 1.95 time = 900
* CHECK dout0_25 vdout0_25ck89 = 1.95 time = 900
* CHECK dout0_26 vdout0_26ck89 = 0 time = 900
* CHECK dout0_27 vdout0_27ck89 = 0 time = 900
* CHECK dout0_28 vdout0_28ck89 = 1.95 time = 900
* CHECK dout0_29 vdout0_29ck89 = 0 time = 900
* CHECK dout0_30 vdout0_30ck89 = 0 time = 900
* CHECK dout0_31 vdout0_31ck89 = 0 time = 900
* CHECK dout1_0 vdout1_0ck89 = 0 time = 900
* CHECK dout1_1 vdout1_1ck89 = 1.95 time = 900
* CHECK dout1_2 vdout1_2ck89 = 0 time = 900
* CHECK dout1_3 vdout1_3ck89 = 0 time = 900
* CHECK dout1_4 vdout1_4ck89 = 0 time = 900
* CHECK dout1_5 vdout1_5ck89 = 0 time = 900
* CHECK dout1_6 vdout1_6ck89 = 0 time = 900
* CHECK dout1_7 vdout1_7ck89 = 0 time = 900
* CHECK dout1_8 vdout1_8ck89 = 1.95 time = 900
* CHECK dout1_9 vdout1_9ck89 = 0 time = 900
* CHECK dout1_10 vdout1_10ck89 = 1.95 time = 900
* CHECK dout1_11 vdout1_11ck89 = 1.95 time = 900
* CHECK dout1_12 vdout1_12ck89 = 0 time = 900
* CHECK dout1_13 vdout1_13ck89 = 0 time = 900
* CHECK dout1_14 vdout1_14ck89 = 1.95 time = 900
* CHECK dout1_15 vdout1_15ck89 = 1.95 time = 900
* CHECK dout1_16 vdout1_16ck89 = 1.95 time = 900
* CHECK dout1_17 vdout1_17ck89 = 0 time = 900
* CHECK dout1_18 vdout1_18ck89 = 0 time = 900
* CHECK dout1_19 vdout1_19ck89 = 1.95 time = 900
* CHECK dout1_20 vdout1_20ck89 = 1.95 time = 900
* CHECK dout1_21 vdout1_21ck89 = 1.95 time = 900
* CHECK dout1_22 vdout1_22ck89 = 1.95 time = 900
* CHECK dout1_23 vdout1_23ck89 = 0 time = 900
* CHECK dout1_24 vdout1_24ck89 = 0 time = 900
* CHECK dout1_25 vdout1_25ck89 = 1.95 time = 900
* CHECK dout1_26 vdout1_26ck89 = 0 time = 900
* CHECK dout1_27 vdout1_27ck89 = 0 time = 900
* CHECK dout1_28 vdout1_28ck89 = 0 time = 900
* CHECK dout1_29 vdout1_29ck89 = 1.95 time = 900
* CHECK dout1_30 vdout1_30ck89 = 1.95 time = 900
* CHECK dout1_31 vdout1_31ck89 = 0 time = 900
* CHECK dout0_0 vdout0_0ck90 = 0 time = 910
* CHECK dout0_1 vdout0_1ck90 = 0 time = 910
* CHECK dout0_2 vdout0_2ck90 = 1.95 time = 910
* CHECK dout0_3 vdout0_3ck90 = 0 time = 910
* CHECK dout0_4 vdout0_4ck90 = 1.95 time = 910
* CHECK dout0_5 vdout0_5ck90 = 0 time = 910
* CHECK dout0_6 vdout0_6ck90 = 0 time = 910
* CHECK dout0_7 vdout0_7ck90 = 1.95 time = 910
* CHECK dout0_8 vdout0_8ck90 = 0 time = 910
* CHECK dout0_9 vdout0_9ck90 = 1.95 time = 910
* CHECK dout0_10 vdout0_10ck90 = 0 time = 910
* CHECK dout0_11 vdout0_11ck90 = 1.95 time = 910
* CHECK dout0_12 vdout0_12ck90 = 0 time = 910
* CHECK dout0_13 vdout0_13ck90 = 1.95 time = 910
* CHECK dout0_14 vdout0_14ck90 = 1.95 time = 910
* CHECK dout0_15 vdout0_15ck90 = 0 time = 910
* CHECK dout0_16 vdout0_16ck90 = 0 time = 910
* CHECK dout0_17 vdout0_17ck90 = 0 time = 910
* CHECK dout0_18 vdout0_18ck90 = 0 time = 910
* CHECK dout0_19 vdout0_19ck90 = 1.95 time = 910
* CHECK dout0_20 vdout0_20ck90 = 1.95 time = 910
* CHECK dout0_21 vdout0_21ck90 = 1.95 time = 910
* CHECK dout0_22 vdout0_22ck90 = 1.95 time = 910
* CHECK dout0_23 vdout0_23ck90 = 0 time = 910
* CHECK dout0_24 vdout0_24ck90 = 1.95 time = 910
* CHECK dout0_25 vdout0_25ck90 = 1.95 time = 910
* CHECK dout0_26 vdout0_26ck90 = 0 time = 910
* CHECK dout0_27 vdout0_27ck90 = 0 time = 910
* CHECK dout0_28 vdout0_28ck90 = 1.95 time = 910
* CHECK dout0_29 vdout0_29ck90 = 0 time = 910
* CHECK dout0_30 vdout0_30ck90 = 0 time = 910
* CHECK dout0_31 vdout0_31ck90 = 0 time = 910
* CHECK dout1_0 vdout1_0ck90 = 0 time = 910
* CHECK dout1_1 vdout1_1ck90 = 0 time = 910
* CHECK dout1_2 vdout1_2ck90 = 1.95 time = 910
* CHECK dout1_3 vdout1_3ck90 = 0 time = 910
* CHECK dout1_4 vdout1_4ck90 = 1.95 time = 910
* CHECK dout1_5 vdout1_5ck90 = 0 time = 910
* CHECK dout1_6 vdout1_6ck90 = 0 time = 910
* CHECK dout1_7 vdout1_7ck90 = 1.95 time = 910
* CHECK dout1_8 vdout1_8ck90 = 0 time = 910
* CHECK dout1_9 vdout1_9ck90 = 1.95 time = 910
* CHECK dout1_10 vdout1_10ck90 = 0 time = 910
* CHECK dout1_11 vdout1_11ck90 = 1.95 time = 910
* CHECK dout1_12 vdout1_12ck90 = 0 time = 910
* CHECK dout1_13 vdout1_13ck90 = 1.95 time = 910
* CHECK dout1_14 vdout1_14ck90 = 1.95 time = 910
* CHECK dout1_15 vdout1_15ck90 = 0 time = 910
* CHECK dout1_16 vdout1_16ck90 = 0 time = 910
* CHECK dout1_17 vdout1_17ck90 = 0 time = 910
* CHECK dout1_18 vdout1_18ck90 = 0 time = 910
* CHECK dout1_19 vdout1_19ck90 = 1.95 time = 910
* CHECK dout1_20 vdout1_20ck90 = 1.95 time = 910
* CHECK dout1_21 vdout1_21ck90 = 1.95 time = 910
* CHECK dout1_22 vdout1_22ck90 = 1.95 time = 910
* CHECK dout1_23 vdout1_23ck90 = 0 time = 910
* CHECK dout1_24 vdout1_24ck90 = 1.95 time = 910
* CHECK dout1_25 vdout1_25ck90 = 1.95 time = 910
* CHECK dout1_26 vdout1_26ck90 = 0 time = 910
* CHECK dout1_27 vdout1_27ck90 = 0 time = 910
* CHECK dout1_28 vdout1_28ck90 = 1.95 time = 910
* CHECK dout1_29 vdout1_29ck90 = 0 time = 910
* CHECK dout1_30 vdout1_30ck90 = 0 time = 910
* CHECK dout1_31 vdout1_31ck90 = 0 time = 910
* CHECK dout0_0 vdout0_0ck91 = 0 time = 920
* CHECK dout0_1 vdout0_1ck91 = 0 time = 920
* CHECK dout0_2 vdout0_2ck91 = 1.95 time = 920
* CHECK dout0_3 vdout0_3ck91 = 0 time = 920
* CHECK dout0_4 vdout0_4ck91 = 1.95 time = 920
* CHECK dout0_5 vdout0_5ck91 = 0 time = 920
* CHECK dout0_6 vdout0_6ck91 = 0 time = 920
* CHECK dout0_7 vdout0_7ck91 = 1.95 time = 920
* CHECK dout0_8 vdout0_8ck91 = 0 time = 920
* CHECK dout0_9 vdout0_9ck91 = 1.95 time = 920
* CHECK dout0_10 vdout0_10ck91 = 0 time = 920
* CHECK dout0_11 vdout0_11ck91 = 1.95 time = 920
* CHECK dout0_12 vdout0_12ck91 = 0 time = 920
* CHECK dout0_13 vdout0_13ck91 = 1.95 time = 920
* CHECK dout0_14 vdout0_14ck91 = 1.95 time = 920
* CHECK dout0_15 vdout0_15ck91 = 0 time = 920
* CHECK dout0_16 vdout0_16ck91 = 0 time = 920
* CHECK dout0_17 vdout0_17ck91 = 0 time = 920
* CHECK dout0_18 vdout0_18ck91 = 0 time = 920
* CHECK dout0_19 vdout0_19ck91 = 1.95 time = 920
* CHECK dout0_20 vdout0_20ck91 = 1.95 time = 920
* CHECK dout0_21 vdout0_21ck91 = 1.95 time = 920
* CHECK dout0_22 vdout0_22ck91 = 1.95 time = 920
* CHECK dout0_23 vdout0_23ck91 = 0 time = 920
* CHECK dout0_24 vdout0_24ck91 = 1.95 time = 920
* CHECK dout0_25 vdout0_25ck91 = 1.95 time = 920
* CHECK dout0_26 vdout0_26ck91 = 0 time = 920
* CHECK dout0_27 vdout0_27ck91 = 0 time = 920
* CHECK dout0_28 vdout0_28ck91 = 1.95 time = 920
* CHECK dout0_29 vdout0_29ck91 = 0 time = 920
* CHECK dout0_30 vdout0_30ck91 = 0 time = 920
* CHECK dout0_31 vdout0_31ck91 = 0 time = 920
* CHECK dout0_0 vdout0_0ck92 = 0 time = 930
* CHECK dout0_1 vdout0_1ck92 = 0 time = 930
* CHECK dout0_2 vdout0_2ck92 = 1.95 time = 930
* CHECK dout0_3 vdout0_3ck92 = 0 time = 930
* CHECK dout0_4 vdout0_4ck92 = 1.95 time = 930
* CHECK dout0_5 vdout0_5ck92 = 0 time = 930
* CHECK dout0_6 vdout0_6ck92 = 0 time = 930
* CHECK dout0_7 vdout0_7ck92 = 1.95 time = 930
* CHECK dout0_8 vdout0_8ck92 = 0 time = 930
* CHECK dout0_9 vdout0_9ck92 = 1.95 time = 930
* CHECK dout0_10 vdout0_10ck92 = 0 time = 930
* CHECK dout0_11 vdout0_11ck92 = 1.95 time = 930
* CHECK dout0_12 vdout0_12ck92 = 0 time = 930
* CHECK dout0_13 vdout0_13ck92 = 1.95 time = 930
* CHECK dout0_14 vdout0_14ck92 = 1.95 time = 930
* CHECK dout0_15 vdout0_15ck92 = 0 time = 930
* CHECK dout0_16 vdout0_16ck92 = 0 time = 930
* CHECK dout0_17 vdout0_17ck92 = 0 time = 930
* CHECK dout0_18 vdout0_18ck92 = 0 time = 930
* CHECK dout0_19 vdout0_19ck92 = 1.95 time = 930
* CHECK dout0_20 vdout0_20ck92 = 1.95 time = 930
* CHECK dout0_21 vdout0_21ck92 = 1.95 time = 930
* CHECK dout0_22 vdout0_22ck92 = 1.95 time = 930
* CHECK dout0_23 vdout0_23ck92 = 0 time = 930
* CHECK dout0_24 vdout0_24ck92 = 1.95 time = 930
* CHECK dout0_25 vdout0_25ck92 = 1.95 time = 930
* CHECK dout0_26 vdout0_26ck92 = 0 time = 930
* CHECK dout0_27 vdout0_27ck92 = 0 time = 930
* CHECK dout0_28 vdout0_28ck92 = 1.95 time = 930
* CHECK dout0_29 vdout0_29ck92 = 0 time = 930
* CHECK dout0_30 vdout0_30ck92 = 0 time = 930
* CHECK dout0_31 vdout0_31ck92 = 0 time = 930
* CHECK dout1_0 vdout1_0ck92 = 0 time = 930
* CHECK dout1_1 vdout1_1ck92 = 0 time = 930
* CHECK dout1_2 vdout1_2ck92 = 1.95 time = 930
* CHECK dout1_3 vdout1_3ck92 = 0 time = 930
* CHECK dout1_4 vdout1_4ck92 = 1.95 time = 930
* CHECK dout1_5 vdout1_5ck92 = 0 time = 930
* CHECK dout1_6 vdout1_6ck92 = 0 time = 930
* CHECK dout1_7 vdout1_7ck92 = 1.95 time = 930
* CHECK dout1_8 vdout1_8ck92 = 0 time = 930
* CHECK dout1_9 vdout1_9ck92 = 1.95 time = 930
* CHECK dout1_10 vdout1_10ck92 = 0 time = 930
* CHECK dout1_11 vdout1_11ck92 = 1.95 time = 930
* CHECK dout1_12 vdout1_12ck92 = 0 time = 930
* CHECK dout1_13 vdout1_13ck92 = 1.95 time = 930
* CHECK dout1_14 vdout1_14ck92 = 1.95 time = 930
* CHECK dout1_15 vdout1_15ck92 = 0 time = 930
* CHECK dout1_16 vdout1_16ck92 = 0 time = 930
* CHECK dout1_17 vdout1_17ck92 = 0 time = 930
* CHECK dout1_18 vdout1_18ck92 = 0 time = 930
* CHECK dout1_19 vdout1_19ck92 = 1.95 time = 930
* CHECK dout1_20 vdout1_20ck92 = 1.95 time = 930
* CHECK dout1_21 vdout1_21ck92 = 1.95 time = 930
* CHECK dout1_22 vdout1_22ck92 = 1.95 time = 930
* CHECK dout1_23 vdout1_23ck92 = 0 time = 930
* CHECK dout1_24 vdout1_24ck92 = 1.95 time = 930
* CHECK dout1_25 vdout1_25ck92 = 1.95 time = 930
* CHECK dout1_26 vdout1_26ck92 = 0 time = 930
* CHECK dout1_27 vdout1_27ck92 = 0 time = 930
* CHECK dout1_28 vdout1_28ck92 = 1.95 time = 930
* CHECK dout1_29 vdout1_29ck92 = 0 time = 930
* CHECK dout1_30 vdout1_30ck92 = 0 time = 930
* CHECK dout1_31 vdout1_31ck92 = 0 time = 930
* CHECK dout0_0 vdout0_0ck93 = 0 time = 940
* CHECK dout0_1 vdout0_1ck93 = 0 time = 940
* CHECK dout0_2 vdout0_2ck93 = 0 time = 940
* CHECK dout0_3 vdout0_3ck93 = 1.95 time = 940
* CHECK dout0_4 vdout0_4ck93 = 1.95 time = 940
* CHECK dout0_5 vdout0_5ck93 = 0 time = 940
* CHECK dout0_6 vdout0_6ck93 = 1.95 time = 940
* CHECK dout0_7 vdout0_7ck93 = 1.95 time = 940
* CHECK dout0_8 vdout0_8ck93 = 0 time = 940
* CHECK dout0_9 vdout0_9ck93 = 1.95 time = 940
* CHECK dout0_10 vdout0_10ck93 = 1.95 time = 940
* CHECK dout0_11 vdout0_11ck93 = 1.95 time = 940
* CHECK dout0_12 vdout0_12ck93 = 0 time = 940
* CHECK dout0_13 vdout0_13ck93 = 0 time = 940
* CHECK dout0_14 vdout0_14ck93 = 1.95 time = 940
* CHECK dout0_15 vdout0_15ck93 = 1.95 time = 940
* CHECK dout0_16 vdout0_16ck93 = 0 time = 940
* CHECK dout0_17 vdout0_17ck93 = 1.95 time = 940
* CHECK dout0_18 vdout0_18ck93 = 0 time = 940
* CHECK dout0_19 vdout0_19ck93 = 0 time = 940
* CHECK dout0_20 vdout0_20ck93 = 0 time = 940
* CHECK dout0_21 vdout0_21ck93 = 0 time = 940
* CHECK dout0_22 vdout0_22ck93 = 0 time = 940
* CHECK dout0_23 vdout0_23ck93 = 0 time = 940
* CHECK dout0_24 vdout0_24ck93 = 0 time = 940
* CHECK dout0_25 vdout0_25ck93 = 1.95 time = 940
* CHECK dout0_26 vdout0_26ck93 = 1.95 time = 940
* CHECK dout0_27 vdout0_27ck93 = 0 time = 940
* CHECK dout0_28 vdout0_28ck93 = 1.95 time = 940
* CHECK dout0_29 vdout0_29ck93 = 0 time = 940
* CHECK dout0_30 vdout0_30ck93 = 1.95 time = 940
* CHECK dout0_31 vdout0_31ck93 = 1.95 time = 940
* CHECK dout1_0 vdout1_0ck93 = 0 time = 940
* CHECK dout1_1 vdout1_1ck93 = 0 time = 940
* CHECK dout1_2 vdout1_2ck93 = 0 time = 940
* CHECK dout1_3 vdout1_3ck93 = 1.95 time = 940
* CHECK dout1_4 vdout1_4ck93 = 1.95 time = 940
* CHECK dout1_5 vdout1_5ck93 = 0 time = 940
* CHECK dout1_6 vdout1_6ck93 = 1.95 time = 940
* CHECK dout1_7 vdout1_7ck93 = 1.95 time = 940
* CHECK dout1_8 vdout1_8ck93 = 0 time = 940
* CHECK dout1_9 vdout1_9ck93 = 1.95 time = 940
* CHECK dout1_10 vdout1_10ck93 = 1.95 time = 940
* CHECK dout1_11 vdout1_11ck93 = 1.95 time = 940
* CHECK dout1_12 vdout1_12ck93 = 0 time = 940
* CHECK dout1_13 vdout1_13ck93 = 0 time = 940
* CHECK dout1_14 vdout1_14ck93 = 1.95 time = 940
* CHECK dout1_15 vdout1_15ck93 = 1.95 time = 940
* CHECK dout1_16 vdout1_16ck93 = 0 time = 940
* CHECK dout1_17 vdout1_17ck93 = 1.95 time = 940
* CHECK dout1_18 vdout1_18ck93 = 0 time = 940
* CHECK dout1_19 vdout1_19ck93 = 0 time = 940
* CHECK dout1_20 vdout1_20ck93 = 0 time = 940
* CHECK dout1_21 vdout1_21ck93 = 0 time = 940
* CHECK dout1_22 vdout1_22ck93 = 0 time = 940
* CHECK dout1_23 vdout1_23ck93 = 0 time = 940
* CHECK dout1_24 vdout1_24ck93 = 0 time = 940
* CHECK dout1_25 vdout1_25ck93 = 1.95 time = 940
* CHECK dout1_26 vdout1_26ck93 = 1.95 time = 940
* CHECK dout1_27 vdout1_27ck93 = 0 time = 940
* CHECK dout1_28 vdout1_28ck93 = 1.95 time = 940
* CHECK dout1_29 vdout1_29ck93 = 0 time = 940
* CHECK dout1_30 vdout1_30ck93 = 1.95 time = 940
* CHECK dout1_31 vdout1_31ck93 = 1.95 time = 940
* CHECK dout0_0 vdout0_0ck96 = 1.95 time = 970
* CHECK dout0_1 vdout0_1ck96 = 0 time = 970
* CHECK dout0_2 vdout0_2ck96 = 1.95 time = 970
* CHECK dout0_3 vdout0_3ck96 = 1.95 time = 970
* CHECK dout0_4 vdout0_4ck96 = 0 time = 970
* CHECK dout0_5 vdout0_5ck96 = 1.95 time = 970
* CHECK dout0_6 vdout0_6ck96 = 0 time = 970
* CHECK dout0_7 vdout0_7ck96 = 0 time = 970
* CHECK dout0_8 vdout0_8ck96 = 1.95 time = 970
* CHECK dout0_9 vdout0_9ck96 = 1.95 time = 970
* CHECK dout0_10 vdout0_10ck96 = 0 time = 970
* CHECK dout0_11 vdout0_11ck96 = 1.95 time = 970
* CHECK dout0_12 vdout0_12ck96 = 0 time = 970
* CHECK dout0_13 vdout0_13ck96 = 0 time = 970
* CHECK dout0_14 vdout0_14ck96 = 0 time = 970
* CHECK dout0_15 vdout0_15ck96 = 0 time = 970
* CHECK dout0_16 vdout0_16ck96 = 0 time = 970
* CHECK dout0_17 vdout0_17ck96 = 0 time = 970
* CHECK dout0_18 vdout0_18ck96 = 0 time = 970
* CHECK dout0_19 vdout0_19ck96 = 0 time = 970
* CHECK dout0_20 vdout0_20ck96 = 1.95 time = 970
* CHECK dout0_21 vdout0_21ck96 = 1.95 time = 970
* CHECK dout0_22 vdout0_22ck96 = 0 time = 970
* CHECK dout0_23 vdout0_23ck96 = 1.95 time = 970
* CHECK dout0_24 vdout0_24ck96 = 1.95 time = 970
* CHECK dout0_25 vdout0_25ck96 = 1.95 time = 970
* CHECK dout0_26 vdout0_26ck96 = 0 time = 970
* CHECK dout0_27 vdout0_27ck96 = 1.95 time = 970
* CHECK dout0_28 vdout0_28ck96 = 1.95 time = 970
* CHECK dout0_29 vdout0_29ck96 = 0 time = 970
* CHECK dout0_30 vdout0_30ck96 = 1.95 time = 970
* CHECK dout0_31 vdout0_31ck96 = 1.95 time = 970
* CHECK dout1_0 vdout1_0ck96 = 0 time = 970
* CHECK dout1_1 vdout1_1ck96 = 1.95 time = 970
* CHECK dout1_2 vdout1_2ck96 = 0 time = 970
* CHECK dout1_3 vdout1_3ck96 = 0 time = 970
* CHECK dout1_4 vdout1_4ck96 = 0 time = 970
* CHECK dout1_5 vdout1_5ck96 = 0 time = 970
* CHECK dout1_6 vdout1_6ck96 = 0 time = 970
* CHECK dout1_7 vdout1_7ck96 = 0 time = 970
* CHECK dout1_8 vdout1_8ck96 = 1.95 time = 970
* CHECK dout1_9 vdout1_9ck96 = 0 time = 970
* CHECK dout1_10 vdout1_10ck96 = 1.95 time = 970
* CHECK dout1_11 vdout1_11ck96 = 1.95 time = 970
* CHECK dout1_12 vdout1_12ck96 = 0 time = 970
* CHECK dout1_13 vdout1_13ck96 = 0 time = 970
* CHECK dout1_14 vdout1_14ck96 = 1.95 time = 970
* CHECK dout1_15 vdout1_15ck96 = 1.95 time = 970
* CHECK dout1_16 vdout1_16ck96 = 1.95 time = 970
* CHECK dout1_17 vdout1_17ck96 = 0 time = 970
* CHECK dout1_18 vdout1_18ck96 = 0 time = 970
* CHECK dout1_19 vdout1_19ck96 = 1.95 time = 970
* CHECK dout1_20 vdout1_20ck96 = 1.95 time = 970
* CHECK dout1_21 vdout1_21ck96 = 1.95 time = 970
* CHECK dout1_22 vdout1_22ck96 = 1.95 time = 970
* CHECK dout1_23 vdout1_23ck96 = 0 time = 970
* CHECK dout1_24 vdout1_24ck96 = 0 time = 970
* CHECK dout1_25 vdout1_25ck96 = 1.95 time = 970
* CHECK dout1_26 vdout1_26ck96 = 0 time = 970
* CHECK dout1_27 vdout1_27ck96 = 0 time = 970
* CHECK dout1_28 vdout1_28ck96 = 0 time = 970
* CHECK dout1_29 vdout1_29ck96 = 1.95 time = 970
* CHECK dout1_30 vdout1_30ck96 = 1.95 time = 970
* CHECK dout1_31 vdout1_31ck96 = 0 time = 970
* CHECK dout0_0 vdout0_0ck100 = 0 time = 1010
* CHECK dout0_1 vdout0_1ck100 = 1.95 time = 1010
* CHECK dout0_2 vdout0_2ck100 = 0 time = 1010
* CHECK dout0_3 vdout0_3ck100 = 0 time = 1010
* CHECK dout0_4 vdout0_4ck100 = 0 time = 1010
* CHECK dout0_5 vdout0_5ck100 = 0 time = 1010
* CHECK dout0_6 vdout0_6ck100 = 0 time = 1010
* CHECK dout0_7 vdout0_7ck100 = 0 time = 1010
* CHECK dout0_8 vdout0_8ck100 = 1.95 time = 1010
* CHECK dout0_9 vdout0_9ck100 = 0 time = 1010
* CHECK dout0_10 vdout0_10ck100 = 1.95 time = 1010
* CHECK dout0_11 vdout0_11ck100 = 1.95 time = 1010
* CHECK dout0_12 vdout0_12ck100 = 0 time = 1010
* CHECK dout0_13 vdout0_13ck100 = 0 time = 1010
* CHECK dout0_14 vdout0_14ck100 = 1.95 time = 1010
* CHECK dout0_15 vdout0_15ck100 = 1.95 time = 1010
* CHECK dout0_16 vdout0_16ck100 = 1.95 time = 1010
* CHECK dout0_17 vdout0_17ck100 = 0 time = 1010
* CHECK dout0_18 vdout0_18ck100 = 0 time = 1010
* CHECK dout0_19 vdout0_19ck100 = 1.95 time = 1010
* CHECK dout0_20 vdout0_20ck100 = 1.95 time = 1010
* CHECK dout0_21 vdout0_21ck100 = 1.95 time = 1010
* CHECK dout0_22 vdout0_22ck100 = 1.95 time = 1010
* CHECK dout0_23 vdout0_23ck100 = 0 time = 1010
* CHECK dout0_24 vdout0_24ck100 = 0 time = 1010
* CHECK dout0_25 vdout0_25ck100 = 1.95 time = 1010
* CHECK dout0_26 vdout0_26ck100 = 0 time = 1010
* CHECK dout0_27 vdout0_27ck100 = 0 time = 1010
* CHECK dout0_28 vdout0_28ck100 = 0 time = 1010
* CHECK dout0_29 vdout0_29ck100 = 1.95 time = 1010
* CHECK dout0_30 vdout0_30ck100 = 1.95 time = 1010
* CHECK dout0_31 vdout0_31ck100 = 0 time = 1010
* CHECK dout1_0 vdout1_0ck101 = 0 time = 1020
* CHECK dout1_1 vdout1_1ck101 = 1.95 time = 1020
* CHECK dout1_2 vdout1_2ck101 = 1.95 time = 1020
* CHECK dout1_3 vdout1_3ck101 = 1.95 time = 1020
* CHECK dout1_4 vdout1_4ck101 = 0 time = 1020
* CHECK dout1_5 vdout1_5ck101 = 1.95 time = 1020
* CHECK dout1_6 vdout1_6ck101 = 1.95 time = 1020
* CHECK dout1_7 vdout1_7ck101 = 0 time = 1020
* CHECK dout1_8 vdout1_8ck101 = 1.95 time = 1020
* CHECK dout1_9 vdout1_9ck101 = 0 time = 1020
* CHECK dout1_10 vdout1_10ck101 = 0 time = 1020
* CHECK dout1_11 vdout1_11ck101 = 0 time = 1020
* CHECK dout1_12 vdout1_12ck101 = 1.95 time = 1020
* CHECK dout1_13 vdout1_13ck101 = 0 time = 1020
* CHECK dout1_14 vdout1_14ck101 = 0 time = 1020
* CHECK dout1_15 vdout1_15ck101 = 1.95 time = 1020
* CHECK dout1_16 vdout1_16ck101 = 0 time = 1020
* CHECK dout1_17 vdout1_17ck101 = 0 time = 1020
* CHECK dout1_18 vdout1_18ck101 = 1.95 time = 1020
* CHECK dout1_19 vdout1_19ck101 = 0 time = 1020
* CHECK dout1_20 vdout1_20ck101 = 1.95 time = 1020
* CHECK dout1_21 vdout1_21ck101 = 0 time = 1020
* CHECK dout1_22 vdout1_22ck101 = 0 time = 1020
* CHECK dout1_23 vdout1_23ck101 = 0 time = 1020
* CHECK dout1_24 vdout1_24ck101 = 0 time = 1020
* CHECK dout1_25 vdout1_25ck101 = 1.95 time = 1020
* CHECK dout1_26 vdout1_26ck101 = 0 time = 1020
* CHECK dout1_27 vdout1_27ck101 = 0 time = 1020
* CHECK dout1_28 vdout1_28ck101 = 1.95 time = 1020
* CHECK dout1_29 vdout1_29ck101 = 1.95 time = 1020
* CHECK dout1_30 vdout1_30ck101 = 0 time = 1020
* CHECK dout1_31 vdout1_31ck101 = 1.95 time = 1020
* CHECK dout0_0 vdout0_0ck102 = 0 time = 1030
* CHECK dout0_1 vdout0_1ck102 = 1.95 time = 1030
* CHECK dout0_2 vdout0_2ck102 = 0 time = 1030
* CHECK dout0_3 vdout0_3ck102 = 0 time = 1030
* CHECK dout0_4 vdout0_4ck102 = 0 time = 1030
* CHECK dout0_5 vdout0_5ck102 = 0 time = 1030
* CHECK dout0_6 vdout0_6ck102 = 0 time = 1030
* CHECK dout0_7 vdout0_7ck102 = 0 time = 1030
* CHECK dout0_8 vdout0_8ck102 = 1.95 time = 1030
* CHECK dout0_9 vdout0_9ck102 = 0 time = 1030
* CHECK dout0_10 vdout0_10ck102 = 1.95 time = 1030
* CHECK dout0_11 vdout0_11ck102 = 1.95 time = 1030
* CHECK dout0_12 vdout0_12ck102 = 0 time = 1030
* CHECK dout0_13 vdout0_13ck102 = 0 time = 1030
* CHECK dout0_14 vdout0_14ck102 = 1.95 time = 1030
* CHECK dout0_15 vdout0_15ck102 = 1.95 time = 1030
* CHECK dout0_16 vdout0_16ck102 = 1.95 time = 1030
* CHECK dout0_17 vdout0_17ck102 = 0 time = 1030
* CHECK dout0_18 vdout0_18ck102 = 0 time = 1030
* CHECK dout0_19 vdout0_19ck102 = 1.95 time = 1030
* CHECK dout0_20 vdout0_20ck102 = 1.95 time = 1030
* CHECK dout0_21 vdout0_21ck102 = 1.95 time = 1030
* CHECK dout0_22 vdout0_22ck102 = 1.95 time = 1030
* CHECK dout0_23 vdout0_23ck102 = 0 time = 1030
* CHECK dout0_24 vdout0_24ck102 = 0 time = 1030
* CHECK dout0_25 vdout0_25ck102 = 1.95 time = 1030
* CHECK dout0_26 vdout0_26ck102 = 0 time = 1030
* CHECK dout0_27 vdout0_27ck102 = 0 time = 1030
* CHECK dout0_28 vdout0_28ck102 = 0 time = 1030
* CHECK dout0_29 vdout0_29ck102 = 1.95 time = 1030
* CHECK dout0_30 vdout0_30ck102 = 1.95 time = 1030
* CHECK dout0_31 vdout0_31ck102 = 0 time = 1030
* CHECK dout1_0 vdout1_0ck102 = 0 time = 1030
* CHECK dout1_1 vdout1_1ck102 = 1.95 time = 1030
* CHECK dout1_2 vdout1_2ck102 = 1.95 time = 1030
* CHECK dout1_3 vdout1_3ck102 = 1.95 time = 1030
* CHECK dout1_4 vdout1_4ck102 = 0 time = 1030
* CHECK dout1_5 vdout1_5ck102 = 1.95 time = 1030
* CHECK dout1_6 vdout1_6ck102 = 1.95 time = 1030
* CHECK dout1_7 vdout1_7ck102 = 0 time = 1030
* CHECK dout1_8 vdout1_8ck102 = 1.95 time = 1030
* CHECK dout1_9 vdout1_9ck102 = 0 time = 1030
* CHECK dout1_10 vdout1_10ck102 = 0 time = 1030
* CHECK dout1_11 vdout1_11ck102 = 0 time = 1030
* CHECK dout1_12 vdout1_12ck102 = 1.95 time = 1030
* CHECK dout1_13 vdout1_13ck102 = 0 time = 1030
* CHECK dout1_14 vdout1_14ck102 = 0 time = 1030
* CHECK dout1_15 vdout1_15ck102 = 1.95 time = 1030
* CHECK dout1_16 vdout1_16ck102 = 0 time = 1030
* CHECK dout1_17 vdout1_17ck102 = 0 time = 1030
* CHECK dout1_18 vdout1_18ck102 = 1.95 time = 1030
* CHECK dout1_19 vdout1_19ck102 = 0 time = 1030
* CHECK dout1_20 vdout1_20ck102 = 1.95 time = 1030
* CHECK dout1_21 vdout1_21ck102 = 0 time = 1030
* CHECK dout1_22 vdout1_22ck102 = 0 time = 1030
* CHECK dout1_23 vdout1_23ck102 = 0 time = 1030
* CHECK dout1_24 vdout1_24ck102 = 0 time = 1030
* CHECK dout1_25 vdout1_25ck102 = 1.95 time = 1030
* CHECK dout1_26 vdout1_26ck102 = 0 time = 1030
* CHECK dout1_27 vdout1_27ck102 = 0 time = 1030
* CHECK dout1_28 vdout1_28ck102 = 1.95 time = 1030
* CHECK dout1_29 vdout1_29ck102 = 1.95 time = 1030
* CHECK dout1_30 vdout1_30ck102 = 0 time = 1030
* CHECK dout1_31 vdout1_31ck102 = 1.95 time = 1030
* CHECK dout1_0 vdout1_0ck104 = 0 time = 1050
* CHECK dout1_1 vdout1_1ck104 = 1.95 time = 1050
* CHECK dout1_2 vdout1_2ck104 = 1.95 time = 1050
* CHECK dout1_3 vdout1_3ck104 = 1.95 time = 1050
* CHECK dout1_4 vdout1_4ck104 = 0 time = 1050
* CHECK dout1_5 vdout1_5ck104 = 1.95 time = 1050
* CHECK dout1_6 vdout1_6ck104 = 1.95 time = 1050
* CHECK dout1_7 vdout1_7ck104 = 0 time = 1050
* CHECK dout1_8 vdout1_8ck104 = 1.95 time = 1050
* CHECK dout1_9 vdout1_9ck104 = 0 time = 1050
* CHECK dout1_10 vdout1_10ck104 = 0 time = 1050
* CHECK dout1_11 vdout1_11ck104 = 0 time = 1050
* CHECK dout1_12 vdout1_12ck104 = 1.95 time = 1050
* CHECK dout1_13 vdout1_13ck104 = 0 time = 1050
* CHECK dout1_14 vdout1_14ck104 = 0 time = 1050
* CHECK dout1_15 vdout1_15ck104 = 1.95 time = 1050
* CHECK dout1_16 vdout1_16ck104 = 0 time = 1050
* CHECK dout1_17 vdout1_17ck104 = 0 time = 1050
* CHECK dout1_18 vdout1_18ck104 = 1.95 time = 1050
* CHECK dout1_19 vdout1_19ck104 = 0 time = 1050
* CHECK dout1_20 vdout1_20ck104 = 1.95 time = 1050
* CHECK dout1_21 vdout1_21ck104 = 0 time = 1050
* CHECK dout1_22 vdout1_22ck104 = 0 time = 1050
* CHECK dout1_23 vdout1_23ck104 = 0 time = 1050
* CHECK dout1_24 vdout1_24ck104 = 0 time = 1050
* CHECK dout1_25 vdout1_25ck104 = 1.95 time = 1050
* CHECK dout1_26 vdout1_26ck104 = 0 time = 1050
* CHECK dout1_27 vdout1_27ck104 = 0 time = 1050
* CHECK dout1_28 vdout1_28ck104 = 1.95 time = 1050
* CHECK dout1_29 vdout1_29ck104 = 1.95 time = 1050
* CHECK dout1_30 vdout1_30ck104 = 0 time = 1050
* CHECK dout1_31 vdout1_31ck104 = 1.95 time = 1050
* CHECK dout1_0 vdout1_0ck105 = 0 time = 1060
* CHECK dout1_1 vdout1_1ck105 = 1.95 time = 1060
* CHECK dout1_2 vdout1_2ck105 = 0 time = 1060
* CHECK dout1_3 vdout1_3ck105 = 1.95 time = 1060
* CHECK dout1_4 vdout1_4ck105 = 1.95 time = 1060
* CHECK dout1_5 vdout1_5ck105 = 1.95 time = 1060
* CHECK dout1_6 vdout1_6ck105 = 1.95 time = 1060
* CHECK dout1_7 vdout1_7ck105 = 1.95 time = 1060
* CHECK dout1_8 vdout1_8ck105 = 1.95 time = 1060
* CHECK dout1_9 vdout1_9ck105 = 1.95 time = 1060
* CHECK dout1_10 vdout1_10ck105 = 0 time = 1060
* CHECK dout1_11 vdout1_11ck105 = 0 time = 1060
* CHECK dout1_12 vdout1_12ck105 = 0 time = 1060
* CHECK dout1_13 vdout1_13ck105 = 1.95 time = 1060
* CHECK dout1_14 vdout1_14ck105 = 0 time = 1060
* CHECK dout1_15 vdout1_15ck105 = 0 time = 1060
* CHECK dout1_16 vdout1_16ck105 = 1.95 time = 1060
* CHECK dout1_17 vdout1_17ck105 = 0 time = 1060
* CHECK dout1_18 vdout1_18ck105 = 0 time = 1060
* CHECK dout1_19 vdout1_19ck105 = 1.95 time = 1060
* CHECK dout1_20 vdout1_20ck105 = 0 time = 1060
* CHECK dout1_21 vdout1_21ck105 = 1.95 time = 1060
* CHECK dout1_22 vdout1_22ck105 = 1.95 time = 1060
* CHECK dout1_23 vdout1_23ck105 = 0 time = 1060
* CHECK dout1_24 vdout1_24ck105 = 1.95 time = 1060
* CHECK dout1_25 vdout1_25ck105 = 1.95 time = 1060
* CHECK dout1_26 vdout1_26ck105 = 1.95 time = 1060
* CHECK dout1_27 vdout1_27ck105 = 0 time = 1060
* CHECK dout1_28 vdout1_28ck105 = 1.95 time = 1060
* CHECK dout1_29 vdout1_29ck105 = 1.95 time = 1060
* CHECK dout1_30 vdout1_30ck105 = 1.95 time = 1060
* CHECK dout1_31 vdout1_31ck105 = 0 time = 1060
* CHECK dout0_0 vdout0_0ck107 = 0 time = 1080
* CHECK dout0_1 vdout0_1ck107 = 1.95 time = 1080
* CHECK dout0_2 vdout0_2ck107 = 1.95 time = 1080
* CHECK dout0_3 vdout0_3ck107 = 1.95 time = 1080
* CHECK dout0_4 vdout0_4ck107 = 0 time = 1080
* CHECK dout0_5 vdout0_5ck107 = 1.95 time = 1080
* CHECK dout0_6 vdout0_6ck107 = 1.95 time = 1080
* CHECK dout0_7 vdout0_7ck107 = 0 time = 1080
* CHECK dout0_8 vdout0_8ck107 = 1.95 time = 1080
* CHECK dout0_9 vdout0_9ck107 = 0 time = 1080
* CHECK dout0_10 vdout0_10ck107 = 0 time = 1080
* CHECK dout0_11 vdout0_11ck107 = 0 time = 1080
* CHECK dout0_12 vdout0_12ck107 = 1.95 time = 1080
* CHECK dout0_13 vdout0_13ck107 = 0 time = 1080
* CHECK dout0_14 vdout0_14ck107 = 0 time = 1080
* CHECK dout0_15 vdout0_15ck107 = 1.95 time = 1080
* CHECK dout0_16 vdout0_16ck107 = 0 time = 1080
* CHECK dout0_17 vdout0_17ck107 = 0 time = 1080
* CHECK dout0_18 vdout0_18ck107 = 1.95 time = 1080
* CHECK dout0_19 vdout0_19ck107 = 0 time = 1080
* CHECK dout0_20 vdout0_20ck107 = 1.95 time = 1080
* CHECK dout0_21 vdout0_21ck107 = 0 time = 1080
* CHECK dout0_22 vdout0_22ck107 = 0 time = 1080
* CHECK dout0_23 vdout0_23ck107 = 0 time = 1080
* CHECK dout0_24 vdout0_24ck107 = 0 time = 1080
* CHECK dout0_25 vdout0_25ck107 = 1.95 time = 1080
* CHECK dout0_26 vdout0_26ck107 = 0 time = 1080
* CHECK dout0_27 vdout0_27ck107 = 0 time = 1080
* CHECK dout0_28 vdout0_28ck107 = 1.95 time = 1080
* CHECK dout0_29 vdout0_29ck107 = 1.95 time = 1080
* CHECK dout0_30 vdout0_30ck107 = 0 time = 1080
* CHECK dout0_31 vdout0_31ck107 = 1.95 time = 1080
* CHECK dout1_0 vdout1_0ck107 = 0 time = 1080
* CHECK dout1_1 vdout1_1ck107 = 1.95 time = 1080
* CHECK dout1_2 vdout1_2ck107 = 1.95 time = 1080
* CHECK dout1_3 vdout1_3ck107 = 1.95 time = 1080
* CHECK dout1_4 vdout1_4ck107 = 0 time = 1080
* CHECK dout1_5 vdout1_5ck107 = 1.95 time = 1080
* CHECK dout1_6 vdout1_6ck107 = 1.95 time = 1080
* CHECK dout1_7 vdout1_7ck107 = 0 time = 1080
* CHECK dout1_8 vdout1_8ck107 = 1.95 time = 1080
* CHECK dout1_9 vdout1_9ck107 = 0 time = 1080
* CHECK dout1_10 vdout1_10ck107 = 0 time = 1080
* CHECK dout1_11 vdout1_11ck107 = 0 time = 1080
* CHECK dout1_12 vdout1_12ck107 = 1.95 time = 1080
* CHECK dout1_13 vdout1_13ck107 = 0 time = 1080
* CHECK dout1_14 vdout1_14ck107 = 0 time = 1080
* CHECK dout1_15 vdout1_15ck107 = 1.95 time = 1080
* CHECK dout1_16 vdout1_16ck107 = 0 time = 1080
* CHECK dout1_17 vdout1_17ck107 = 0 time = 1080
* CHECK dout1_18 vdout1_18ck107 = 1.95 time = 1080
* CHECK dout1_19 vdout1_19ck107 = 0 time = 1080
* CHECK dout1_20 vdout1_20ck107 = 1.95 time = 1080
* CHECK dout1_21 vdout1_21ck107 = 0 time = 1080
* CHECK dout1_22 vdout1_22ck107 = 0 time = 1080
* CHECK dout1_23 vdout1_23ck107 = 0 time = 1080
* CHECK dout1_24 vdout1_24ck107 = 0 time = 1080
* CHECK dout1_25 vdout1_25ck107 = 1.95 time = 1080
* CHECK dout1_26 vdout1_26ck107 = 0 time = 1080
* CHECK dout1_27 vdout1_27ck107 = 0 time = 1080
* CHECK dout1_28 vdout1_28ck107 = 1.95 time = 1080
* CHECK dout1_29 vdout1_29ck107 = 1.95 time = 1080
* CHECK dout1_30 vdout1_30ck107 = 0 time = 1080
* CHECK dout1_31 vdout1_31ck107 = 1.95 time = 1080
* CHECK dout0_0 vdout0_0ck109 = 0 time = 1100
* CHECK dout0_1 vdout0_1ck109 = 0 time = 1100
* CHECK dout0_2 vdout0_2ck109 = 0 time = 1100
* CHECK dout0_3 vdout0_3ck109 = 1.95 time = 1100
* CHECK dout0_4 vdout0_4ck109 = 1.95 time = 1100
* CHECK dout0_5 vdout0_5ck109 = 0 time = 1100
* CHECK dout0_6 vdout0_6ck109 = 1.95 time = 1100
* CHECK dout0_7 vdout0_7ck109 = 1.95 time = 1100
* CHECK dout0_8 vdout0_8ck109 = 0 time = 1100
* CHECK dout0_9 vdout0_9ck109 = 1.95 time = 1100
* CHECK dout0_10 vdout0_10ck109 = 1.95 time = 1100
* CHECK dout0_11 vdout0_11ck109 = 1.95 time = 1100
* CHECK dout0_12 vdout0_12ck109 = 0 time = 1100
* CHECK dout0_13 vdout0_13ck109 = 0 time = 1100
* CHECK dout0_14 vdout0_14ck109 = 1.95 time = 1100
* CHECK dout0_15 vdout0_15ck109 = 1.95 time = 1100
* CHECK dout0_16 vdout0_16ck109 = 0 time = 1100
* CHECK dout0_17 vdout0_17ck109 = 1.95 time = 1100
* CHECK dout0_18 vdout0_18ck109 = 0 time = 1100
* CHECK dout0_19 vdout0_19ck109 = 0 time = 1100
* CHECK dout0_20 vdout0_20ck109 = 0 time = 1100
* CHECK dout0_21 vdout0_21ck109 = 0 time = 1100
* CHECK dout0_22 vdout0_22ck109 = 0 time = 1100
* CHECK dout0_23 vdout0_23ck109 = 0 time = 1100
* CHECK dout0_24 vdout0_24ck109 = 0 time = 1100
* CHECK dout0_25 vdout0_25ck109 = 1.95 time = 1100
* CHECK dout0_26 vdout0_26ck109 = 1.95 time = 1100
* CHECK dout0_27 vdout0_27ck109 = 0 time = 1100
* CHECK dout0_28 vdout0_28ck109 = 1.95 time = 1100
* CHECK dout0_29 vdout0_29ck109 = 0 time = 1100
* CHECK dout0_30 vdout0_30ck109 = 1.95 time = 1100
* CHECK dout0_31 vdout0_31ck109 = 1.95 time = 1100
* CHECK dout1_0 vdout1_0ck109 = 0 time = 1100
* CHECK dout1_1 vdout1_1ck109 = 0 time = 1100
* CHECK dout1_2 vdout1_2ck109 = 1.95 time = 1100
* CHECK dout1_3 vdout1_3ck109 = 0 time = 1100
* CHECK dout1_4 vdout1_4ck109 = 1.95 time = 1100
* CHECK dout1_5 vdout1_5ck109 = 0 time = 1100
* CHECK dout1_6 vdout1_6ck109 = 1.95 time = 1100
* CHECK dout1_7 vdout1_7ck109 = 0 time = 1100
* CHECK dout1_8 vdout1_8ck109 = 1.95 time = 1100
* CHECK dout1_9 vdout1_9ck109 = 1.95 time = 1100
* CHECK dout1_10 vdout1_10ck109 = 0 time = 1100
* CHECK dout1_11 vdout1_11ck109 = 1.95 time = 1100
* CHECK dout1_12 vdout1_12ck109 = 1.95 time = 1100
* CHECK dout1_13 vdout1_13ck109 = 1.95 time = 1100
* CHECK dout1_14 vdout1_14ck109 = 0 time = 1100
* CHECK dout1_15 vdout1_15ck109 = 0 time = 1100
* CHECK dout1_16 vdout1_16ck109 = 1.95 time = 1100
* CHECK dout1_17 vdout1_17ck109 = 0 time = 1100
* CHECK dout1_18 vdout1_18ck109 = 0 time = 1100
* CHECK dout1_19 vdout1_19ck109 = 1.95 time = 1100
* CHECK dout1_20 vdout1_20ck109 = 1.95 time = 1100
* CHECK dout1_21 vdout1_21ck109 = 1.95 time = 1100
* CHECK dout1_22 vdout1_22ck109 = 1.95 time = 1100
* CHECK dout1_23 vdout1_23ck109 = 0 time = 1100
* CHECK dout1_24 vdout1_24ck109 = 0 time = 1100
* CHECK dout1_25 vdout1_25ck109 = 1.95 time = 1100
* CHECK dout1_26 vdout1_26ck109 = 0 time = 1100
* CHECK dout1_27 vdout1_27ck109 = 0 time = 1100
* CHECK dout1_28 vdout1_28ck109 = 0 time = 1100
* CHECK dout1_29 vdout1_29ck109 = 0 time = 1100
* CHECK dout1_30 vdout1_30ck109 = 1.95 time = 1100
* CHECK dout1_31 vdout1_31ck109 = 0 time = 1100
* CHECK dout1_0 vdout1_0ck111 = 0 time = 1120
* CHECK dout1_1 vdout1_1ck111 = 1.95 time = 1120
* CHECK dout1_2 vdout1_2ck111 = 0 time = 1120
* CHECK dout1_3 vdout1_3ck111 = 1.95 time = 1120
* CHECK dout1_4 vdout1_4ck111 = 1.95 time = 1120
* CHECK dout1_5 vdout1_5ck111 = 1.95 time = 1120
* CHECK dout1_6 vdout1_6ck111 = 1.95 time = 1120
* CHECK dout1_7 vdout1_7ck111 = 1.95 time = 1120
* CHECK dout1_8 vdout1_8ck111 = 1.95 time = 1120
* CHECK dout1_9 vdout1_9ck111 = 1.95 time = 1120
* CHECK dout1_10 vdout1_10ck111 = 0 time = 1120
* CHECK dout1_11 vdout1_11ck111 = 0 time = 1120
* CHECK dout1_12 vdout1_12ck111 = 0 time = 1120
* CHECK dout1_13 vdout1_13ck111 = 1.95 time = 1120
* CHECK dout1_14 vdout1_14ck111 = 0 time = 1120
* CHECK dout1_15 vdout1_15ck111 = 0 time = 1120
* CHECK dout1_16 vdout1_16ck111 = 1.95 time = 1120
* CHECK dout1_17 vdout1_17ck111 = 0 time = 1120
* CHECK dout1_18 vdout1_18ck111 = 0 time = 1120
* CHECK dout1_19 vdout1_19ck111 = 1.95 time = 1120
* CHECK dout1_20 vdout1_20ck111 = 0 time = 1120
* CHECK dout1_21 vdout1_21ck111 = 1.95 time = 1120
* CHECK dout1_22 vdout1_22ck111 = 1.95 time = 1120
* CHECK dout1_23 vdout1_23ck111 = 0 time = 1120
* CHECK dout1_24 vdout1_24ck111 = 1.95 time = 1120
* CHECK dout1_25 vdout1_25ck111 = 1.95 time = 1120
* CHECK dout1_26 vdout1_26ck111 = 1.95 time = 1120
* CHECK dout1_27 vdout1_27ck111 = 0 time = 1120
* CHECK dout1_28 vdout1_28ck111 = 1.95 time = 1120
* CHECK dout1_29 vdout1_29ck111 = 1.95 time = 1120
* CHECK dout1_30 vdout1_30ck111 = 1.95 time = 1120
* CHECK dout1_31 vdout1_31ck111 = 0 time = 1120
* CHECK dout0_0 vdout0_0ck112 = 0 time = 1130
* CHECK dout0_1 vdout0_1ck112 = 0 time = 1130
* CHECK dout0_2 vdout0_2ck112 = 0 time = 1130
* CHECK dout0_3 vdout0_3ck112 = 1.95 time = 1130
* CHECK dout0_4 vdout0_4ck112 = 1.95 time = 1130
* CHECK dout0_5 vdout0_5ck112 = 0 time = 1130
* CHECK dout0_6 vdout0_6ck112 = 1.95 time = 1130
* CHECK dout0_7 vdout0_7ck112 = 1.95 time = 1130
* CHECK dout0_8 vdout0_8ck112 = 0 time = 1130
* CHECK dout0_9 vdout0_9ck112 = 1.95 time = 1130
* CHECK dout0_10 vdout0_10ck112 = 1.95 time = 1130
* CHECK dout0_11 vdout0_11ck112 = 1.95 time = 1130
* CHECK dout0_12 vdout0_12ck112 = 0 time = 1130
* CHECK dout0_13 vdout0_13ck112 = 0 time = 1130
* CHECK dout0_14 vdout0_14ck112 = 1.95 time = 1130
* CHECK dout0_15 vdout0_15ck112 = 1.95 time = 1130
* CHECK dout0_16 vdout0_16ck112 = 0 time = 1130
* CHECK dout0_17 vdout0_17ck112 = 1.95 time = 1130
* CHECK dout0_18 vdout0_18ck112 = 0 time = 1130
* CHECK dout0_19 vdout0_19ck112 = 0 time = 1130
* CHECK dout0_20 vdout0_20ck112 = 0 time = 1130
* CHECK dout0_21 vdout0_21ck112 = 0 time = 1130
* CHECK dout0_22 vdout0_22ck112 = 0 time = 1130
* CHECK dout0_23 vdout0_23ck112 = 0 time = 1130
* CHECK dout0_24 vdout0_24ck112 = 1.95 time = 1130
* CHECK dout0_25 vdout0_25ck112 = 1.95 time = 1130
* CHECK dout0_26 vdout0_26ck112 = 0 time = 1130
* CHECK dout0_27 vdout0_27ck112 = 0 time = 1130
* CHECK dout0_28 vdout0_28ck112 = 1.95 time = 1130
* CHECK dout0_29 vdout0_29ck112 = 1.95 time = 1130
* CHECK dout0_30 vdout0_30ck112 = 1.95 time = 1130
* CHECK dout0_31 vdout0_31ck112 = 1.95 time = 1130
* CHECK dout1_0 vdout1_0ck112 = 0 time = 1130
* CHECK dout1_1 vdout1_1ck112 = 0 time = 1130
* CHECK dout1_2 vdout1_2ck112 = 1.95 time = 1130
* CHECK dout1_3 vdout1_3ck112 = 0 time = 1130
* CHECK dout1_4 vdout1_4ck112 = 1.95 time = 1130
* CHECK dout1_5 vdout1_5ck112 = 0 time = 1130
* CHECK dout1_6 vdout1_6ck112 = 1.95 time = 1130
* CHECK dout1_7 vdout1_7ck112 = 0 time = 1130
* CHECK dout1_8 vdout1_8ck112 = 1.95 time = 1130
* CHECK dout1_9 vdout1_9ck112 = 1.95 time = 1130
* CHECK dout1_10 vdout1_10ck112 = 0 time = 1130
* CHECK dout1_11 vdout1_11ck112 = 1.95 time = 1130
* CHECK dout1_12 vdout1_12ck112 = 1.95 time = 1130
* CHECK dout1_13 vdout1_13ck112 = 1.95 time = 1130
* CHECK dout1_14 vdout1_14ck112 = 0 time = 1130
* CHECK dout1_15 vdout1_15ck112 = 0 time = 1130
* CHECK dout1_16 vdout1_16ck112 = 1.95 time = 1130
* CHECK dout1_17 vdout1_17ck112 = 0 time = 1130
* CHECK dout1_18 vdout1_18ck112 = 0 time = 1130
* CHECK dout1_19 vdout1_19ck112 = 1.95 time = 1130
* CHECK dout1_20 vdout1_20ck112 = 1.95 time = 1130
* CHECK dout1_21 vdout1_21ck112 = 1.95 time = 1130
* CHECK dout1_22 vdout1_22ck112 = 1.95 time = 1130
* CHECK dout1_23 vdout1_23ck112 = 0 time = 1130
* CHECK dout1_24 vdout1_24ck112 = 0 time = 1130
* CHECK dout1_25 vdout1_25ck112 = 1.95 time = 1130
* CHECK dout1_26 vdout1_26ck112 = 0 time = 1130
* CHECK dout1_27 vdout1_27ck112 = 0 time = 1130
* CHECK dout1_28 vdout1_28ck112 = 0 time = 1130
* CHECK dout1_29 vdout1_29ck112 = 0 time = 1130
* CHECK dout1_30 vdout1_30ck112 = 1.95 time = 1130
* CHECK dout1_31 vdout1_31ck112 = 0 time = 1130
* CHECK dout0_0 vdout0_0ck113 = 0 time = 1140
* CHECK dout0_1 vdout0_1ck113 = 0 time = 1140
* CHECK dout0_2 vdout0_2ck113 = 1.95 time = 1140
* CHECK dout0_3 vdout0_3ck113 = 0 time = 1140
* CHECK dout0_4 vdout0_4ck113 = 1.95 time = 1140
* CHECK dout0_5 vdout0_5ck113 = 0 time = 1140
* CHECK dout0_6 vdout0_6ck113 = 1.95 time = 1140
* CHECK dout0_7 vdout0_7ck113 = 0 time = 1140
* CHECK dout0_8 vdout0_8ck113 = 1.95 time = 1140
* CHECK dout0_9 vdout0_9ck113 = 1.95 time = 1140
* CHECK dout0_10 vdout0_10ck113 = 0 time = 1140
* CHECK dout0_11 vdout0_11ck113 = 1.95 time = 1140
* CHECK dout0_12 vdout0_12ck113 = 1.95 time = 1140
* CHECK dout0_13 vdout0_13ck113 = 1.95 time = 1140
* CHECK dout0_14 vdout0_14ck113 = 0 time = 1140
* CHECK dout0_15 vdout0_15ck113 = 0 time = 1140
* CHECK dout0_16 vdout0_16ck113 = 1.95 time = 1140
* CHECK dout0_17 vdout0_17ck113 = 0 time = 1140
* CHECK dout0_18 vdout0_18ck113 = 0 time = 1140
* CHECK dout0_19 vdout0_19ck113 = 1.95 time = 1140
* CHECK dout0_20 vdout0_20ck113 = 1.95 time = 1140
* CHECK dout0_21 vdout0_21ck113 = 1.95 time = 1140
* CHECK dout0_22 vdout0_22ck113 = 1.95 time = 1140
* CHECK dout0_23 vdout0_23ck113 = 0 time = 1140
* CHECK dout0_24 vdout0_24ck113 = 0 time = 1140
* CHECK dout0_25 vdout0_25ck113 = 1.95 time = 1140
* CHECK dout0_26 vdout0_26ck113 = 0 time = 1140
* CHECK dout0_27 vdout0_27ck113 = 0 time = 1140
* CHECK dout0_28 vdout0_28ck113 = 0 time = 1140
* CHECK dout0_29 vdout0_29ck113 = 0 time = 1140
* CHECK dout0_30 vdout0_30ck113 = 1.95 time = 1140
* CHECK dout0_31 vdout0_31ck113 = 0 time = 1140
* CHECK dout1_0 vdout1_0ck113 = 0 time = 1140
* CHECK dout1_1 vdout1_1ck113 = 0 time = 1140
* CHECK dout1_2 vdout1_2ck113 = 1.95 time = 1140
* CHECK dout1_3 vdout1_3ck113 = 0 time = 1140
* CHECK dout1_4 vdout1_4ck113 = 1.95 time = 1140
* CHECK dout1_5 vdout1_5ck113 = 0 time = 1140
* CHECK dout1_6 vdout1_6ck113 = 1.95 time = 1140
* CHECK dout1_7 vdout1_7ck113 = 0 time = 1140
* CHECK dout1_8 vdout1_8ck113 = 1.95 time = 1140
* CHECK dout1_9 vdout1_9ck113 = 1.95 time = 1140
* CHECK dout1_10 vdout1_10ck113 = 0 time = 1140
* CHECK dout1_11 vdout1_11ck113 = 1.95 time = 1140
* CHECK dout1_12 vdout1_12ck113 = 1.95 time = 1140
* CHECK dout1_13 vdout1_13ck113 = 1.95 time = 1140
* CHECK dout1_14 vdout1_14ck113 = 0 time = 1140
* CHECK dout1_15 vdout1_15ck113 = 0 time = 1140
* CHECK dout1_16 vdout1_16ck113 = 1.95 time = 1140
* CHECK dout1_17 vdout1_17ck113 = 0 time = 1140
* CHECK dout1_18 vdout1_18ck113 = 0 time = 1140
* CHECK dout1_19 vdout1_19ck113 = 1.95 time = 1140
* CHECK dout1_20 vdout1_20ck113 = 1.95 time = 1140
* CHECK dout1_21 vdout1_21ck113 = 1.95 time = 1140
* CHECK dout1_22 vdout1_22ck113 = 1.95 time = 1140
* CHECK dout1_23 vdout1_23ck113 = 0 time = 1140
* CHECK dout1_24 vdout1_24ck113 = 0 time = 1140
* CHECK dout1_25 vdout1_25ck113 = 1.95 time = 1140
* CHECK dout1_26 vdout1_26ck113 = 0 time = 1140
* CHECK dout1_27 vdout1_27ck113 = 0 time = 1140
* CHECK dout1_28 vdout1_28ck113 = 0 time = 1140
* CHECK dout1_29 vdout1_29ck113 = 0 time = 1140
* CHECK dout1_30 vdout1_30ck113 = 1.95 time = 1140
* CHECK dout1_31 vdout1_31ck113 = 0 time = 1140
* CHECK dout0_0 vdout0_0ck114 = 0 time = 1150
* CHECK dout0_1 vdout0_1ck114 = 0 time = 1150
* CHECK dout0_2 vdout0_2ck114 = 0 time = 1150
* CHECK dout0_3 vdout0_3ck114 = 1.95 time = 1150
* CHECK dout0_4 vdout0_4ck114 = 1.95 time = 1150
* CHECK dout0_5 vdout0_5ck114 = 0 time = 1150
* CHECK dout0_6 vdout0_6ck114 = 1.95 time = 1150
* CHECK dout0_7 vdout0_7ck114 = 1.95 time = 1150
* CHECK dout0_8 vdout0_8ck114 = 0 time = 1150
* CHECK dout0_9 vdout0_9ck114 = 1.95 time = 1150
* CHECK dout0_10 vdout0_10ck114 = 1.95 time = 1150
* CHECK dout0_11 vdout0_11ck114 = 1.95 time = 1150
* CHECK dout0_12 vdout0_12ck114 = 0 time = 1150
* CHECK dout0_13 vdout0_13ck114 = 0 time = 1150
* CHECK dout0_14 vdout0_14ck114 = 1.95 time = 1150
* CHECK dout0_15 vdout0_15ck114 = 1.95 time = 1150
* CHECK dout0_16 vdout0_16ck114 = 0 time = 1150
* CHECK dout0_17 vdout0_17ck114 = 1.95 time = 1150
* CHECK dout0_18 vdout0_18ck114 = 0 time = 1150
* CHECK dout0_19 vdout0_19ck114 = 0 time = 1150
* CHECK dout0_20 vdout0_20ck114 = 0 time = 1150
* CHECK dout0_21 vdout0_21ck114 = 0 time = 1150
* CHECK dout0_22 vdout0_22ck114 = 0 time = 1150
* CHECK dout0_23 vdout0_23ck114 = 0 time = 1150
* CHECK dout0_24 vdout0_24ck114 = 1.95 time = 1150
* CHECK dout0_25 vdout0_25ck114 = 1.95 time = 1150
* CHECK dout0_26 vdout0_26ck114 = 0 time = 1150
* CHECK dout0_27 vdout0_27ck114 = 0 time = 1150
* CHECK dout0_28 vdout0_28ck114 = 1.95 time = 1150
* CHECK dout0_29 vdout0_29ck114 = 1.95 time = 1150
* CHECK dout0_30 vdout0_30ck114 = 1.95 time = 1150
* CHECK dout0_31 vdout0_31ck114 = 1.95 time = 1150
* CHECK dout1_0 vdout1_0ck115 = 0 time = 1160
* CHECK dout1_1 vdout1_1ck115 = 1.95 time = 1160
* CHECK dout1_2 vdout1_2ck115 = 0 time = 1160
* CHECK dout1_3 vdout1_3ck115 = 1.95 time = 1160
* CHECK dout1_4 vdout1_4ck115 = 1.95 time = 1160
* CHECK dout1_5 vdout1_5ck115 = 1.95 time = 1160
* CHECK dout1_6 vdout1_6ck115 = 1.95 time = 1160
* CHECK dout1_7 vdout1_7ck115 = 1.95 time = 1160
* CHECK dout1_8 vdout1_8ck115 = 1.95 time = 1160
* CHECK dout1_9 vdout1_9ck115 = 1.95 time = 1160
* CHECK dout1_10 vdout1_10ck115 = 0 time = 1160
* CHECK dout1_11 vdout1_11ck115 = 0 time = 1160
* CHECK dout1_12 vdout1_12ck115 = 0 time = 1160
* CHECK dout1_13 vdout1_13ck115 = 1.95 time = 1160
* CHECK dout1_14 vdout1_14ck115 = 0 time = 1160
* CHECK dout1_15 vdout1_15ck115 = 0 time = 1160
* CHECK dout1_16 vdout1_16ck115 = 1.95 time = 1160
* CHECK dout1_17 vdout1_17ck115 = 0 time = 1160
* CHECK dout1_18 vdout1_18ck115 = 0 time = 1160
* CHECK dout1_19 vdout1_19ck115 = 1.95 time = 1160
* CHECK dout1_20 vdout1_20ck115 = 0 time = 1160
* CHECK dout1_21 vdout1_21ck115 = 1.95 time = 1160
* CHECK dout1_22 vdout1_22ck115 = 1.95 time = 1160
* CHECK dout1_23 vdout1_23ck115 = 0 time = 1160
* CHECK dout1_24 vdout1_24ck115 = 1.95 time = 1160
* CHECK dout1_25 vdout1_25ck115 = 1.95 time = 1160
* CHECK dout1_26 vdout1_26ck115 = 1.95 time = 1160
* CHECK dout1_27 vdout1_27ck115 = 0 time = 1160
* CHECK dout1_28 vdout1_28ck115 = 1.95 time = 1160
* CHECK dout1_29 vdout1_29ck115 = 1.95 time = 1160
* CHECK dout1_30 vdout1_30ck115 = 1.95 time = 1160
* CHECK dout1_31 vdout1_31ck115 = 0 time = 1160
* CHECK dout0_0 vdout0_0ck116 = 0 time = 1170
* CHECK dout0_1 vdout0_1ck116 = 0 time = 1170
* CHECK dout0_2 vdout0_2ck116 = 1.95 time = 1170
* CHECK dout0_3 vdout0_3ck116 = 0 time = 1170
* CHECK dout0_4 vdout0_4ck116 = 1.95 time = 1170
* CHECK dout0_5 vdout0_5ck116 = 0 time = 1170
* CHECK dout0_6 vdout0_6ck116 = 1.95 time = 1170
* CHECK dout0_7 vdout0_7ck116 = 0 time = 1170
* CHECK dout0_8 vdout0_8ck116 = 1.95 time = 1170
* CHECK dout0_9 vdout0_9ck116 = 1.95 time = 1170
* CHECK dout0_10 vdout0_10ck116 = 0 time = 1170
* CHECK dout0_11 vdout0_11ck116 = 1.95 time = 1170
* CHECK dout0_12 vdout0_12ck116 = 1.95 time = 1170
* CHECK dout0_13 vdout0_13ck116 = 1.95 time = 1170
* CHECK dout0_14 vdout0_14ck116 = 0 time = 1170
* CHECK dout0_15 vdout0_15ck116 = 0 time = 1170
* CHECK dout0_16 vdout0_16ck116 = 1.95 time = 1170
* CHECK dout0_17 vdout0_17ck116 = 0 time = 1170
* CHECK dout0_18 vdout0_18ck116 = 0 time = 1170
* CHECK dout0_19 vdout0_19ck116 = 1.95 time = 1170
* CHECK dout0_20 vdout0_20ck116 = 1.95 time = 1170
* CHECK dout0_21 vdout0_21ck116 = 1.95 time = 1170
* CHECK dout0_22 vdout0_22ck116 = 1.95 time = 1170
* CHECK dout0_23 vdout0_23ck116 = 0 time = 1170
* CHECK dout0_24 vdout0_24ck116 = 0 time = 1170
* CHECK dout0_25 vdout0_25ck116 = 1.95 time = 1170
* CHECK dout0_26 vdout0_26ck116 = 0 time = 1170
* CHECK dout0_27 vdout0_27ck116 = 0 time = 1170
* CHECK dout0_28 vdout0_28ck116 = 0 time = 1170
* CHECK dout0_29 vdout0_29ck116 = 0 time = 1170
* CHECK dout0_30 vdout0_30ck116 = 1.95 time = 1170
* CHECK dout0_31 vdout0_31ck116 = 0 time = 1170
* CHECK dout1_0 vdout1_0ck116 = 0 time = 1170
* CHECK dout1_1 vdout1_1ck116 = 1.95 time = 1170
* CHECK dout1_2 vdout1_2ck116 = 0 time = 1170
* CHECK dout1_3 vdout1_3ck116 = 1.95 time = 1170
* CHECK dout1_4 vdout1_4ck116 = 1.95 time = 1170
* CHECK dout1_5 vdout1_5ck116 = 1.95 time = 1170
* CHECK dout1_6 vdout1_6ck116 = 1.95 time = 1170
* CHECK dout1_7 vdout1_7ck116 = 1.95 time = 1170
* CHECK dout1_8 vdout1_8ck116 = 1.95 time = 1170
* CHECK dout1_9 vdout1_9ck116 = 1.95 time = 1170
* CHECK dout1_10 vdout1_10ck116 = 0 time = 1170
* CHECK dout1_11 vdout1_11ck116 = 0 time = 1170
* CHECK dout1_12 vdout1_12ck116 = 0 time = 1170
* CHECK dout1_13 vdout1_13ck116 = 1.95 time = 1170
* CHECK dout1_14 vdout1_14ck116 = 0 time = 1170
* CHECK dout1_15 vdout1_15ck116 = 0 time = 1170
* CHECK dout1_16 vdout1_16ck116 = 1.95 time = 1170
* CHECK dout1_17 vdout1_17ck116 = 0 time = 1170
* CHECK dout1_18 vdout1_18ck116 = 0 time = 1170
* CHECK dout1_19 vdout1_19ck116 = 1.95 time = 1170
* CHECK dout1_20 vdout1_20ck116 = 0 time = 1170
* CHECK dout1_21 vdout1_21ck116 = 1.95 time = 1170
* CHECK dout1_22 vdout1_22ck116 = 1.95 time = 1170
* CHECK dout1_23 vdout1_23ck116 = 0 time = 1170
* CHECK dout1_24 vdout1_24ck116 = 1.95 time = 1170
* CHECK dout1_25 vdout1_25ck116 = 1.95 time = 1170
* CHECK dout1_26 vdout1_26ck116 = 1.95 time = 1170
* CHECK dout1_27 vdout1_27ck116 = 0 time = 1170
* CHECK dout1_28 vdout1_28ck116 = 1.95 time = 1170
* CHECK dout1_29 vdout1_29ck116 = 1.95 time = 1170
* CHECK dout1_30 vdout1_30ck116 = 1.95 time = 1170
* CHECK dout1_31 vdout1_31ck116 = 0 time = 1170
* CHECK dout0_0 vdout0_0ck117 = 0 time = 1180
* CHECK dout0_1 vdout0_1ck117 = 1.95 time = 1180
* CHECK dout0_2 vdout0_2ck117 = 0 time = 1180
* CHECK dout0_3 vdout0_3ck117 = 1.95 time = 1180
* CHECK dout0_4 vdout0_4ck117 = 1.95 time = 1180
* CHECK dout0_5 vdout0_5ck117 = 1.95 time = 1180
* CHECK dout0_6 vdout0_6ck117 = 1.95 time = 1180
* CHECK dout0_7 vdout0_7ck117 = 1.95 time = 1180
* CHECK dout0_8 vdout0_8ck117 = 1.95 time = 1180
* CHECK dout0_9 vdout0_9ck117 = 1.95 time = 1180
* CHECK dout0_10 vdout0_10ck117 = 0 time = 1180
* CHECK dout0_11 vdout0_11ck117 = 0 time = 1180
* CHECK dout0_12 vdout0_12ck117 = 0 time = 1180
* CHECK dout0_13 vdout0_13ck117 = 1.95 time = 1180
* CHECK dout0_14 vdout0_14ck117 = 0 time = 1180
* CHECK dout0_15 vdout0_15ck117 = 0 time = 1180
* CHECK dout0_16 vdout0_16ck117 = 1.95 time = 1180
* CHECK dout0_17 vdout0_17ck117 = 0 time = 1180
* CHECK dout0_18 vdout0_18ck117 = 0 time = 1180
* CHECK dout0_19 vdout0_19ck117 = 1.95 time = 1180
* CHECK dout0_20 vdout0_20ck117 = 0 time = 1180
* CHECK dout0_21 vdout0_21ck117 = 1.95 time = 1180
* CHECK dout0_22 vdout0_22ck117 = 1.95 time = 1180
* CHECK dout0_23 vdout0_23ck117 = 0 time = 1180
* CHECK dout0_24 vdout0_24ck117 = 1.95 time = 1180
* CHECK dout0_25 vdout0_25ck117 = 1.95 time = 1180
* CHECK dout0_26 vdout0_26ck117 = 1.95 time = 1180
* CHECK dout0_27 vdout0_27ck117 = 0 time = 1180
* CHECK dout0_28 vdout0_28ck117 = 1.95 time = 1180
* CHECK dout0_29 vdout0_29ck117 = 1.95 time = 1180
* CHECK dout0_30 vdout0_30ck117 = 1.95 time = 1180
* CHECK dout0_31 vdout0_31ck117 = 0 time = 1180
* CHECK dout1_0 vdout1_0ck117 = 0 time = 1180
* CHECK dout1_1 vdout1_1ck117 = 1.95 time = 1180
* CHECK dout1_2 vdout1_2ck117 = 0 time = 1180
* CHECK dout1_3 vdout1_3ck117 = 1.95 time = 1180
* CHECK dout1_4 vdout1_4ck117 = 0 time = 1180
* CHECK dout1_5 vdout1_5ck117 = 1.95 time = 1180
* CHECK dout1_6 vdout1_6ck117 = 1.95 time = 1180
* CHECK dout1_7 vdout1_7ck117 = 1.95 time = 1180
* CHECK dout1_8 vdout1_8ck117 = 0 time = 1180
* CHECK dout1_9 vdout1_9ck117 = 1.95 time = 1180
* CHECK dout1_10 vdout1_10ck117 = 1.95 time = 1180
* CHECK dout1_11 vdout1_11ck117 = 0 time = 1180
* CHECK dout1_12 vdout1_12ck117 = 0 time = 1180
* CHECK dout1_13 vdout1_13ck117 = 0 time = 1180
* CHECK dout1_14 vdout1_14ck117 = 0 time = 1180
* CHECK dout1_15 vdout1_15ck117 = 1.95 time = 1180
* CHECK dout1_16 vdout1_16ck117 = 0 time = 1180
* CHECK dout1_17 vdout1_17ck117 = 0 time = 1180
* CHECK dout1_18 vdout1_18ck117 = 0 time = 1180
* CHECK dout1_19 vdout1_19ck117 = 1.95 time = 1180
* CHECK dout1_20 vdout1_20ck117 = 0 time = 1180
* CHECK dout1_21 vdout1_21ck117 = 1.95 time = 1180
* CHECK dout1_22 vdout1_22ck117 = 0 time = 1180
* CHECK dout1_23 vdout1_23ck117 = 1.95 time = 1180
* CHECK dout1_24 vdout1_24ck117 = 1.95 time = 1180
* CHECK dout1_25 vdout1_25ck117 = 0 time = 1180
* CHECK dout1_26 vdout1_26ck117 = 1.95 time = 1180
* CHECK dout1_27 vdout1_27ck117 = 0 time = 1180
* CHECK dout1_28 vdout1_28ck117 = 1.95 time = 1180
* CHECK dout1_29 vdout1_29ck117 = 1.95 time = 1180
* CHECK dout1_30 vdout1_30ck117 = 0 time = 1180
* CHECK dout1_31 vdout1_31ck117 = 0 time = 1180
* CHECK dout1_0 vdout1_0ck118 = 0 time = 1190
* CHECK dout1_1 vdout1_1ck118 = 1.95 time = 1190
* CHECK dout1_2 vdout1_2ck118 = 0 time = 1190
* CHECK dout1_3 vdout1_3ck118 = 1.95 time = 1190
* CHECK dout1_4 vdout1_4ck118 = 1.95 time = 1190
* CHECK dout1_5 vdout1_5ck118 = 1.95 time = 1190
* CHECK dout1_6 vdout1_6ck118 = 1.95 time = 1190
* CHECK dout1_7 vdout1_7ck118 = 1.95 time = 1190
* CHECK dout1_8 vdout1_8ck118 = 1.95 time = 1190
* CHECK dout1_9 vdout1_9ck118 = 1.95 time = 1190
* CHECK dout1_10 vdout1_10ck118 = 0 time = 1190
* CHECK dout1_11 vdout1_11ck118 = 0 time = 1190
* CHECK dout1_12 vdout1_12ck118 = 0 time = 1190
* CHECK dout1_13 vdout1_13ck118 = 1.95 time = 1190
* CHECK dout1_14 vdout1_14ck118 = 0 time = 1190
* CHECK dout1_15 vdout1_15ck118 = 0 time = 1190
* CHECK dout1_16 vdout1_16ck118 = 1.95 time = 1190
* CHECK dout1_17 vdout1_17ck118 = 0 time = 1190
* CHECK dout1_18 vdout1_18ck118 = 0 time = 1190
* CHECK dout1_19 vdout1_19ck118 = 1.95 time = 1190
* CHECK dout1_20 vdout1_20ck118 = 0 time = 1190
* CHECK dout1_21 vdout1_21ck118 = 1.95 time = 1190
* CHECK dout1_22 vdout1_22ck118 = 1.95 time = 1190
* CHECK dout1_23 vdout1_23ck118 = 0 time = 1190
* CHECK dout1_24 vdout1_24ck118 = 1.95 time = 1190
* CHECK dout1_25 vdout1_25ck118 = 1.95 time = 1190
* CHECK dout1_26 vdout1_26ck118 = 1.95 time = 1190
* CHECK dout1_27 vdout1_27ck118 = 0 time = 1190
* CHECK dout1_28 vdout1_28ck118 = 1.95 time = 1190
* CHECK dout1_29 vdout1_29ck118 = 1.95 time = 1190
* CHECK dout1_30 vdout1_30ck118 = 1.95 time = 1190
* CHECK dout1_31 vdout1_31ck118 = 0 time = 1190
* CHECK dout0_0 vdout0_0ck119 = 0 time = 1200
* CHECK dout0_1 vdout0_1ck119 = 0 time = 1200
* CHECK dout0_2 vdout0_2ck119 = 1.95 time = 1200
* CHECK dout0_3 vdout0_3ck119 = 0 time = 1200
* CHECK dout0_4 vdout0_4ck119 = 1.95 time = 1200
* CHECK dout0_5 vdout0_5ck119 = 0 time = 1200
* CHECK dout0_6 vdout0_6ck119 = 1.95 time = 1200
* CHECK dout0_7 vdout0_7ck119 = 0 time = 1200
* CHECK dout0_8 vdout0_8ck119 = 1.95 time = 1200
* CHECK dout0_9 vdout0_9ck119 = 1.95 time = 1200
* CHECK dout0_10 vdout0_10ck119 = 0 time = 1200
* CHECK dout0_11 vdout0_11ck119 = 1.95 time = 1200
* CHECK dout0_12 vdout0_12ck119 = 1.95 time = 1200
* CHECK dout0_13 vdout0_13ck119 = 1.95 time = 1200
* CHECK dout0_14 vdout0_14ck119 = 0 time = 1200
* CHECK dout0_15 vdout0_15ck119 = 0 time = 1200
* CHECK dout0_16 vdout0_16ck119 = 1.95 time = 1200
* CHECK dout0_17 vdout0_17ck119 = 0 time = 1200
* CHECK dout0_18 vdout0_18ck119 = 0 time = 1200
* CHECK dout0_19 vdout0_19ck119 = 1.95 time = 1200
* CHECK dout0_20 vdout0_20ck119 = 1.95 time = 1200
* CHECK dout0_21 vdout0_21ck119 = 1.95 time = 1200
* CHECK dout0_22 vdout0_22ck119 = 1.95 time = 1200
* CHECK dout0_23 vdout0_23ck119 = 0 time = 1200
* CHECK dout0_24 vdout0_24ck119 = 0 time = 1200
* CHECK dout0_25 vdout0_25ck119 = 1.95 time = 1200
* CHECK dout0_26 vdout0_26ck119 = 0 time = 1200
* CHECK dout0_27 vdout0_27ck119 = 0 time = 1200
* CHECK dout0_28 vdout0_28ck119 = 0 time = 1200
* CHECK dout0_29 vdout0_29ck119 = 0 time = 1200
* CHECK dout0_30 vdout0_30ck119 = 1.95 time = 1200
* CHECK dout0_31 vdout0_31ck119 = 0 time = 1200
* CHECK dout0_0 vdout0_0ck120 = 0 time = 1210
* CHECK dout0_1 vdout0_1ck120 = 0 time = 1210
* CHECK dout0_2 vdout0_2ck120 = 1.95 time = 1210
* CHECK dout0_3 vdout0_3ck120 = 0 time = 1210
* CHECK dout0_4 vdout0_4ck120 = 1.95 time = 1210
* CHECK dout0_5 vdout0_5ck120 = 0 time = 1210
* CHECK dout0_6 vdout0_6ck120 = 1.95 time = 1210
* CHECK dout0_7 vdout0_7ck120 = 0 time = 1210
* CHECK dout0_8 vdout0_8ck120 = 1.95 time = 1210
* CHECK dout0_9 vdout0_9ck120 = 1.95 time = 1210
* CHECK dout0_10 vdout0_10ck120 = 0 time = 1210
* CHECK dout0_11 vdout0_11ck120 = 1.95 time = 1210
* CHECK dout0_12 vdout0_12ck120 = 1.95 time = 1210
* CHECK dout0_13 vdout0_13ck120 = 1.95 time = 1210
* CHECK dout0_14 vdout0_14ck120 = 0 time = 1210
* CHECK dout0_15 vdout0_15ck120 = 0 time = 1210
* CHECK dout0_16 vdout0_16ck120 = 1.95 time = 1210
* CHECK dout0_17 vdout0_17ck120 = 0 time = 1210
* CHECK dout0_18 vdout0_18ck120 = 0 time = 1210
* CHECK dout0_19 vdout0_19ck120 = 1.95 time = 1210
* CHECK dout0_20 vdout0_20ck120 = 1.95 time = 1210
* CHECK dout0_21 vdout0_21ck120 = 1.95 time = 1210
* CHECK dout0_22 vdout0_22ck120 = 1.95 time = 1210
* CHECK dout0_23 vdout0_23ck120 = 0 time = 1210
* CHECK dout0_24 vdout0_24ck120 = 0 time = 1210
* CHECK dout0_25 vdout0_25ck120 = 1.95 time = 1210
* CHECK dout0_26 vdout0_26ck120 = 0 time = 1210
* CHECK dout0_27 vdout0_27ck120 = 0 time = 1210
* CHECK dout0_28 vdout0_28ck120 = 0 time = 1210
* CHECK dout0_29 vdout0_29ck120 = 0 time = 1210
* CHECK dout0_30 vdout0_30ck120 = 1.95 time = 1210
* CHECK dout0_31 vdout0_31ck120 = 0 time = 1210
* CHECK dout1_0 vdout1_0ck120 = 0 time = 1210
* CHECK dout1_1 vdout1_1ck120 = 1.95 time = 1210
* CHECK dout1_2 vdout1_2ck120 = 1.95 time = 1210
* CHECK dout1_3 vdout1_3ck120 = 1.95 time = 1210
* CHECK dout1_4 vdout1_4ck120 = 0 time = 1210
* CHECK dout1_5 vdout1_5ck120 = 1.95 time = 1210
* CHECK dout1_6 vdout1_6ck120 = 1.95 time = 1210
* CHECK dout1_7 vdout1_7ck120 = 0 time = 1210
* CHECK dout1_8 vdout1_8ck120 = 1.95 time = 1210
* CHECK dout1_9 vdout1_9ck120 = 0 time = 1210
* CHECK dout1_10 vdout1_10ck120 = 0 time = 1210
* CHECK dout1_11 vdout1_11ck120 = 0 time = 1210
* CHECK dout1_12 vdout1_12ck120 = 1.95 time = 1210
* CHECK dout1_13 vdout1_13ck120 = 0 time = 1210
* CHECK dout1_14 vdout1_14ck120 = 0 time = 1210
* CHECK dout1_15 vdout1_15ck120 = 1.95 time = 1210
* CHECK dout1_16 vdout1_16ck120 = 0 time = 1210
* CHECK dout1_17 vdout1_17ck120 = 0 time = 1210
* CHECK dout1_18 vdout1_18ck120 = 1.95 time = 1210
* CHECK dout1_19 vdout1_19ck120 = 0 time = 1210
* CHECK dout1_20 vdout1_20ck120 = 1.95 time = 1210
* CHECK dout1_21 vdout1_21ck120 = 0 time = 1210
* CHECK dout1_22 vdout1_22ck120 = 0 time = 1210
* CHECK dout1_23 vdout1_23ck120 = 0 time = 1210
* CHECK dout1_24 vdout1_24ck120 = 0 time = 1210
* CHECK dout1_25 vdout1_25ck120 = 1.95 time = 1210
* CHECK dout1_26 vdout1_26ck120 = 0 time = 1210
* CHECK dout1_27 vdout1_27ck120 = 0 time = 1210
* CHECK dout1_28 vdout1_28ck120 = 1.95 time = 1210
* CHECK dout1_29 vdout1_29ck120 = 1.95 time = 1210
* CHECK dout1_30 vdout1_30ck120 = 0 time = 1210
* CHECK dout1_31 vdout1_31ck120 = 1.95 time = 1210
* CHECK dout1_0 vdout1_0ck121 = 0 time = 1220
* CHECK dout1_1 vdout1_1ck121 = 1.95 time = 1220
* CHECK dout1_2 vdout1_2ck121 = 1.95 time = 1220
* CHECK dout1_3 vdout1_3ck121 = 1.95 time = 1220
* CHECK dout1_4 vdout1_4ck121 = 0 time = 1220
* CHECK dout1_5 vdout1_5ck121 = 1.95 time = 1220
* CHECK dout1_6 vdout1_6ck121 = 1.95 time = 1220
* CHECK dout1_7 vdout1_7ck121 = 0 time = 1220
* CHECK dout1_8 vdout1_8ck121 = 1.95 time = 1220
* CHECK dout1_9 vdout1_9ck121 = 0 time = 1220
* CHECK dout1_10 vdout1_10ck121 = 0 time = 1220
* CHECK dout1_11 vdout1_11ck121 = 0 time = 1220
* CHECK dout1_12 vdout1_12ck121 = 1.95 time = 1220
* CHECK dout1_13 vdout1_13ck121 = 0 time = 1220
* CHECK dout1_14 vdout1_14ck121 = 0 time = 1220
* CHECK dout1_15 vdout1_15ck121 = 1.95 time = 1220
* CHECK dout1_16 vdout1_16ck121 = 0 time = 1220
* CHECK dout1_17 vdout1_17ck121 = 0 time = 1220
* CHECK dout1_18 vdout1_18ck121 = 1.95 time = 1220
* CHECK dout1_19 vdout1_19ck121 = 0 time = 1220
* CHECK dout1_20 vdout1_20ck121 = 1.95 time = 1220
* CHECK dout1_21 vdout1_21ck121 = 0 time = 1220
* CHECK dout1_22 vdout1_22ck121 = 0 time = 1220
* CHECK dout1_23 vdout1_23ck121 = 0 time = 1220
* CHECK dout1_24 vdout1_24ck121 = 0 time = 1220
* CHECK dout1_25 vdout1_25ck121 = 1.95 time = 1220
* CHECK dout1_26 vdout1_26ck121 = 0 time = 1220
* CHECK dout1_27 vdout1_27ck121 = 0 time = 1220
* CHECK dout1_28 vdout1_28ck121 = 1.95 time = 1220
* CHECK dout1_29 vdout1_29ck121 = 1.95 time = 1220
* CHECK dout1_30 vdout1_30ck121 = 0 time = 1220
* CHECK dout1_31 vdout1_31ck121 = 1.95 time = 1220
* CHECK dout1_0 vdout1_0ck122 = 0 time = 1230
* CHECK dout1_1 vdout1_1ck122 = 1.95 time = 1230
* CHECK dout1_2 vdout1_2ck122 = 1.95 time = 1230
* CHECK dout1_3 vdout1_3ck122 = 0 time = 1230
* CHECK dout1_4 vdout1_4ck122 = 0 time = 1230
* CHECK dout1_5 vdout1_5ck122 = 1.95 time = 1230
* CHECK dout1_6 vdout1_6ck122 = 0 time = 1230
* CHECK dout1_7 vdout1_7ck122 = 0 time = 1230
* CHECK dout1_8 vdout1_8ck122 = 1.95 time = 1230
* CHECK dout1_9 vdout1_9ck122 = 1.95 time = 1230
* CHECK dout1_10 vdout1_10ck122 = 0 time = 1230
* CHECK dout1_11 vdout1_11ck122 = 1.95 time = 1230
* CHECK dout1_12 vdout1_12ck122 = 1.95 time = 1230
* CHECK dout1_13 vdout1_13ck122 = 1.95 time = 1230
* CHECK dout1_14 vdout1_14ck122 = 0 time = 1230
* CHECK dout1_15 vdout1_15ck122 = 0 time = 1230
* CHECK dout1_16 vdout1_16ck122 = 1.95 time = 1230
* CHECK dout1_17 vdout1_17ck122 = 0 time = 1230
* CHECK dout1_18 vdout1_18ck122 = 0 time = 1230
* CHECK dout1_19 vdout1_19ck122 = 1.95 time = 1230
* CHECK dout1_20 vdout1_20ck122 = 1.95 time = 1230
* CHECK dout1_21 vdout1_21ck122 = 1.95 time = 1230
* CHECK dout1_22 vdout1_22ck122 = 1.95 time = 1230
* CHECK dout1_23 vdout1_23ck122 = 0 time = 1230
* CHECK dout1_24 vdout1_24ck122 = 0 time = 1230
* CHECK dout1_25 vdout1_25ck122 = 1.95 time = 1230
* CHECK dout1_26 vdout1_26ck122 = 0 time = 1230
* CHECK dout1_27 vdout1_27ck122 = 0 time = 1230
* CHECK dout1_28 vdout1_28ck122 = 0 time = 1230
* CHECK dout1_29 vdout1_29ck122 = 0 time = 1230
* CHECK dout1_30 vdout1_30ck122 = 1.95 time = 1230
* CHECK dout1_31 vdout1_31ck122 = 0 time = 1230
* CHECK dout1_0 vdout1_0ck123 = 0 time = 1240
* CHECK dout1_1 vdout1_1ck123 = 1.95 time = 1240
* CHECK dout1_2 vdout1_2ck123 = 0 time = 1240
* CHECK dout1_3 vdout1_3ck123 = 1.95 time = 1240
* CHECK dout1_4 vdout1_4ck123 = 1.95 time = 1240
* CHECK dout1_5 vdout1_5ck123 = 1.95 time = 1240
* CHECK dout1_6 vdout1_6ck123 = 1.95 time = 1240
* CHECK dout1_7 vdout1_7ck123 = 1.95 time = 1240
* CHECK dout1_8 vdout1_8ck123 = 1.95 time = 1240
* CHECK dout1_9 vdout1_9ck123 = 1.95 time = 1240
* CHECK dout1_10 vdout1_10ck123 = 0 time = 1240
* CHECK dout1_11 vdout1_11ck123 = 0 time = 1240
* CHECK dout1_12 vdout1_12ck123 = 0 time = 1240
* CHECK dout1_13 vdout1_13ck123 = 1.95 time = 1240
* CHECK dout1_14 vdout1_14ck123 = 0 time = 1240
* CHECK dout1_15 vdout1_15ck123 = 0 time = 1240
* CHECK dout1_16 vdout1_16ck123 = 1.95 time = 1240
* CHECK dout1_17 vdout1_17ck123 = 0 time = 1240
* CHECK dout1_18 vdout1_18ck123 = 0 time = 1240
* CHECK dout1_19 vdout1_19ck123 = 1.95 time = 1240
* CHECK dout1_20 vdout1_20ck123 = 0 time = 1240
* CHECK dout1_21 vdout1_21ck123 = 1.95 time = 1240
* CHECK dout1_22 vdout1_22ck123 = 1.95 time = 1240
* CHECK dout1_23 vdout1_23ck123 = 0 time = 1240
* CHECK dout1_24 vdout1_24ck123 = 1.95 time = 1240
* CHECK dout1_25 vdout1_25ck123 = 1.95 time = 1240
* CHECK dout1_26 vdout1_26ck123 = 1.95 time = 1240
* CHECK dout1_27 vdout1_27ck123 = 0 time = 1240
* CHECK dout1_28 vdout1_28ck123 = 1.95 time = 1240
* CHECK dout1_29 vdout1_29ck123 = 1.95 time = 1240
* CHECK dout1_30 vdout1_30ck123 = 1.95 time = 1240
* CHECK dout1_31 vdout1_31ck123 = 0 time = 1240
* CHECK dout1_0 vdout1_0ck124 = 0 time = 1250
* CHECK dout1_1 vdout1_1ck124 = 1.95 time = 1250
* CHECK dout1_2 vdout1_2ck124 = 1.95 time = 1250
* CHECK dout1_3 vdout1_3ck124 = 0 time = 1250
* CHECK dout1_4 vdout1_4ck124 = 1.95 time = 1250
* CHECK dout1_5 vdout1_5ck124 = 0 time = 1250
* CHECK dout1_6 vdout1_6ck124 = 1.95 time = 1250
* CHECK dout1_7 vdout1_7ck124 = 1.95 time = 1250
* CHECK dout1_8 vdout1_8ck124 = 1.95 time = 1250
* CHECK dout1_9 vdout1_9ck124 = 1.95 time = 1250
* CHECK dout1_10 vdout1_10ck124 = 1.95 time = 1250
* CHECK dout1_11 vdout1_11ck124 = 1.95 time = 1250
* CHECK dout1_12 vdout1_12ck124 = 0 time = 1250
* CHECK dout1_13 vdout1_13ck124 = 0 time = 1250
* CHECK dout1_14 vdout1_14ck124 = 1.95 time = 1250
* CHECK dout1_15 vdout1_15ck124 = 1.95 time = 1250
* CHECK dout1_16 vdout1_16ck124 = 1.95 time = 1250
* CHECK dout1_17 vdout1_17ck124 = 1.95 time = 1250
* CHECK dout1_18 vdout1_18ck124 = 1.95 time = 1250
* CHECK dout1_19 vdout1_19ck124 = 0 time = 1250
* CHECK dout1_20 vdout1_20ck124 = 1.95 time = 1250
* CHECK dout1_21 vdout1_21ck124 = 0 time = 1250
* CHECK dout1_22 vdout1_22ck124 = 1.95 time = 1250
* CHECK dout1_23 vdout1_23ck124 = 0 time = 1250
* CHECK dout1_24 vdout1_24ck124 = 1.95 time = 1250
* CHECK dout1_25 vdout1_25ck124 = 1.95 time = 1250
* CHECK dout1_26 vdout1_26ck124 = 0 time = 1250
* CHECK dout1_27 vdout1_27ck124 = 1.95 time = 1250
* CHECK dout1_28 vdout1_28ck124 = 0 time = 1250
* CHECK dout1_29 vdout1_29ck124 = 0 time = 1250
* CHECK dout1_30 vdout1_30ck124 = 1.95 time = 1250
* CHECK dout1_31 vdout1_31ck124 = 0 time = 1250
* CHECK dout1_0 vdout1_0ck125 = 0 time = 1260
* CHECK dout1_1 vdout1_1ck125 = 1.95 time = 1260
* CHECK dout1_2 vdout1_2ck125 = 1.95 time = 1260
* CHECK dout1_3 vdout1_3ck125 = 1.95 time = 1260
* CHECK dout1_4 vdout1_4ck125 = 0 time = 1260
* CHECK dout1_5 vdout1_5ck125 = 1.95 time = 1260
* CHECK dout1_6 vdout1_6ck125 = 1.95 time = 1260
* CHECK dout1_7 vdout1_7ck125 = 0 time = 1260
* CHECK dout1_8 vdout1_8ck125 = 1.95 time = 1260
* CHECK dout1_9 vdout1_9ck125 = 0 time = 1260
* CHECK dout1_10 vdout1_10ck125 = 0 time = 1260
* CHECK dout1_11 vdout1_11ck125 = 0 time = 1260
* CHECK dout1_12 vdout1_12ck125 = 1.95 time = 1260
* CHECK dout1_13 vdout1_13ck125 = 0 time = 1260
* CHECK dout1_14 vdout1_14ck125 = 0 time = 1260
* CHECK dout1_15 vdout1_15ck125 = 1.95 time = 1260
* CHECK dout1_16 vdout1_16ck125 = 0 time = 1260
* CHECK dout1_17 vdout1_17ck125 = 0 time = 1260
* CHECK dout1_18 vdout1_18ck125 = 0 time = 1260
* CHECK dout1_19 vdout1_19ck125 = 1.95 time = 1260
* CHECK dout1_20 vdout1_20ck125 = 0 time = 1260
* CHECK dout1_21 vdout1_21ck125 = 0 time = 1260
* CHECK dout1_22 vdout1_22ck125 = 1.95 time = 1260
* CHECK dout1_23 vdout1_23ck125 = 0 time = 1260
* CHECK dout1_24 vdout1_24ck125 = 0 time = 1260
* CHECK dout1_25 vdout1_25ck125 = 1.95 time = 1260
* CHECK dout1_26 vdout1_26ck125 = 0 time = 1260
* CHECK dout1_27 vdout1_27ck125 = 0 time = 1260
* CHECK dout1_28 vdout1_28ck125 = 1.95 time = 1260
* CHECK dout1_29 vdout1_29ck125 = 1.95 time = 1260
* CHECK dout1_30 vdout1_30ck125 = 0 time = 1260
* CHECK dout1_31 vdout1_31ck125 = 1.95 time = 1260
* CHECK dout1_0 vdout1_0ck126 = 0 time = 1270
* CHECK dout1_1 vdout1_1ck126 = 1.95 time = 1270
* CHECK dout1_2 vdout1_2ck126 = 0 time = 1270
* CHECK dout1_3 vdout1_3ck126 = 0 time = 1270
* CHECK dout1_4 vdout1_4ck126 = 1.95 time = 1270
* CHECK dout1_5 vdout1_5ck126 = 0 time = 1270
* CHECK dout1_6 vdout1_6ck126 = 1.95 time = 1270
* CHECK dout1_7 vdout1_7ck126 = 1.95 time = 1270
* CHECK dout1_8 vdout1_8ck126 = 0 time = 1270
* CHECK dout1_9 vdout1_9ck126 = 0 time = 1270
* CHECK dout1_10 vdout1_10ck126 = 1.95 time = 1270
* CHECK dout1_11 vdout1_11ck126 = 1.95 time = 1270
* CHECK dout1_12 vdout1_12ck126 = 1.95 time = 1270
* CHECK dout1_13 vdout1_13ck126 = 1.95 time = 1270
* CHECK dout1_14 vdout1_14ck126 = 1.95 time = 1270
* CHECK dout1_15 vdout1_15ck126 = 1.95 time = 1270
* CHECK dout1_16 vdout1_16ck126 = 1.95 time = 1270
* CHECK dout1_17 vdout1_17ck126 = 1.95 time = 1270
* CHECK dout1_18 vdout1_18ck126 = 1.95 time = 1270
* CHECK dout1_19 vdout1_19ck126 = 0 time = 1270
* CHECK dout1_20 vdout1_20ck126 = 1.95 time = 1270
* CHECK dout1_21 vdout1_21ck126 = 0 time = 1270
* CHECK dout1_22 vdout1_22ck126 = 1.95 time = 1270
* CHECK dout1_23 vdout1_23ck126 = 0 time = 1270
* CHECK dout1_24 vdout1_24ck126 = 1.95 time = 1270
* CHECK dout1_25 vdout1_25ck126 = 0 time = 1270
* CHECK dout1_26 vdout1_26ck126 = 0 time = 1270
* CHECK dout1_27 vdout1_27ck126 = 0 time = 1270
* CHECK dout1_28 vdout1_28ck126 = 1.95 time = 1270
* CHECK dout1_29 vdout1_29ck126 = 1.95 time = 1270
* CHECK dout1_30 vdout1_30ck126 = 0 time = 1270
* CHECK dout1_31 vdout1_31ck126 = 0 time = 1270
* CHECK dout0_0 vdout0_0ck127 = 0 time = 1280
* CHECK dout0_1 vdout0_1ck127 = 1.95 time = 1280
* CHECK dout0_2 vdout0_2ck127 = 0 time = 1280
* CHECK dout0_3 vdout0_3ck127 = 1.95 time = 1280
* CHECK dout0_4 vdout0_4ck127 = 1.95 time = 1280
* CHECK dout0_5 vdout0_5ck127 = 1.95 time = 1280
* CHECK dout0_6 vdout0_6ck127 = 1.95 time = 1280
* CHECK dout0_7 vdout0_7ck127 = 1.95 time = 1280
* CHECK dout0_8 vdout0_8ck127 = 1.95 time = 1280
* CHECK dout0_9 vdout0_9ck127 = 1.95 time = 1280
* CHECK dout0_10 vdout0_10ck127 = 0 time = 1280
* CHECK dout0_11 vdout0_11ck127 = 0 time = 1280
* CHECK dout0_12 vdout0_12ck127 = 0 time = 1280
* CHECK dout0_13 vdout0_13ck127 = 1.95 time = 1280
* CHECK dout0_14 vdout0_14ck127 = 0 time = 1280
* CHECK dout0_15 vdout0_15ck127 = 0 time = 1280
* CHECK dout0_16 vdout0_16ck127 = 1.95 time = 1280
* CHECK dout0_17 vdout0_17ck127 = 0 time = 1280
* CHECK dout0_18 vdout0_18ck127 = 0 time = 1280
* CHECK dout0_19 vdout0_19ck127 = 1.95 time = 1280
* CHECK dout0_20 vdout0_20ck127 = 0 time = 1280
* CHECK dout0_21 vdout0_21ck127 = 1.95 time = 1280
* CHECK dout0_22 vdout0_22ck127 = 1.95 time = 1280
* CHECK dout0_23 vdout0_23ck127 = 0 time = 1280
* CHECK dout0_24 vdout0_24ck127 = 1.95 time = 1280
* CHECK dout0_25 vdout0_25ck127 = 1.95 time = 1280
* CHECK dout0_26 vdout0_26ck127 = 1.95 time = 1280
* CHECK dout0_27 vdout0_27ck127 = 0 time = 1280
* CHECK dout0_28 vdout0_28ck127 = 1.95 time = 1280
* CHECK dout0_29 vdout0_29ck127 = 1.95 time = 1280
* CHECK dout0_30 vdout0_30ck127 = 1.95 time = 1280
* CHECK dout0_31 vdout0_31ck127 = 0 time = 1280
* CHECK dout1_0 vdout1_0ck127 = 0 time = 1280
* CHECK dout1_1 vdout1_1ck127 = 1.95 time = 1280
* CHECK dout1_2 vdout1_2ck127 = 0 time = 1280
* CHECK dout1_3 vdout1_3ck127 = 0 time = 1280
* CHECK dout1_4 vdout1_4ck127 = 1.95 time = 1280
* CHECK dout1_5 vdout1_5ck127 = 0 time = 1280
* CHECK dout1_6 vdout1_6ck127 = 1.95 time = 1280
* CHECK dout1_7 vdout1_7ck127 = 1.95 time = 1280
* CHECK dout1_8 vdout1_8ck127 = 0 time = 1280
* CHECK dout1_9 vdout1_9ck127 = 0 time = 1280
* CHECK dout1_10 vdout1_10ck127 = 1.95 time = 1280
* CHECK dout1_11 vdout1_11ck127 = 1.95 time = 1280
* CHECK dout1_12 vdout1_12ck127 = 1.95 time = 1280
* CHECK dout1_13 vdout1_13ck127 = 1.95 time = 1280
* CHECK dout1_14 vdout1_14ck127 = 1.95 time = 1280
* CHECK dout1_15 vdout1_15ck127 = 1.95 time = 1280
* CHECK dout1_16 vdout1_16ck127 = 1.95 time = 1280
* CHECK dout1_17 vdout1_17ck127 = 1.95 time = 1280
* CHECK dout1_18 vdout1_18ck127 = 1.95 time = 1280
* CHECK dout1_19 vdout1_19ck127 = 0 time = 1280
* CHECK dout1_20 vdout1_20ck127 = 1.95 time = 1280
* CHECK dout1_21 vdout1_21ck127 = 0 time = 1280
* CHECK dout1_22 vdout1_22ck127 = 1.95 time = 1280
* CHECK dout1_23 vdout1_23ck127 = 0 time = 1280
* CHECK dout1_24 vdout1_24ck127 = 1.95 time = 1280
* CHECK dout1_25 vdout1_25ck127 = 0 time = 1280
* CHECK dout1_26 vdout1_26ck127 = 0 time = 1280
* CHECK dout1_27 vdout1_27ck127 = 0 time = 1280
* CHECK dout1_28 vdout1_28ck127 = 1.95 time = 1280
* CHECK dout1_29 vdout1_29ck127 = 1.95 time = 1280
* CHECK dout1_30 vdout1_30ck127 = 0 time = 1280
* CHECK dout1_31 vdout1_31ck127 = 0 time = 1280
* CHECK dout0_0 vdout0_0ck128 = 0 time = 1290
* CHECK dout0_1 vdout0_1ck128 = 1.95 time = 1290
* CHECK dout0_2 vdout0_2ck128 = 0 time = 1290
* CHECK dout0_3 vdout0_3ck128 = 1.95 time = 1290
* CHECK dout0_4 vdout0_4ck128 = 1.95 time = 1290
* CHECK dout0_5 vdout0_5ck128 = 1.95 time = 1290
* CHECK dout0_6 vdout0_6ck128 = 1.95 time = 1290
* CHECK dout0_7 vdout0_7ck128 = 1.95 time = 1290
* CHECK dout0_8 vdout0_8ck128 = 1.95 time = 1290
* CHECK dout0_9 vdout0_9ck128 = 1.95 time = 1290
* CHECK dout0_10 vdout0_10ck128 = 0 time = 1290
* CHECK dout0_11 vdout0_11ck128 = 0 time = 1290
* CHECK dout0_12 vdout0_12ck128 = 0 time = 1290
* CHECK dout0_13 vdout0_13ck128 = 1.95 time = 1290
* CHECK dout0_14 vdout0_14ck128 = 0 time = 1290
* CHECK dout0_15 vdout0_15ck128 = 0 time = 1290
* CHECK dout0_16 vdout0_16ck128 = 1.95 time = 1290
* CHECK dout0_17 vdout0_17ck128 = 0 time = 1290
* CHECK dout0_18 vdout0_18ck128 = 0 time = 1290
* CHECK dout0_19 vdout0_19ck128 = 1.95 time = 1290
* CHECK dout0_20 vdout0_20ck128 = 0 time = 1290
* CHECK dout0_21 vdout0_21ck128 = 1.95 time = 1290
* CHECK dout0_22 vdout0_22ck128 = 1.95 time = 1290
* CHECK dout0_23 vdout0_23ck128 = 0 time = 1290
* CHECK dout0_24 vdout0_24ck128 = 1.95 time = 1290
* CHECK dout0_25 vdout0_25ck128 = 1.95 time = 1290
* CHECK dout0_26 vdout0_26ck128 = 1.95 time = 1290
* CHECK dout0_27 vdout0_27ck128 = 0 time = 1290
* CHECK dout0_28 vdout0_28ck128 = 1.95 time = 1290
* CHECK dout0_29 vdout0_29ck128 = 1.95 time = 1290
* CHECK dout0_30 vdout0_30ck128 = 1.95 time = 1290
* CHECK dout0_31 vdout0_31ck128 = 0 time = 1290
* CHECK dout1_0 vdout1_0ck128 = 0 time = 1290
* CHECK dout1_1 vdout1_1ck128 = 1.95 time = 1290
* CHECK dout1_2 vdout1_2ck128 = 1.95 time = 1290
* CHECK dout1_3 vdout1_3ck128 = 1.95 time = 1290
* CHECK dout1_4 vdout1_4ck128 = 0 time = 1290
* CHECK dout1_5 vdout1_5ck128 = 1.95 time = 1290
* CHECK dout1_6 vdout1_6ck128 = 1.95 time = 1290
* CHECK dout1_7 vdout1_7ck128 = 0 time = 1290
* CHECK dout1_8 vdout1_8ck128 = 1.95 time = 1290
* CHECK dout1_9 vdout1_9ck128 = 0 time = 1290
* CHECK dout1_10 vdout1_10ck128 = 0 time = 1290
* CHECK dout1_11 vdout1_11ck128 = 0 time = 1290
* CHECK dout1_12 vdout1_12ck128 = 1.95 time = 1290
* CHECK dout1_13 vdout1_13ck128 = 0 time = 1290
* CHECK dout1_14 vdout1_14ck128 = 0 time = 1290
* CHECK dout1_15 vdout1_15ck128 = 1.95 time = 1290
* CHECK dout1_16 vdout1_16ck128 = 0 time = 1290
* CHECK dout1_17 vdout1_17ck128 = 0 time = 1290
* CHECK dout1_18 vdout1_18ck128 = 0 time = 1290
* CHECK dout1_19 vdout1_19ck128 = 1.95 time = 1290
* CHECK dout1_20 vdout1_20ck128 = 0 time = 1290
* CHECK dout1_21 vdout1_21ck128 = 0 time = 1290
* CHECK dout1_22 vdout1_22ck128 = 1.95 time = 1290
* CHECK dout1_23 vdout1_23ck128 = 0 time = 1290
* CHECK dout1_24 vdout1_24ck128 = 0 time = 1290
* CHECK dout1_25 vdout1_25ck128 = 1.95 time = 1290
* CHECK dout1_26 vdout1_26ck128 = 0 time = 1290
* CHECK dout1_27 vdout1_27ck128 = 0 time = 1290
* CHECK dout1_28 vdout1_28ck128 = 1.95 time = 1290
* CHECK dout1_29 vdout1_29ck128 = 1.95 time = 1290
* CHECK dout1_30 vdout1_30ck128 = 0 time = 1290
* CHECK dout1_31 vdout1_31ck128 = 1.95 time = 1290
* CHECK dout0_0 vdout0_0ck130 = 0 time = 1310
* CHECK dout0_1 vdout0_1ck130 = 1.95 time = 1310
* CHECK dout0_2 vdout0_2ck130 = 1.95 time = 1310
* CHECK dout0_3 vdout0_3ck130 = 0 time = 1310
* CHECK dout0_4 vdout0_4ck130 = 1.95 time = 1310
* CHECK dout0_5 vdout0_5ck130 = 1.95 time = 1310
* CHECK dout0_6 vdout0_6ck130 = 0 time = 1310
* CHECK dout0_7 vdout0_7ck130 = 1.95 time = 1310
* CHECK dout0_8 vdout0_8ck130 = 0 time = 1310
* CHECK dout0_9 vdout0_9ck130 = 0 time = 1310
* CHECK dout0_10 vdout0_10ck130 = 0 time = 1310
* CHECK dout0_11 vdout0_11ck130 = 1.95 time = 1310
* CHECK dout0_12 vdout0_12ck130 = 1.95 time = 1310
* CHECK dout0_13 vdout0_13ck130 = 0 time = 1310
* CHECK dout0_14 vdout0_14ck130 = 1.95 time = 1310
* CHECK dout0_15 vdout0_15ck130 = 0 time = 1310
* CHECK dout0_16 vdout0_16ck130 = 0 time = 1310
* CHECK dout0_17 vdout0_17ck130 = 0 time = 1310
* CHECK dout0_18 vdout0_18ck130 = 0 time = 1310
* CHECK dout0_19 vdout0_19ck130 = 0 time = 1310
* CHECK dout0_20 vdout0_20ck130 = 0 time = 1310
* CHECK dout0_21 vdout0_21ck130 = 0 time = 1310
* CHECK dout0_22 vdout0_22ck130 = 1.95 time = 1310
* CHECK dout0_23 vdout0_23ck130 = 0 time = 1310
* CHECK dout0_24 vdout0_24ck130 = 1.95 time = 1310
* CHECK dout0_25 vdout0_25ck130 = 0 time = 1310
* CHECK dout0_26 vdout0_26ck130 = 0 time = 1310
* CHECK dout0_27 vdout0_27ck130 = 1.95 time = 1310
* CHECK dout0_28 vdout0_28ck130 = 0 time = 1310
* CHECK dout0_29 vdout0_29ck130 = 0 time = 1310
* CHECK dout0_30 vdout0_30ck130 = 1.95 time = 1310
* CHECK dout0_31 vdout0_31ck130 = 1.95 time = 1310
* CHECK dout1_0 vdout1_0ck130 = 0 time = 1310
* CHECK dout1_1 vdout1_1ck130 = 1.95 time = 1310
* CHECK dout1_2 vdout1_2ck130 = 0 time = 1310
* CHECK dout1_3 vdout1_3ck130 = 1.95 time = 1310
* CHECK dout1_4 vdout1_4ck130 = 1.95 time = 1310
* CHECK dout1_5 vdout1_5ck130 = 1.95 time = 1310
* CHECK dout1_6 vdout1_6ck130 = 1.95 time = 1310
* CHECK dout1_7 vdout1_7ck130 = 1.95 time = 1310
* CHECK dout1_8 vdout1_8ck130 = 1.95 time = 1310
* CHECK dout1_9 vdout1_9ck130 = 1.95 time = 1310
* CHECK dout1_10 vdout1_10ck130 = 0 time = 1310
* CHECK dout1_11 vdout1_11ck130 = 0 time = 1310
* CHECK dout1_12 vdout1_12ck130 = 0 time = 1310
* CHECK dout1_13 vdout1_13ck130 = 1.95 time = 1310
* CHECK dout1_14 vdout1_14ck130 = 0 time = 1310
* CHECK dout1_15 vdout1_15ck130 = 0 time = 1310
* CHECK dout1_16 vdout1_16ck130 = 1.95 time = 1310
* CHECK dout1_17 vdout1_17ck130 = 0 time = 1310
* CHECK dout1_18 vdout1_18ck130 = 0 time = 1310
* CHECK dout1_19 vdout1_19ck130 = 1.95 time = 1310
* CHECK dout1_20 vdout1_20ck130 = 0 time = 1310
* CHECK dout1_21 vdout1_21ck130 = 1.95 time = 1310
* CHECK dout1_22 vdout1_22ck130 = 1.95 time = 1310
* CHECK dout1_23 vdout1_23ck130 = 0 time = 1310
* CHECK dout1_24 vdout1_24ck130 = 1.95 time = 1310
* CHECK dout1_25 vdout1_25ck130 = 1.95 time = 1310
* CHECK dout1_26 vdout1_26ck130 = 1.95 time = 1310
* CHECK dout1_27 vdout1_27ck130 = 0 time = 1310
* CHECK dout1_28 vdout1_28ck130 = 1.95 time = 1310
* CHECK dout1_29 vdout1_29ck130 = 1.95 time = 1310
* CHECK dout1_30 vdout1_30ck130 = 1.95 time = 1310
* CHECK dout1_31 vdout1_31ck130 = 0 time = 1310
* CHECK dout1_0 vdout1_0ck131 = 0 time = 1320
* CHECK dout1_1 vdout1_1ck131 = 1.95 time = 1320
* CHECK dout1_2 vdout1_2ck131 = 0 time = 1320
* CHECK dout1_3 vdout1_3ck131 = 1.95 time = 1320
* CHECK dout1_4 vdout1_4ck131 = 1.95 time = 1320
* CHECK dout1_5 vdout1_5ck131 = 1.95 time = 1320
* CHECK dout1_6 vdout1_6ck131 = 1.95 time = 1320
* CHECK dout1_7 vdout1_7ck131 = 1.95 time = 1320
* CHECK dout1_8 vdout1_8ck131 = 1.95 time = 1320
* CHECK dout1_9 vdout1_9ck131 = 1.95 time = 1320
* CHECK dout1_10 vdout1_10ck131 = 0 time = 1320
* CHECK dout1_11 vdout1_11ck131 = 0 time = 1320
* CHECK dout1_12 vdout1_12ck131 = 0 time = 1320
* CHECK dout1_13 vdout1_13ck131 = 1.95 time = 1320
* CHECK dout1_14 vdout1_14ck131 = 0 time = 1320
* CHECK dout1_15 vdout1_15ck131 = 0 time = 1320
* CHECK dout1_16 vdout1_16ck131 = 1.95 time = 1320
* CHECK dout1_17 vdout1_17ck131 = 0 time = 1320
* CHECK dout1_18 vdout1_18ck131 = 0 time = 1320
* CHECK dout1_19 vdout1_19ck131 = 1.95 time = 1320
* CHECK dout1_20 vdout1_20ck131 = 0 time = 1320
* CHECK dout1_21 vdout1_21ck131 = 1.95 time = 1320
* CHECK dout1_22 vdout1_22ck131 = 1.95 time = 1320
* CHECK dout1_23 vdout1_23ck131 = 0 time = 1320
* CHECK dout1_24 vdout1_24ck131 = 1.95 time = 1320
* CHECK dout1_25 vdout1_25ck131 = 1.95 time = 1320
* CHECK dout1_26 vdout1_26ck131 = 1.95 time = 1320
* CHECK dout1_27 vdout1_27ck131 = 0 time = 1320
* CHECK dout1_28 vdout1_28ck131 = 1.95 time = 1320
* CHECK dout1_29 vdout1_29ck131 = 1.95 time = 1320
* CHECK dout1_30 vdout1_30ck131 = 1.95 time = 1320
* CHECK dout1_31 vdout1_31ck131 = 0 time = 1320
* CHECK dout1_0 vdout1_0ck132 = 0 time = 1330
* CHECK dout1_1 vdout1_1ck132 = 1.95 time = 1330
* CHECK dout1_2 vdout1_2ck132 = 1.95 time = 1330
* CHECK dout1_3 vdout1_3ck132 = 1.95 time = 1330
* CHECK dout1_4 vdout1_4ck132 = 0 time = 1330
* CHECK dout1_5 vdout1_5ck132 = 1.95 time = 1330
* CHECK dout1_6 vdout1_6ck132 = 1.95 time = 1330
* CHECK dout1_7 vdout1_7ck132 = 0 time = 1330
* CHECK dout1_8 vdout1_8ck132 = 1.95 time = 1330
* CHECK dout1_9 vdout1_9ck132 = 0 time = 1330
* CHECK dout1_10 vdout1_10ck132 = 0 time = 1330
* CHECK dout1_11 vdout1_11ck132 = 0 time = 1330
* CHECK dout1_12 vdout1_12ck132 = 1.95 time = 1330
* CHECK dout1_13 vdout1_13ck132 = 0 time = 1330
* CHECK dout1_14 vdout1_14ck132 = 0 time = 1330
* CHECK dout1_15 vdout1_15ck132 = 1.95 time = 1330
* CHECK dout1_16 vdout1_16ck132 = 0 time = 1330
* CHECK dout1_17 vdout1_17ck132 = 0 time = 1330
* CHECK dout1_18 vdout1_18ck132 = 0 time = 1330
* CHECK dout1_19 vdout1_19ck132 = 1.95 time = 1330
* CHECK dout1_20 vdout1_20ck132 = 0 time = 1330
* CHECK dout1_21 vdout1_21ck132 = 0 time = 1330
* CHECK dout1_22 vdout1_22ck132 = 1.95 time = 1330
* CHECK dout1_23 vdout1_23ck132 = 0 time = 1330
* CHECK dout1_24 vdout1_24ck132 = 0 time = 1330
* CHECK dout1_25 vdout1_25ck132 = 1.95 time = 1330
* CHECK dout1_26 vdout1_26ck132 = 0 time = 1330
* CHECK dout1_27 vdout1_27ck132 = 0 time = 1330
* CHECK dout1_28 vdout1_28ck132 = 1.95 time = 1330
* CHECK dout1_29 vdout1_29ck132 = 1.95 time = 1330
* CHECK dout1_30 vdout1_30ck132 = 0 time = 1330
* CHECK dout1_31 vdout1_31ck132 = 1.95 time = 1330
* CHECK dout0_0 vdout0_0ck135 = 0 time = 1360
* CHECK dout0_1 vdout0_1ck135 = 1.95 time = 1360
* CHECK dout0_2 vdout0_2ck135 = 1.95 time = 1360
* CHECK dout0_3 vdout0_3ck135 = 0 time = 1360
* CHECK dout0_4 vdout0_4ck135 = 1.95 time = 1360
* CHECK dout0_5 vdout0_5ck135 = 1.95 time = 1360
* CHECK dout0_6 vdout0_6ck135 = 0 time = 1360
* CHECK dout0_7 vdout0_7ck135 = 1.95 time = 1360
* CHECK dout0_8 vdout0_8ck135 = 0 time = 1360
* CHECK dout0_9 vdout0_9ck135 = 0 time = 1360
* CHECK dout0_10 vdout0_10ck135 = 0 time = 1360
* CHECK dout0_11 vdout0_11ck135 = 1.95 time = 1360
* CHECK dout0_12 vdout0_12ck135 = 1.95 time = 1360
* CHECK dout0_13 vdout0_13ck135 = 0 time = 1360
* CHECK dout0_14 vdout0_14ck135 = 1.95 time = 1360
* CHECK dout0_15 vdout0_15ck135 = 0 time = 1360
* CHECK dout0_16 vdout0_16ck135 = 0 time = 1360
* CHECK dout0_17 vdout0_17ck135 = 0 time = 1360
* CHECK dout0_18 vdout0_18ck135 = 0 time = 1360
* CHECK dout0_19 vdout0_19ck135 = 0 time = 1360
* CHECK dout0_20 vdout0_20ck135 = 0 time = 1360
* CHECK dout0_21 vdout0_21ck135 = 0 time = 1360
* CHECK dout0_22 vdout0_22ck135 = 1.95 time = 1360
* CHECK dout0_23 vdout0_23ck135 = 0 time = 1360
* CHECK dout0_24 vdout0_24ck135 = 1.95 time = 1360
* CHECK dout0_25 vdout0_25ck135 = 0 time = 1360
* CHECK dout0_26 vdout0_26ck135 = 0 time = 1360
* CHECK dout0_27 vdout0_27ck135 = 1.95 time = 1360
* CHECK dout0_28 vdout0_28ck135 = 0 time = 1360
* CHECK dout0_29 vdout0_29ck135 = 0 time = 1360
* CHECK dout0_30 vdout0_30ck135 = 1.95 time = 1360
* CHECK dout0_31 vdout0_31ck135 = 1.95 time = 1360
* CHECK dout1_0 vdout1_0ck136 = 0 time = 1370
* CHECK dout1_1 vdout1_1ck136 = 1.95 time = 1370
* CHECK dout1_2 vdout1_2ck136 = 1.95 time = 1370
* CHECK dout1_3 vdout1_3ck136 = 0 time = 1370
* CHECK dout1_4 vdout1_4ck136 = 1.95 time = 1370
* CHECK dout1_5 vdout1_5ck136 = 1.95 time = 1370
* CHECK dout1_6 vdout1_6ck136 = 0 time = 1370
* CHECK dout1_7 vdout1_7ck136 = 1.95 time = 1370
* CHECK dout1_8 vdout1_8ck136 = 0 time = 1370
* CHECK dout1_9 vdout1_9ck136 = 0 time = 1370
* CHECK dout1_10 vdout1_10ck136 = 0 time = 1370
* CHECK dout1_11 vdout1_11ck136 = 1.95 time = 1370
* CHECK dout1_12 vdout1_12ck136 = 1.95 time = 1370
* CHECK dout1_13 vdout1_13ck136 = 0 time = 1370
* CHECK dout1_14 vdout1_14ck136 = 1.95 time = 1370
* CHECK dout1_15 vdout1_15ck136 = 0 time = 1370
* CHECK dout1_16 vdout1_16ck136 = 0 time = 1370
* CHECK dout1_17 vdout1_17ck136 = 0 time = 1370
* CHECK dout1_18 vdout1_18ck136 = 0 time = 1370
* CHECK dout1_19 vdout1_19ck136 = 0 time = 1370
* CHECK dout1_20 vdout1_20ck136 = 0 time = 1370
* CHECK dout1_21 vdout1_21ck136 = 0 time = 1370
* CHECK dout1_22 vdout1_22ck136 = 1.95 time = 1370
* CHECK dout1_23 vdout1_23ck136 = 0 time = 1370
* CHECK dout1_24 vdout1_24ck136 = 1.95 time = 1370
* CHECK dout1_25 vdout1_25ck136 = 0 time = 1370
* CHECK dout1_26 vdout1_26ck136 = 0 time = 1370
* CHECK dout1_27 vdout1_27ck136 = 1.95 time = 1370
* CHECK dout1_28 vdout1_28ck136 = 0 time = 1370
* CHECK dout1_29 vdout1_29ck136 = 0 time = 1370
* CHECK dout1_30 vdout1_30ck136 = 1.95 time = 1370
* CHECK dout1_31 vdout1_31ck136 = 1.95 time = 1370
* CHECK dout0_0 vdout0_0ck137 = 0 time = 1380
* CHECK dout0_1 vdout0_1ck137 = 1.95 time = 1380
* CHECK dout0_2 vdout0_2ck137 = 0 time = 1380
* CHECK dout0_3 vdout0_3ck137 = 1.95 time = 1380
* CHECK dout0_4 vdout0_4ck137 = 1.95 time = 1380
* CHECK dout0_5 vdout0_5ck137 = 1.95 time = 1380
* CHECK dout0_6 vdout0_6ck137 = 1.95 time = 1380
* CHECK dout0_7 vdout0_7ck137 = 1.95 time = 1380
* CHECK dout0_8 vdout0_8ck137 = 1.95 time = 1380
* CHECK dout0_9 vdout0_9ck137 = 1.95 time = 1380
* CHECK dout0_10 vdout0_10ck137 = 0 time = 1380
* CHECK dout0_11 vdout0_11ck137 = 0 time = 1380
* CHECK dout0_12 vdout0_12ck137 = 0 time = 1380
* CHECK dout0_13 vdout0_13ck137 = 1.95 time = 1380
* CHECK dout0_14 vdout0_14ck137 = 0 time = 1380
* CHECK dout0_15 vdout0_15ck137 = 0 time = 1380
* CHECK dout0_16 vdout0_16ck137 = 1.95 time = 1380
* CHECK dout0_17 vdout0_17ck137 = 1.95 time = 1380
* CHECK dout0_18 vdout0_18ck137 = 0 time = 1380
* CHECK dout0_19 vdout0_19ck137 = 0 time = 1380
* CHECK dout0_20 vdout0_20ck137 = 0 time = 1380
* CHECK dout0_21 vdout0_21ck137 = 0 time = 1380
* CHECK dout0_22 vdout0_22ck137 = 0 time = 1380
* CHECK dout0_23 vdout0_23ck137 = 1.95 time = 1380
* CHECK dout0_24 vdout0_24ck137 = 1.95 time = 1380
* CHECK dout0_25 vdout0_25ck137 = 1.95 time = 1380
* CHECK dout0_26 vdout0_26ck137 = 1.95 time = 1380
* CHECK dout0_27 vdout0_27ck137 = 0 time = 1380
* CHECK dout0_28 vdout0_28ck137 = 1.95 time = 1380
* CHECK dout0_29 vdout0_29ck137 = 1.95 time = 1380
* CHECK dout0_30 vdout0_30ck137 = 1.95 time = 1380
* CHECK dout0_31 vdout0_31ck137 = 0 time = 1380
* CHECK dout1_0 vdout1_0ck137 = 0 time = 1380
* CHECK dout1_1 vdout1_1ck137 = 1.95 time = 1380
* CHECK dout1_2 vdout1_2ck137 = 1.95 time = 1380
* CHECK dout1_3 vdout1_3ck137 = 0 time = 1380
* CHECK dout1_4 vdout1_4ck137 = 1.95 time = 1380
* CHECK dout1_5 vdout1_5ck137 = 1.95 time = 1380
* CHECK dout1_6 vdout1_6ck137 = 0 time = 1380
* CHECK dout1_7 vdout1_7ck137 = 1.95 time = 1380
* CHECK dout1_8 vdout1_8ck137 = 0 time = 1380
* CHECK dout1_9 vdout1_9ck137 = 0 time = 1380
* CHECK dout1_10 vdout1_10ck137 = 0 time = 1380
* CHECK dout1_11 vdout1_11ck137 = 1.95 time = 1380
* CHECK dout1_12 vdout1_12ck137 = 1.95 time = 1380
* CHECK dout1_13 vdout1_13ck137 = 0 time = 1380
* CHECK dout1_14 vdout1_14ck137 = 1.95 time = 1380
* CHECK dout1_15 vdout1_15ck137 = 0 time = 1380
* CHECK dout1_16 vdout1_16ck137 = 0 time = 1380
* CHECK dout1_17 vdout1_17ck137 = 0 time = 1380
* CHECK dout1_18 vdout1_18ck137 = 0 time = 1380
* CHECK dout1_19 vdout1_19ck137 = 0 time = 1380
* CHECK dout1_20 vdout1_20ck137 = 0 time = 1380
* CHECK dout1_21 vdout1_21ck137 = 0 time = 1380
* CHECK dout1_22 vdout1_22ck137 = 1.95 time = 1380
* CHECK dout1_23 vdout1_23ck137 = 0 time = 1380
* CHECK dout1_24 vdout1_24ck137 = 1.95 time = 1380
* CHECK dout1_25 vdout1_25ck137 = 0 time = 1380
* CHECK dout1_26 vdout1_26ck137 = 0 time = 1380
* CHECK dout1_27 vdout1_27ck137 = 1.95 time = 1380
* CHECK dout1_28 vdout1_28ck137 = 0 time = 1380
* CHECK dout1_29 vdout1_29ck137 = 0 time = 1380
* CHECK dout1_30 vdout1_30ck137 = 1.95 time = 1380
* CHECK dout1_31 vdout1_31ck137 = 1.95 time = 1380
* CHECK dout0_0 vdout0_0ck140 = 0 time = 1410
* CHECK dout0_1 vdout0_1ck140 = 0 time = 1410
* CHECK dout0_2 vdout0_2ck140 = 1.95 time = 1410
* CHECK dout0_3 vdout0_3ck140 = 0 time = 1410
* CHECK dout0_4 vdout0_4ck140 = 1.95 time = 1410
* CHECK dout0_5 vdout0_5ck140 = 1.95 time = 1410
* CHECK dout0_6 vdout0_6ck140 = 1.95 time = 1410
* CHECK dout0_7 vdout0_7ck140 = 0 time = 1410
* CHECK dout0_8 vdout0_8ck140 = 1.95 time = 1410
* CHECK dout0_9 vdout0_9ck140 = 0 time = 1410
* CHECK dout0_10 vdout0_10ck140 = 1.95 time = 1410
* CHECK dout0_11 vdout0_11ck140 = 0 time = 1410
* CHECK dout0_12 vdout0_12ck140 = 1.95 time = 1410
* CHECK dout0_13 vdout0_13ck140 = 0 time = 1410
* CHECK dout0_14 vdout0_14ck140 = 1.95 time = 1410
* CHECK dout0_15 vdout0_15ck140 = 0 time = 1410
* CHECK dout0_16 vdout0_16ck140 = 1.95 time = 1410
* CHECK dout0_17 vdout0_17ck140 = 1.95 time = 1410
* CHECK dout0_18 vdout0_18ck140 = 0 time = 1410
* CHECK dout0_19 vdout0_19ck140 = 0 time = 1410
* CHECK dout0_20 vdout0_20ck140 = 1.95 time = 1410
* CHECK dout0_21 vdout0_21ck140 = 0 time = 1410
* CHECK dout0_22 vdout0_22ck140 = 0 time = 1410
* CHECK dout0_23 vdout0_23ck140 = 0 time = 1410
* CHECK dout0_24 vdout0_24ck140 = 1.95 time = 1410
* CHECK dout0_25 vdout0_25ck140 = 1.95 time = 1410
* CHECK dout0_26 vdout0_26ck140 = 1.95 time = 1410
* CHECK dout0_27 vdout0_27ck140 = 1.95 time = 1410
* CHECK dout0_28 vdout0_28ck140 = 0 time = 1410
* CHECK dout0_29 vdout0_29ck140 = 0 time = 1410
* CHECK dout0_30 vdout0_30ck140 = 0 time = 1410
* CHECK dout0_31 vdout0_31ck140 = 0 time = 1410
* CHECK dout0_0 vdout0_0ck141 = 0 time = 1420
* CHECK dout0_1 vdout0_1ck141 = 1.95 time = 1420
* CHECK dout0_2 vdout0_2ck141 = 1.95 time = 1420
* CHECK dout0_3 vdout0_3ck141 = 0 time = 1420
* CHECK dout0_4 vdout0_4ck141 = 1.95 time = 1420
* CHECK dout0_5 vdout0_5ck141 = 1.95 time = 1420
* CHECK dout0_6 vdout0_6ck141 = 0 time = 1420
* CHECK dout0_7 vdout0_7ck141 = 1.95 time = 1420
* CHECK dout0_8 vdout0_8ck141 = 0 time = 1420
* CHECK dout0_9 vdout0_9ck141 = 0 time = 1420
* CHECK dout0_10 vdout0_10ck141 = 0 time = 1420
* CHECK dout0_11 vdout0_11ck141 = 1.95 time = 1420
* CHECK dout0_12 vdout0_12ck141 = 1.95 time = 1420
* CHECK dout0_13 vdout0_13ck141 = 0 time = 1420
* CHECK dout0_14 vdout0_14ck141 = 1.95 time = 1420
* CHECK dout0_15 vdout0_15ck141 = 0 time = 1420
* CHECK dout0_16 vdout0_16ck141 = 0 time = 1420
* CHECK dout0_17 vdout0_17ck141 = 0 time = 1420
* CHECK dout0_18 vdout0_18ck141 = 0 time = 1420
* CHECK dout0_19 vdout0_19ck141 = 0 time = 1420
* CHECK dout0_20 vdout0_20ck141 = 0 time = 1420
* CHECK dout0_21 vdout0_21ck141 = 0 time = 1420
* CHECK dout0_22 vdout0_22ck141 = 1.95 time = 1420
* CHECK dout0_23 vdout0_23ck141 = 0 time = 1420
* CHECK dout0_24 vdout0_24ck141 = 1.95 time = 1420
* CHECK dout0_25 vdout0_25ck141 = 0 time = 1420
* CHECK dout0_26 vdout0_26ck141 = 0 time = 1420
* CHECK dout0_27 vdout0_27ck141 = 1.95 time = 1420
* CHECK dout0_28 vdout0_28ck141 = 0 time = 1420
* CHECK dout0_29 vdout0_29ck141 = 0 time = 1420
* CHECK dout0_30 vdout0_30ck141 = 1.95 time = 1420
* CHECK dout0_31 vdout0_31ck141 = 1.95 time = 1420
* CHECK dout1_0 vdout1_0ck141 = 0 time = 1420
* CHECK dout1_1 vdout1_1ck141 = 1.95 time = 1420
* CHECK dout1_2 vdout1_2ck141 = 0 time = 1420
* CHECK dout1_3 vdout1_3ck141 = 1.95 time = 1420
* CHECK dout1_4 vdout1_4ck141 = 1.95 time = 1420
* CHECK dout1_5 vdout1_5ck141 = 1.95 time = 1420
* CHECK dout1_6 vdout1_6ck141 = 1.95 time = 1420
* CHECK dout1_7 vdout1_7ck141 = 1.95 time = 1420
* CHECK dout1_8 vdout1_8ck141 = 1.95 time = 1420
* CHECK dout1_9 vdout1_9ck141 = 1.95 time = 1420
* CHECK dout1_10 vdout1_10ck141 = 0 time = 1420
* CHECK dout1_11 vdout1_11ck141 = 0 time = 1420
* CHECK dout1_12 vdout1_12ck141 = 0 time = 1420
* CHECK dout1_13 vdout1_13ck141 = 1.95 time = 1420
* CHECK dout1_14 vdout1_14ck141 = 0 time = 1420
* CHECK dout1_15 vdout1_15ck141 = 0 time = 1420
* CHECK dout1_16 vdout1_16ck141 = 1.95 time = 1420
* CHECK dout1_17 vdout1_17ck141 = 1.95 time = 1420
* CHECK dout1_18 vdout1_18ck141 = 1.95 time = 1420
* CHECK dout1_19 vdout1_19ck141 = 1.95 time = 1420
* CHECK dout1_20 vdout1_20ck141 = 0 time = 1420
* CHECK dout1_21 vdout1_21ck141 = 1.95 time = 1420
* CHECK dout1_22 vdout1_22ck141 = 0 time = 1420
* CHECK dout1_23 vdout1_23ck141 = 0 time = 1420
* CHECK dout1_24 vdout1_24ck141 = 1.95 time = 1420
* CHECK dout1_25 vdout1_25ck141 = 1.95 time = 1420
* CHECK dout1_26 vdout1_26ck141 = 1.95 time = 1420
* CHECK dout1_27 vdout1_27ck141 = 0 time = 1420
* CHECK dout1_28 vdout1_28ck141 = 1.95 time = 1420
* CHECK dout1_29 vdout1_29ck141 = 1.95 time = 1420
* CHECK dout1_30 vdout1_30ck141 = 1.95 time = 1420
* CHECK dout1_31 vdout1_31ck141 = 0 time = 1420
* CHECK dout1_0 vdout1_0ck142 = 0 time = 1430
* CHECK dout1_1 vdout1_1ck142 = 0 time = 1430
* CHECK dout1_2 vdout1_2ck142 = 0 time = 1430
* CHECK dout1_3 vdout1_3ck142 = 0 time = 1430
* CHECK dout1_4 vdout1_4ck142 = 0 time = 1430
* CHECK dout1_5 vdout1_5ck142 = 1.95 time = 1430
* CHECK dout1_6 vdout1_6ck142 = 1.95 time = 1430
* CHECK dout1_7 vdout1_7ck142 = 1.95 time = 1430
* CHECK dout1_8 vdout1_8ck142 = 1.95 time = 1430
* CHECK dout1_9 vdout1_9ck142 = 0 time = 1430
* CHECK dout1_10 vdout1_10ck142 = 1.95 time = 1430
* CHECK dout1_11 vdout1_11ck142 = 1.95 time = 1430
* CHECK dout1_12 vdout1_12ck142 = 0 time = 1430
* CHECK dout1_13 vdout1_13ck142 = 1.95 time = 1430
* CHECK dout1_14 vdout1_14ck142 = 1.95 time = 1430
* CHECK dout1_15 vdout1_15ck142 = 1.95 time = 1430
* CHECK dout1_16 vdout1_16ck142 = 1.95 time = 1430
* CHECK dout1_17 vdout1_17ck142 = 0 time = 1430
* CHECK dout1_18 vdout1_18ck142 = 0 time = 1430
* CHECK dout1_19 vdout1_19ck142 = 1.95 time = 1430
* CHECK dout1_20 vdout1_20ck142 = 1.95 time = 1430
* CHECK dout1_21 vdout1_21ck142 = 1.95 time = 1430
* CHECK dout1_22 vdout1_22ck142 = 0 time = 1430
* CHECK dout1_23 vdout1_23ck142 = 1.95 time = 1430
* CHECK dout1_24 vdout1_24ck142 = 0 time = 1430
* CHECK dout1_25 vdout1_25ck142 = 1.95 time = 1430
* CHECK dout1_26 vdout1_26ck142 = 0 time = 1430
* CHECK dout1_27 vdout1_27ck142 = 1.95 time = 1430
* CHECK dout1_28 vdout1_28ck142 = 1.95 time = 1430
* CHECK dout1_29 vdout1_29ck142 = 1.95 time = 1430
* CHECK dout1_30 vdout1_30ck142 = 0 time = 1430
* CHECK dout1_31 vdout1_31ck142 = 1.95 time = 1430
* CHECK dout0_0 vdout0_0ck145 = 0 time = 1460
* CHECK dout0_1 vdout0_1ck145 = 0 time = 1460
* CHECK dout0_2 vdout0_2ck145 = 1.95 time = 1460
* CHECK dout0_3 vdout0_3ck145 = 0 time = 1460
* CHECK dout0_4 vdout0_4ck145 = 1.95 time = 1460
* CHECK dout0_5 vdout0_5ck145 = 1.95 time = 1460
* CHECK dout0_6 vdout0_6ck145 = 1.95 time = 1460
* CHECK dout0_7 vdout0_7ck145 = 0 time = 1460
* CHECK dout0_8 vdout0_8ck145 = 1.95 time = 1460
* CHECK dout0_9 vdout0_9ck145 = 0 time = 1460
* CHECK dout0_10 vdout0_10ck145 = 1.95 time = 1460
* CHECK dout0_11 vdout0_11ck145 = 0 time = 1460
* CHECK dout0_12 vdout0_12ck145 = 1.95 time = 1460
* CHECK dout0_13 vdout0_13ck145 = 0 time = 1460
* CHECK dout0_14 vdout0_14ck145 = 1.95 time = 1460
* CHECK dout0_15 vdout0_15ck145 = 0 time = 1460
* CHECK dout0_16 vdout0_16ck145 = 1.95 time = 1460
* CHECK dout0_17 vdout0_17ck145 = 1.95 time = 1460
* CHECK dout0_18 vdout0_18ck145 = 0 time = 1460
* CHECK dout0_19 vdout0_19ck145 = 0 time = 1460
* CHECK dout0_20 vdout0_20ck145 = 1.95 time = 1460
* CHECK dout0_21 vdout0_21ck145 = 0 time = 1460
* CHECK dout0_22 vdout0_22ck145 = 0 time = 1460
* CHECK dout0_23 vdout0_23ck145 = 0 time = 1460
* CHECK dout0_24 vdout0_24ck145 = 1.95 time = 1460
* CHECK dout0_25 vdout0_25ck145 = 1.95 time = 1460
* CHECK dout0_26 vdout0_26ck145 = 1.95 time = 1460
* CHECK dout0_27 vdout0_27ck145 = 1.95 time = 1460
* CHECK dout0_28 vdout0_28ck145 = 0 time = 1460
* CHECK dout0_29 vdout0_29ck145 = 0 time = 1460
* CHECK dout0_30 vdout0_30ck145 = 0 time = 1460
* CHECK dout0_31 vdout0_31ck145 = 0 time = 1460
* CHECK dout0_0 vdout0_0ck146 = 0 time = 1470
* CHECK dout0_1 vdout0_1ck146 = 1.95 time = 1470
* CHECK dout0_2 vdout0_2ck146 = 1.95 time = 1470
* CHECK dout0_3 vdout0_3ck146 = 0 time = 1470
* CHECK dout0_4 vdout0_4ck146 = 1.95 time = 1470
* CHECK dout0_5 vdout0_5ck146 = 1.95 time = 1470
* CHECK dout0_6 vdout0_6ck146 = 0 time = 1470
* CHECK dout0_7 vdout0_7ck146 = 1.95 time = 1470
* CHECK dout0_8 vdout0_8ck146 = 0 time = 1470
* CHECK dout0_9 vdout0_9ck146 = 0 time = 1470
* CHECK dout0_10 vdout0_10ck146 = 0 time = 1470
* CHECK dout0_11 vdout0_11ck146 = 1.95 time = 1470
* CHECK dout0_12 vdout0_12ck146 = 1.95 time = 1470
* CHECK dout0_13 vdout0_13ck146 = 0 time = 1470
* CHECK dout0_14 vdout0_14ck146 = 1.95 time = 1470
* CHECK dout0_15 vdout0_15ck146 = 0 time = 1470
* CHECK dout0_16 vdout0_16ck146 = 0 time = 1470
* CHECK dout0_17 vdout0_17ck146 = 0 time = 1470
* CHECK dout0_18 vdout0_18ck146 = 0 time = 1470
* CHECK dout0_19 vdout0_19ck146 = 0 time = 1470
* CHECK dout0_20 vdout0_20ck146 = 0 time = 1470
* CHECK dout0_21 vdout0_21ck146 = 0 time = 1470
* CHECK dout0_22 vdout0_22ck146 = 1.95 time = 1470
* CHECK dout0_23 vdout0_23ck146 = 0 time = 1470
* CHECK dout0_24 vdout0_24ck146 = 1.95 time = 1470
* CHECK dout0_25 vdout0_25ck146 = 0 time = 1470
* CHECK dout0_26 vdout0_26ck146 = 0 time = 1470
* CHECK dout0_27 vdout0_27ck146 = 1.95 time = 1470
* CHECK dout0_28 vdout0_28ck146 = 0 time = 1470
* CHECK dout0_29 vdout0_29ck146 = 0 time = 1470
* CHECK dout0_30 vdout0_30ck146 = 1.95 time = 1470
* CHECK dout0_31 vdout0_31ck146 = 1.95 time = 1470
* CHECK dout1_0 vdout1_0ck147 = 0 time = 1480
* CHECK dout1_1 vdout1_1ck147 = 0 time = 1480
* CHECK dout1_2 vdout1_2ck147 = 1.95 time = 1480
* CHECK dout1_3 vdout1_3ck147 = 0 time = 1480
* CHECK dout1_4 vdout1_4ck147 = 1.95 time = 1480
* CHECK dout1_5 vdout1_5ck147 = 1.95 time = 1480
* CHECK dout1_6 vdout1_6ck147 = 1.95 time = 1480
* CHECK dout1_7 vdout1_7ck147 = 0 time = 1480
* CHECK dout1_8 vdout1_8ck147 = 1.95 time = 1480
* CHECK dout1_9 vdout1_9ck147 = 0 time = 1480
* CHECK dout1_10 vdout1_10ck147 = 1.95 time = 1480
* CHECK dout1_11 vdout1_11ck147 = 0 time = 1480
* CHECK dout1_12 vdout1_12ck147 = 1.95 time = 1480
* CHECK dout1_13 vdout1_13ck147 = 0 time = 1480
* CHECK dout1_14 vdout1_14ck147 = 1.95 time = 1480
* CHECK dout1_15 vdout1_15ck147 = 0 time = 1480
* CHECK dout1_16 vdout1_16ck147 = 1.95 time = 1480
* CHECK dout1_17 vdout1_17ck147 = 1.95 time = 1480
* CHECK dout1_18 vdout1_18ck147 = 0 time = 1480
* CHECK dout1_19 vdout1_19ck147 = 0 time = 1480
* CHECK dout1_20 vdout1_20ck147 = 1.95 time = 1480
* CHECK dout1_21 vdout1_21ck147 = 0 time = 1480
* CHECK dout1_22 vdout1_22ck147 = 0 time = 1480
* CHECK dout1_23 vdout1_23ck147 = 0 time = 1480
* CHECK dout1_24 vdout1_24ck147 = 1.95 time = 1480
* CHECK dout1_25 vdout1_25ck147 = 1.95 time = 1480
* CHECK dout1_26 vdout1_26ck147 = 1.95 time = 1480
* CHECK dout1_27 vdout1_27ck147 = 1.95 time = 1480
* CHECK dout1_28 vdout1_28ck147 = 0 time = 1480
* CHECK dout1_29 vdout1_29ck147 = 0 time = 1480
* CHECK dout1_30 vdout1_30ck147 = 0 time = 1480
* CHECK dout1_31 vdout1_31ck147 = 0 time = 1480
* CHECK dout0_0 vdout0_0ck148 = 1.95 time = 1490
* CHECK dout0_1 vdout0_1ck148 = 0 time = 1490
* CHECK dout0_2 vdout0_2ck148 = 0 time = 1490
* CHECK dout0_3 vdout0_3ck148 = 1.95 time = 1490
* CHECK dout0_4 vdout0_4ck148 = 0 time = 1490
* CHECK dout0_5 vdout0_5ck148 = 1.95 time = 1490
* CHECK dout0_6 vdout0_6ck148 = 0 time = 1490
* CHECK dout0_7 vdout0_7ck148 = 0 time = 1490
* CHECK dout0_8 vdout0_8ck148 = 0 time = 1490
* CHECK dout0_9 vdout0_9ck148 = 1.95 time = 1490
* CHECK dout0_10 vdout0_10ck148 = 0 time = 1490
* CHECK dout0_11 vdout0_11ck148 = 0 time = 1490
* CHECK dout0_12 vdout0_12ck148 = 1.95 time = 1490
* CHECK dout0_13 vdout0_13ck148 = 1.95 time = 1490
* CHECK dout0_14 vdout0_14ck148 = 1.95 time = 1490
* CHECK dout0_15 vdout0_15ck148 = 1.95 time = 1490
* CHECK dout0_16 vdout0_16ck148 = 1.95 time = 1490
* CHECK dout0_17 vdout0_17ck148 = 0 time = 1490
* CHECK dout0_18 vdout0_18ck148 = 1.95 time = 1490
* CHECK dout0_19 vdout0_19ck148 = 1.95 time = 1490
* CHECK dout0_20 vdout0_20ck148 = 1.95 time = 1490
* CHECK dout0_21 vdout0_21ck148 = 0 time = 1490
* CHECK dout0_22 vdout0_22ck148 = 1.95 time = 1490
* CHECK dout0_23 vdout0_23ck148 = 0 time = 1490
* CHECK dout0_24 vdout0_24ck148 = 1.95 time = 1490
* CHECK dout0_25 vdout0_25ck148 = 0 time = 1490
* CHECK dout0_26 vdout0_26ck148 = 1.95 time = 1490
* CHECK dout0_27 vdout0_27ck148 = 1.95 time = 1490
* CHECK dout0_28 vdout0_28ck148 = 0 time = 1490
* CHECK dout0_29 vdout0_29ck148 = 0 time = 1490
* CHECK dout0_30 vdout0_30ck148 = 1.95 time = 1490
* CHECK dout0_31 vdout0_31ck148 = 1.95 time = 1490
* CHECK dout0_0 vdout0_0ck149 = 0 time = 1500
* CHECK dout0_1 vdout0_1ck149 = 1.95 time = 1500
* CHECK dout0_2 vdout0_2ck149 = 1.95 time = 1500
* CHECK dout0_3 vdout0_3ck149 = 0 time = 1500
* CHECK dout0_4 vdout0_4ck149 = 1.95 time = 1500
* CHECK dout0_5 vdout0_5ck149 = 1.95 time = 1500
* CHECK dout0_6 vdout0_6ck149 = 0 time = 1500
* CHECK dout0_7 vdout0_7ck149 = 1.95 time = 1500
* CHECK dout0_8 vdout0_8ck149 = 0 time = 1500
* CHECK dout0_9 vdout0_9ck149 = 0 time = 1500
* CHECK dout0_10 vdout0_10ck149 = 0 time = 1500
* CHECK dout0_11 vdout0_11ck149 = 1.95 time = 1500
* CHECK dout0_12 vdout0_12ck149 = 1.95 time = 1500
* CHECK dout0_13 vdout0_13ck149 = 0 time = 1500
* CHECK dout0_14 vdout0_14ck149 = 1.95 time = 1500
* CHECK dout0_15 vdout0_15ck149 = 0 time = 1500
* CHECK dout0_16 vdout0_16ck149 = 0 time = 1500
* CHECK dout0_17 vdout0_17ck149 = 0 time = 1500
* CHECK dout0_18 vdout0_18ck149 = 0 time = 1500
* CHECK dout0_19 vdout0_19ck149 = 0 time = 1500
* CHECK dout0_20 vdout0_20ck149 = 0 time = 1500
* CHECK dout0_21 vdout0_21ck149 = 0 time = 1500
* CHECK dout0_22 vdout0_22ck149 = 1.95 time = 1500
* CHECK dout0_23 vdout0_23ck149 = 0 time = 1500
* CHECK dout0_24 vdout0_24ck149 = 1.95 time = 1500
* CHECK dout0_25 vdout0_25ck149 = 0 time = 1500
* CHECK dout0_26 vdout0_26ck149 = 0 time = 1500
* CHECK dout0_27 vdout0_27ck149 = 1.95 time = 1500
* CHECK dout0_28 vdout0_28ck149 = 0 time = 1500
* CHECK dout0_29 vdout0_29ck149 = 0 time = 1500
* CHECK dout0_30 vdout0_30ck149 = 1.95 time = 1500
* CHECK dout0_31 vdout0_31ck149 = 1.95 time = 1500
* CHECK dout0_0 vdout0_0ck150 = 1.95 time = 1510
* CHECK dout0_1 vdout0_1ck150 = 0 time = 1510
* CHECK dout0_2 vdout0_2ck150 = 0 time = 1510
* CHECK dout0_3 vdout0_3ck150 = 1.95 time = 1510
* CHECK dout0_4 vdout0_4ck150 = 0 time = 1510
* CHECK dout0_5 vdout0_5ck150 = 1.95 time = 1510
* CHECK dout0_6 vdout0_6ck150 = 0 time = 1510
* CHECK dout0_7 vdout0_7ck150 = 0 time = 1510
* CHECK dout0_8 vdout0_8ck150 = 0 time = 1510
* CHECK dout0_9 vdout0_9ck150 = 1.95 time = 1510
* CHECK dout0_10 vdout0_10ck150 = 0 time = 1510
* CHECK dout0_11 vdout0_11ck150 = 0 time = 1510
* CHECK dout0_12 vdout0_12ck150 = 1.95 time = 1510
* CHECK dout0_13 vdout0_13ck150 = 1.95 time = 1510
* CHECK dout0_14 vdout0_14ck150 = 1.95 time = 1510
* CHECK dout0_15 vdout0_15ck150 = 1.95 time = 1510
* CHECK dout0_16 vdout0_16ck150 = 1.95 time = 1510
* CHECK dout0_17 vdout0_17ck150 = 0 time = 1510
* CHECK dout0_18 vdout0_18ck150 = 1.95 time = 1510
* CHECK dout0_19 vdout0_19ck150 = 1.95 time = 1510
* CHECK dout0_20 vdout0_20ck150 = 1.95 time = 1510
* CHECK dout0_21 vdout0_21ck150 = 0 time = 1510
* CHECK dout0_22 vdout0_22ck150 = 1.95 time = 1510
* CHECK dout0_23 vdout0_23ck150 = 0 time = 1510
* CHECK dout0_24 vdout0_24ck150 = 1.95 time = 1510
* CHECK dout0_25 vdout0_25ck150 = 0 time = 1510
* CHECK dout0_26 vdout0_26ck150 = 1.95 time = 1510
* CHECK dout0_27 vdout0_27ck150 = 1.95 time = 1510
* CHECK dout0_28 vdout0_28ck150 = 0 time = 1510
* CHECK dout0_29 vdout0_29ck150 = 0 time = 1510
* CHECK dout0_30 vdout0_30ck150 = 1.95 time = 1510
* CHECK dout0_31 vdout0_31ck150 = 1.95 time = 1510
* CHECK dout0_0 vdout0_0ck151 = 0 time = 1520
* CHECK dout0_1 vdout0_1ck151 = 1.95 time = 1520
* CHECK dout0_2 vdout0_2ck151 = 1.95 time = 1520
* CHECK dout0_3 vdout0_3ck151 = 0 time = 1520
* CHECK dout0_4 vdout0_4ck151 = 1.95 time = 1520
* CHECK dout0_5 vdout0_5ck151 = 1.95 time = 1520
* CHECK dout0_6 vdout0_6ck151 = 0 time = 1520
* CHECK dout0_7 vdout0_7ck151 = 1.95 time = 1520
* CHECK dout0_8 vdout0_8ck151 = 0 time = 1520
* CHECK dout0_9 vdout0_9ck151 = 0 time = 1520
* CHECK dout0_10 vdout0_10ck151 = 0 time = 1520
* CHECK dout0_11 vdout0_11ck151 = 1.95 time = 1520
* CHECK dout0_12 vdout0_12ck151 = 1.95 time = 1520
* CHECK dout0_13 vdout0_13ck151 = 0 time = 1520
* CHECK dout0_14 vdout0_14ck151 = 1.95 time = 1520
* CHECK dout0_15 vdout0_15ck151 = 0 time = 1520
* CHECK dout0_16 vdout0_16ck151 = 0 time = 1520
* CHECK dout0_17 vdout0_17ck151 = 0 time = 1520
* CHECK dout0_18 vdout0_18ck151 = 0 time = 1520
* CHECK dout0_19 vdout0_19ck151 = 0 time = 1520
* CHECK dout0_20 vdout0_20ck151 = 0 time = 1520
* CHECK dout0_21 vdout0_21ck151 = 0 time = 1520
* CHECK dout0_22 vdout0_22ck151 = 1.95 time = 1520
* CHECK dout0_23 vdout0_23ck151 = 0 time = 1520
* CHECK dout0_24 vdout0_24ck151 = 1.95 time = 1520
* CHECK dout0_25 vdout0_25ck151 = 0 time = 1520
* CHECK dout0_26 vdout0_26ck151 = 0 time = 1520
* CHECK dout0_27 vdout0_27ck151 = 1.95 time = 1520
* CHECK dout0_28 vdout0_28ck151 = 0 time = 1520
* CHECK dout0_29 vdout0_29ck151 = 0 time = 1520
* CHECK dout0_30 vdout0_30ck151 = 1.95 time = 1520
* CHECK dout0_31 vdout0_31ck151 = 1.95 time = 1520
* CHECK dout0_0 vdout0_0ck153 = 0 time = 1540
* CHECK dout0_1 vdout0_1ck153 = 0 time = 1540
* CHECK dout0_2 vdout0_2ck153 = 1.95 time = 1540
* CHECK dout0_3 vdout0_3ck153 = 0 time = 1540
* CHECK dout0_4 vdout0_4ck153 = 1.95 time = 1540
* CHECK dout0_5 vdout0_5ck153 = 1.95 time = 1540
* CHECK dout0_6 vdout0_6ck153 = 1.95 time = 1540
* CHECK dout0_7 vdout0_7ck153 = 0 time = 1540
* CHECK dout0_8 vdout0_8ck153 = 1.95 time = 1540
* CHECK dout0_9 vdout0_9ck153 = 0 time = 1540
* CHECK dout0_10 vdout0_10ck153 = 1.95 time = 1540
* CHECK dout0_11 vdout0_11ck153 = 0 time = 1540
* CHECK dout0_12 vdout0_12ck153 = 1.95 time = 1540
* CHECK dout0_13 vdout0_13ck153 = 0 time = 1540
* CHECK dout0_14 vdout0_14ck153 = 1.95 time = 1540
* CHECK dout0_15 vdout0_15ck153 = 0 time = 1540
* CHECK dout0_16 vdout0_16ck153 = 1.95 time = 1540
* CHECK dout0_17 vdout0_17ck153 = 1.95 time = 1540
* CHECK dout0_18 vdout0_18ck153 = 0 time = 1540
* CHECK dout0_19 vdout0_19ck153 = 0 time = 1540
* CHECK dout0_20 vdout0_20ck153 = 1.95 time = 1540
* CHECK dout0_21 vdout0_21ck153 = 0 time = 1540
* CHECK dout0_22 vdout0_22ck153 = 0 time = 1540
* CHECK dout0_23 vdout0_23ck153 = 0 time = 1540
* CHECK dout0_24 vdout0_24ck153 = 1.95 time = 1540
* CHECK dout0_25 vdout0_25ck153 = 1.95 time = 1540
* CHECK dout0_26 vdout0_26ck153 = 1.95 time = 1540
* CHECK dout0_27 vdout0_27ck153 = 1.95 time = 1540
* CHECK dout0_28 vdout0_28ck153 = 0 time = 1540
* CHECK dout0_29 vdout0_29ck153 = 0 time = 1540
* CHECK dout0_30 vdout0_30ck153 = 0 time = 1540
* CHECK dout0_31 vdout0_31ck153 = 0 time = 1540
* CHECK dout1_0 vdout1_0ck153 = 0 time = 1540
* CHECK dout1_1 vdout1_1ck153 = 1.95 time = 1540
* CHECK dout1_2 vdout1_2ck153 = 1.95 time = 1540
* CHECK dout1_3 vdout1_3ck153 = 0 time = 1540
* CHECK dout1_4 vdout1_4ck153 = 1.95 time = 1540
* CHECK dout1_5 vdout1_5ck153 = 1.95 time = 1540
* CHECK dout1_6 vdout1_6ck153 = 0 time = 1540
* CHECK dout1_7 vdout1_7ck153 = 1.95 time = 1540
* CHECK dout1_8 vdout1_8ck153 = 0 time = 1540
* CHECK dout1_9 vdout1_9ck153 = 0 time = 1540
* CHECK dout1_10 vdout1_10ck153 = 0 time = 1540
* CHECK dout1_11 vdout1_11ck153 = 1.95 time = 1540
* CHECK dout1_12 vdout1_12ck153 = 1.95 time = 1540
* CHECK dout1_13 vdout1_13ck153 = 0 time = 1540
* CHECK dout1_14 vdout1_14ck153 = 1.95 time = 1540
* CHECK dout1_15 vdout1_15ck153 = 0 time = 1540
* CHECK dout1_16 vdout1_16ck153 = 0 time = 1540
* CHECK dout1_17 vdout1_17ck153 = 0 time = 1540
* CHECK dout1_18 vdout1_18ck153 = 0 time = 1540
* CHECK dout1_19 vdout1_19ck153 = 0 time = 1540
* CHECK dout1_20 vdout1_20ck153 = 0 time = 1540
* CHECK dout1_21 vdout1_21ck153 = 0 time = 1540
* CHECK dout1_22 vdout1_22ck153 = 1.95 time = 1540
* CHECK dout1_23 vdout1_23ck153 = 0 time = 1540
* CHECK dout1_24 vdout1_24ck153 = 1.95 time = 1540
* CHECK dout1_25 vdout1_25ck153 = 0 time = 1540
* CHECK dout1_26 vdout1_26ck153 = 0 time = 1540
* CHECK dout1_27 vdout1_27ck153 = 1.95 time = 1540
* CHECK dout1_28 vdout1_28ck153 = 0 time = 1540
* CHECK dout1_29 vdout1_29ck153 = 0 time = 1540
* CHECK dout1_30 vdout1_30ck153 = 1.95 time = 1540
* CHECK dout1_31 vdout1_31ck153 = 1.95 time = 1540
* CHECK dout1_0 vdout1_0ck154 = 0 time = 1550
* CHECK dout1_1 vdout1_1ck154 = 0 time = 1550
* CHECK dout1_2 vdout1_2ck154 = 0 time = 1550
* CHECK dout1_3 vdout1_3ck154 = 0 time = 1550
* CHECK dout1_4 vdout1_4ck154 = 0 time = 1550
* CHECK dout1_5 vdout1_5ck154 = 1.95 time = 1550
* CHECK dout1_6 vdout1_6ck154 = 1.95 time = 1550
* CHECK dout1_7 vdout1_7ck154 = 1.95 time = 1550
* CHECK dout1_8 vdout1_8ck154 = 1.95 time = 1550
* CHECK dout1_9 vdout1_9ck154 = 0 time = 1550
* CHECK dout1_10 vdout1_10ck154 = 1.95 time = 1550
* CHECK dout1_11 vdout1_11ck154 = 1.95 time = 1550
* CHECK dout1_12 vdout1_12ck154 = 0 time = 1550
* CHECK dout1_13 vdout1_13ck154 = 1.95 time = 1550
* CHECK dout1_14 vdout1_14ck154 = 1.95 time = 1550
* CHECK dout1_15 vdout1_15ck154 = 1.95 time = 1550
* CHECK dout1_16 vdout1_16ck154 = 1.95 time = 1550
* CHECK dout1_17 vdout1_17ck154 = 0 time = 1550
* CHECK dout1_18 vdout1_18ck154 = 0 time = 1550
* CHECK dout1_19 vdout1_19ck154 = 1.95 time = 1550
* CHECK dout1_20 vdout1_20ck154 = 1.95 time = 1550
* CHECK dout1_21 vdout1_21ck154 = 1.95 time = 1550
* CHECK dout1_22 vdout1_22ck154 = 0 time = 1550
* CHECK dout1_23 vdout1_23ck154 = 1.95 time = 1550
* CHECK dout1_24 vdout1_24ck154 = 0 time = 1550
* CHECK dout1_25 vdout1_25ck154 = 1.95 time = 1550
* CHECK dout1_26 vdout1_26ck154 = 0 time = 1550
* CHECK dout1_27 vdout1_27ck154 = 1.95 time = 1550
* CHECK dout1_28 vdout1_28ck154 = 1.95 time = 1550
* CHECK dout1_29 vdout1_29ck154 = 1.95 time = 1550
* CHECK dout1_30 vdout1_30ck154 = 0 time = 1550
* CHECK dout1_31 vdout1_31ck154 = 1.95 time = 1550
* CHECK dout0_0 vdout0_0ck157 = 0 time = 1580
* CHECK dout0_1 vdout0_1ck157 = 0 time = 1580
* CHECK dout0_2 vdout0_2ck157 = 1.95 time = 1580
* CHECK dout0_3 vdout0_3ck157 = 1.95 time = 1580
* CHECK dout0_4 vdout0_4ck157 = 1.95 time = 1580
* CHECK dout0_5 vdout0_5ck157 = 0 time = 1580
* CHECK dout0_6 vdout0_6ck157 = 1.95 time = 1580
* CHECK dout0_7 vdout0_7ck157 = 0 time = 1580
* CHECK dout0_8 vdout0_8ck157 = 0 time = 1580
* CHECK dout0_9 vdout0_9ck157 = 1.95 time = 1580
* CHECK dout0_10 vdout0_10ck157 = 0 time = 1580
* CHECK dout0_11 vdout0_11ck157 = 0 time = 1580
* CHECK dout0_12 vdout0_12ck157 = 1.95 time = 1580
* CHECK dout0_13 vdout0_13ck157 = 1.95 time = 1580
* CHECK dout0_14 vdout0_14ck157 = 1.95 time = 1580
* CHECK dout0_15 vdout0_15ck157 = 1.95 time = 1580
* CHECK dout0_16 vdout0_16ck157 = 1.95 time = 1580
* CHECK dout0_17 vdout0_17ck157 = 0 time = 1580
* CHECK dout0_18 vdout0_18ck157 = 1.95 time = 1580
* CHECK dout0_19 vdout0_19ck157 = 1.95 time = 1580
* CHECK dout0_20 vdout0_20ck157 = 1.95 time = 1580
* CHECK dout0_21 vdout0_21ck157 = 0 time = 1580
* CHECK dout0_22 vdout0_22ck157 = 1.95 time = 1580
* CHECK dout0_23 vdout0_23ck157 = 0 time = 1580
* CHECK dout0_24 vdout0_24ck157 = 1.95 time = 1580
* CHECK dout0_25 vdout0_25ck157 = 0 time = 1580
* CHECK dout0_26 vdout0_26ck157 = 1.95 time = 1580
* CHECK dout0_27 vdout0_27ck157 = 0 time = 1580
* CHECK dout0_28 vdout0_28ck157 = 0 time = 1580
* CHECK dout0_29 vdout0_29ck157 = 1.95 time = 1580
* CHECK dout0_30 vdout0_30ck157 = 1.95 time = 1580
* CHECK dout0_31 vdout0_31ck157 = 0 time = 1580
* CHECK dout1_0 vdout1_0ck157 = 0 time = 1580
* CHECK dout1_1 vdout1_1ck157 = 1.95 time = 1580
* CHECK dout1_2 vdout1_2ck157 = 1.95 time = 1580
* CHECK dout1_3 vdout1_3ck157 = 0 time = 1580
* CHECK dout1_4 vdout1_4ck157 = 1.95 time = 1580
* CHECK dout1_5 vdout1_5ck157 = 1.95 time = 1580
* CHECK dout1_6 vdout1_6ck157 = 0 time = 1580
* CHECK dout1_7 vdout1_7ck157 = 1.95 time = 1580
* CHECK dout1_8 vdout1_8ck157 = 0 time = 1580
* CHECK dout1_9 vdout1_9ck157 = 0 time = 1580
* CHECK dout1_10 vdout1_10ck157 = 0 time = 1580
* CHECK dout1_11 vdout1_11ck157 = 1.95 time = 1580
* CHECK dout1_12 vdout1_12ck157 = 1.95 time = 1580
* CHECK dout1_13 vdout1_13ck157 = 0 time = 1580
* CHECK dout1_14 vdout1_14ck157 = 1.95 time = 1580
* CHECK dout1_15 vdout1_15ck157 = 0 time = 1580
* CHECK dout1_16 vdout1_16ck157 = 0 time = 1580
* CHECK dout1_17 vdout1_17ck157 = 0 time = 1580
* CHECK dout1_18 vdout1_18ck157 = 0 time = 1580
* CHECK dout1_19 vdout1_19ck157 = 0 time = 1580
* CHECK dout1_20 vdout1_20ck157 = 0 time = 1580
* CHECK dout1_21 vdout1_21ck157 = 0 time = 1580
* CHECK dout1_22 vdout1_22ck157 = 1.95 time = 1580
* CHECK dout1_23 vdout1_23ck157 = 0 time = 1580
* CHECK dout1_24 vdout1_24ck157 = 1.95 time = 1580
* CHECK dout1_25 vdout1_25ck157 = 0 time = 1580
* CHECK dout1_26 vdout1_26ck157 = 0 time = 1580
* CHECK dout1_27 vdout1_27ck157 = 1.95 time = 1580
* CHECK dout1_28 vdout1_28ck157 = 0 time = 1580
* CHECK dout1_29 vdout1_29ck157 = 0 time = 1580
* CHECK dout1_30 vdout1_30ck157 = 1.95 time = 1580
* CHECK dout1_31 vdout1_31ck157 = 1.95 time = 1580
* CHECK dout0_0 vdout0_0ck159 = 0 time = 1600
* CHECK dout0_1 vdout0_1ck159 = 0 time = 1600
* CHECK dout0_2 vdout0_2ck159 = 1.95 time = 1600
* CHECK dout0_3 vdout0_3ck159 = 1.95 time = 1600
* CHECK dout0_4 vdout0_4ck159 = 1.95 time = 1600
* CHECK dout0_5 vdout0_5ck159 = 0 time = 1600
* CHECK dout0_6 vdout0_6ck159 = 1.95 time = 1600
* CHECK dout0_7 vdout0_7ck159 = 0 time = 1600
* CHECK dout0_8 vdout0_8ck159 = 0 time = 1600
* CHECK dout0_9 vdout0_9ck159 = 1.95 time = 1600
* CHECK dout0_10 vdout0_10ck159 = 0 time = 1600
* CHECK dout0_11 vdout0_11ck159 = 0 time = 1600
* CHECK dout0_12 vdout0_12ck159 = 1.95 time = 1600
* CHECK dout0_13 vdout0_13ck159 = 1.95 time = 1600
* CHECK dout0_14 vdout0_14ck159 = 1.95 time = 1600
* CHECK dout0_15 vdout0_15ck159 = 1.95 time = 1600
* CHECK dout0_16 vdout0_16ck159 = 1.95 time = 1600
* CHECK dout0_17 vdout0_17ck159 = 0 time = 1600
* CHECK dout0_18 vdout0_18ck159 = 1.95 time = 1600
* CHECK dout0_19 vdout0_19ck159 = 1.95 time = 1600
* CHECK dout0_20 vdout0_20ck159 = 1.95 time = 1600
* CHECK dout0_21 vdout0_21ck159 = 0 time = 1600
* CHECK dout0_22 vdout0_22ck159 = 1.95 time = 1600
* CHECK dout0_23 vdout0_23ck159 = 0 time = 1600
* CHECK dout0_24 vdout0_24ck159 = 1.95 time = 1600
* CHECK dout0_25 vdout0_25ck159 = 0 time = 1600
* CHECK dout0_26 vdout0_26ck159 = 1.95 time = 1600
* CHECK dout0_27 vdout0_27ck159 = 0 time = 1600
* CHECK dout0_28 vdout0_28ck159 = 0 time = 1600
* CHECK dout0_29 vdout0_29ck159 = 1.95 time = 1600
* CHECK dout0_30 vdout0_30ck159 = 1.95 time = 1600
* CHECK dout0_31 vdout0_31ck159 = 0 time = 1600
* CHECK dout0_0 vdout0_0ck162 = 0 time = 1630
* CHECK dout0_1 vdout0_1ck162 = 0 time = 1630
* CHECK dout0_2 vdout0_2ck162 = 0 time = 1630
* CHECK dout0_3 vdout0_3ck162 = 0 time = 1630
* CHECK dout0_4 vdout0_4ck162 = 0 time = 1630
* CHECK dout0_5 vdout0_5ck162 = 1.95 time = 1630
* CHECK dout0_6 vdout0_6ck162 = 1.95 time = 1630
* CHECK dout0_7 vdout0_7ck162 = 1.95 time = 1630
* CHECK dout0_8 vdout0_8ck162 = 1.95 time = 1630
* CHECK dout0_9 vdout0_9ck162 = 0 time = 1630
* CHECK dout0_10 vdout0_10ck162 = 1.95 time = 1630
* CHECK dout0_11 vdout0_11ck162 = 1.95 time = 1630
* CHECK dout0_12 vdout0_12ck162 = 0 time = 1630
* CHECK dout0_13 vdout0_13ck162 = 1.95 time = 1630
* CHECK dout0_14 vdout0_14ck162 = 1.95 time = 1630
* CHECK dout0_15 vdout0_15ck162 = 1.95 time = 1630
* CHECK dout0_16 vdout0_16ck162 = 1.95 time = 1630
* CHECK dout0_17 vdout0_17ck162 = 0 time = 1630
* CHECK dout0_18 vdout0_18ck162 = 0 time = 1630
* CHECK dout0_19 vdout0_19ck162 = 1.95 time = 1630
* CHECK dout0_20 vdout0_20ck162 = 1.95 time = 1630
* CHECK dout0_21 vdout0_21ck162 = 1.95 time = 1630
* CHECK dout0_22 vdout0_22ck162 = 0 time = 1630
* CHECK dout0_23 vdout0_23ck162 = 1.95 time = 1630
* CHECK dout0_24 vdout0_24ck162 = 0 time = 1630
* CHECK dout0_25 vdout0_25ck162 = 1.95 time = 1630
* CHECK dout0_26 vdout0_26ck162 = 0 time = 1630
* CHECK dout0_27 vdout0_27ck162 = 1.95 time = 1630
* CHECK dout0_28 vdout0_28ck162 = 1.95 time = 1630
* CHECK dout0_29 vdout0_29ck162 = 1.95 time = 1630
* CHECK dout0_30 vdout0_30ck162 = 0 time = 1630
* CHECK dout0_31 vdout0_31ck162 = 1.95 time = 1630
* CHECK dout1_0 vdout1_0ck162 = 0 time = 1630
* CHECK dout1_1 vdout1_1ck162 = 1.95 time = 1630
* CHECK dout1_2 vdout1_2ck162 = 1.95 time = 1630
* CHECK dout1_3 vdout1_3ck162 = 0 time = 1630
* CHECK dout1_4 vdout1_4ck162 = 1.95 time = 1630
* CHECK dout1_5 vdout1_5ck162 = 1.95 time = 1630
* CHECK dout1_6 vdout1_6ck162 = 0 time = 1630
* CHECK dout1_7 vdout1_7ck162 = 1.95 time = 1630
* CHECK dout1_8 vdout1_8ck162 = 0 time = 1630
* CHECK dout1_9 vdout1_9ck162 = 0 time = 1630
* CHECK dout1_10 vdout1_10ck162 = 0 time = 1630
* CHECK dout1_11 vdout1_11ck162 = 1.95 time = 1630
* CHECK dout1_12 vdout1_12ck162 = 1.95 time = 1630
* CHECK dout1_13 vdout1_13ck162 = 0 time = 1630
* CHECK dout1_14 vdout1_14ck162 = 1.95 time = 1630
* CHECK dout1_15 vdout1_15ck162 = 0 time = 1630
* CHECK dout1_16 vdout1_16ck162 = 0 time = 1630
* CHECK dout1_17 vdout1_17ck162 = 0 time = 1630
* CHECK dout1_18 vdout1_18ck162 = 0 time = 1630
* CHECK dout1_19 vdout1_19ck162 = 0 time = 1630
* CHECK dout1_20 vdout1_20ck162 = 0 time = 1630
* CHECK dout1_21 vdout1_21ck162 = 0 time = 1630
* CHECK dout1_22 vdout1_22ck162 = 1.95 time = 1630
* CHECK dout1_23 vdout1_23ck162 = 0 time = 1630
* CHECK dout1_24 vdout1_24ck162 = 1.95 time = 1630
* CHECK dout1_25 vdout1_25ck162 = 0 time = 1630
* CHECK dout1_26 vdout1_26ck162 = 0 time = 1630
* CHECK dout1_27 vdout1_27ck162 = 1.95 time = 1630
* CHECK dout1_28 vdout1_28ck162 = 0 time = 1630
* CHECK dout1_29 vdout1_29ck162 = 0 time = 1630
* CHECK dout1_30 vdout1_30ck162 = 1.95 time = 1630
* CHECK dout1_31 vdout1_31ck162 = 1.95 time = 1630
* CHECK dout0_0 vdout0_0ck163 = 0 time = 1640
* CHECK dout0_1 vdout0_1ck163 = 1.95 time = 1640
* CHECK dout0_2 vdout0_2ck163 = 0 time = 1640
* CHECK dout0_3 vdout0_3ck163 = 1.95 time = 1640
* CHECK dout0_4 vdout0_4ck163 = 0 time = 1640
* CHECK dout0_5 vdout0_5ck163 = 1.95 time = 1640
* CHECK dout0_6 vdout0_6ck163 = 1.95 time = 1640
* CHECK dout0_7 vdout0_7ck163 = 1.95 time = 1640
* CHECK dout0_8 vdout0_8ck163 = 0 time = 1640
* CHECK dout0_9 vdout0_9ck163 = 1.95 time = 1640
* CHECK dout0_10 vdout0_10ck163 = 0 time = 1640
* CHECK dout0_11 vdout0_11ck163 = 0 time = 1640
* CHECK dout0_12 vdout0_12ck163 = 1.95 time = 1640
* CHECK dout0_13 vdout0_13ck163 = 0 time = 1640
* CHECK dout0_14 vdout0_14ck163 = 0 time = 1640
* CHECK dout0_15 vdout0_15ck163 = 1.95 time = 1640
* CHECK dout0_16 vdout0_16ck163 = 0 time = 1640
* CHECK dout0_17 vdout0_17ck163 = 0 time = 1640
* CHECK dout0_18 vdout0_18ck163 = 0 time = 1640
* CHECK dout0_19 vdout0_19ck163 = 0 time = 1640
* CHECK dout0_20 vdout0_20ck163 = 1.95 time = 1640
* CHECK dout0_21 vdout0_21ck163 = 0 time = 1640
* CHECK dout0_22 vdout0_22ck163 = 1.95 time = 1640
* CHECK dout0_23 vdout0_23ck163 = 0 time = 1640
* CHECK dout0_24 vdout0_24ck163 = 1.95 time = 1640
* CHECK dout0_25 vdout0_25ck163 = 1.95 time = 1640
* CHECK dout0_26 vdout0_26ck163 = 0 time = 1640
* CHECK dout0_27 vdout0_27ck163 = 1.95 time = 1640
* CHECK dout0_28 vdout0_28ck163 = 0 time = 1640
* CHECK dout0_29 vdout0_29ck163 = 1.95 time = 1640
* CHECK dout0_30 vdout0_30ck163 = 0 time = 1640
* CHECK dout0_31 vdout0_31ck163 = 1.95 time = 1640
* CHECK dout0_0 vdout0_0ck165 = 0 time = 1660
* CHECK dout0_1 vdout0_1ck165 = 0 time = 1660
* CHECK dout0_2 vdout0_2ck165 = 1.95 time = 1660
* CHECK dout0_3 vdout0_3ck165 = 1.95 time = 1660
* CHECK dout0_4 vdout0_4ck165 = 1.95 time = 1660
* CHECK dout0_5 vdout0_5ck165 = 0 time = 1660
* CHECK dout0_6 vdout0_6ck165 = 1.95 time = 1660
* CHECK dout0_7 vdout0_7ck165 = 0 time = 1660
* CHECK dout0_8 vdout0_8ck165 = 0 time = 1660
* CHECK dout0_9 vdout0_9ck165 = 1.95 time = 1660
* CHECK dout0_10 vdout0_10ck165 = 0 time = 1660
* CHECK dout0_11 vdout0_11ck165 = 0 time = 1660
* CHECK dout0_12 vdout0_12ck165 = 1.95 time = 1660
* CHECK dout0_13 vdout0_13ck165 = 1.95 time = 1660
* CHECK dout0_14 vdout0_14ck165 = 1.95 time = 1660
* CHECK dout0_15 vdout0_15ck165 = 1.95 time = 1660
* CHECK dout0_16 vdout0_16ck165 = 1.95 time = 1660
* CHECK dout0_17 vdout0_17ck165 = 0 time = 1660
* CHECK dout0_18 vdout0_18ck165 = 1.95 time = 1660
* CHECK dout0_19 vdout0_19ck165 = 0 time = 1660
* CHECK dout0_20 vdout0_20ck165 = 0 time = 1660
* CHECK dout0_21 vdout0_21ck165 = 0 time = 1660
* CHECK dout0_22 vdout0_22ck165 = 1.95 time = 1660
* CHECK dout0_23 vdout0_23ck165 = 0 time = 1660
* CHECK dout0_24 vdout0_24ck165 = 1.95 time = 1660
* CHECK dout0_25 vdout0_25ck165 = 1.95 time = 1660
* CHECK dout0_26 vdout0_26ck165 = 1.95 time = 1660
* CHECK dout0_27 vdout0_27ck165 = 1.95 time = 1660
* CHECK dout0_28 vdout0_28ck165 = 1.95 time = 1660
* CHECK dout0_29 vdout0_29ck165 = 1.95 time = 1660
* CHECK dout0_30 vdout0_30ck165 = 0 time = 1660
* CHECK dout0_31 vdout0_31ck165 = 1.95 time = 1660
* CHECK dout1_0 vdout1_0ck165 = 0 time = 1660
* CHECK dout1_1 vdout1_1ck165 = 1.95 time = 1660
* CHECK dout1_2 vdout1_2ck165 = 1.95 time = 1660
* CHECK dout1_3 vdout1_3ck165 = 0 time = 1660
* CHECK dout1_4 vdout1_4ck165 = 1.95 time = 1660
* CHECK dout1_5 vdout1_5ck165 = 1.95 time = 1660
* CHECK dout1_6 vdout1_6ck165 = 0 time = 1660
* CHECK dout1_7 vdout1_7ck165 = 1.95 time = 1660
* CHECK dout1_8 vdout1_8ck165 = 0 time = 1660
* CHECK dout1_9 vdout1_9ck165 = 0 time = 1660
* CHECK dout1_10 vdout1_10ck165 = 0 time = 1660
* CHECK dout1_11 vdout1_11ck165 = 1.95 time = 1660
* CHECK dout1_12 vdout1_12ck165 = 1.95 time = 1660
* CHECK dout1_13 vdout1_13ck165 = 0 time = 1660
* CHECK dout1_14 vdout1_14ck165 = 1.95 time = 1660
* CHECK dout1_15 vdout1_15ck165 = 0 time = 1660
* CHECK dout1_16 vdout1_16ck165 = 0 time = 1660
* CHECK dout1_17 vdout1_17ck165 = 0 time = 1660
* CHECK dout1_18 vdout1_18ck165 = 0 time = 1660
* CHECK dout1_19 vdout1_19ck165 = 0 time = 1660
* CHECK dout1_20 vdout1_20ck165 = 0 time = 1660
* CHECK dout1_21 vdout1_21ck165 = 0 time = 1660
* CHECK dout1_22 vdout1_22ck165 = 1.95 time = 1660
* CHECK dout1_23 vdout1_23ck165 = 0 time = 1660
* CHECK dout1_24 vdout1_24ck165 = 1.95 time = 1660
* CHECK dout1_25 vdout1_25ck165 = 0 time = 1660
* CHECK dout1_26 vdout1_26ck165 = 0 time = 1660
* CHECK dout1_27 vdout1_27ck165 = 1.95 time = 1660
* CHECK dout1_28 vdout1_28ck165 = 0 time = 1660
* CHECK dout1_29 vdout1_29ck165 = 0 time = 1660
* CHECK dout1_30 vdout1_30ck165 = 1.95 time = 1660
* CHECK dout1_31 vdout1_31ck165 = 1.95 time = 1660
* CHECK dout1_0 vdout1_0ck166 = 0 time = 1670
* CHECK dout1_1 vdout1_1ck166 = 0 time = 1670
* CHECK dout1_2 vdout1_2ck166 = 0 time = 1670
* CHECK dout1_3 vdout1_3ck166 = 0 time = 1670
* CHECK dout1_4 vdout1_4ck166 = 0 time = 1670
* CHECK dout1_5 vdout1_5ck166 = 1.95 time = 1670
* CHECK dout1_6 vdout1_6ck166 = 1.95 time = 1670
* CHECK dout1_7 vdout1_7ck166 = 1.95 time = 1670
* CHECK dout1_8 vdout1_8ck166 = 1.95 time = 1670
* CHECK dout1_9 vdout1_9ck166 = 0 time = 1670
* CHECK dout1_10 vdout1_10ck166 = 1.95 time = 1670
* CHECK dout1_11 vdout1_11ck166 = 1.95 time = 1670
* CHECK dout1_12 vdout1_12ck166 = 0 time = 1670
* CHECK dout1_13 vdout1_13ck166 = 1.95 time = 1670
* CHECK dout1_14 vdout1_14ck166 = 1.95 time = 1670
* CHECK dout1_15 vdout1_15ck166 = 1.95 time = 1670
* CHECK dout1_16 vdout1_16ck166 = 1.95 time = 1670
* CHECK dout1_17 vdout1_17ck166 = 0 time = 1670
* CHECK dout1_18 vdout1_18ck166 = 0 time = 1670
* CHECK dout1_19 vdout1_19ck166 = 1.95 time = 1670
* CHECK dout1_20 vdout1_20ck166 = 1.95 time = 1670
* CHECK dout1_21 vdout1_21ck166 = 1.95 time = 1670
* CHECK dout1_22 vdout1_22ck166 = 0 time = 1670
* CHECK dout1_23 vdout1_23ck166 = 1.95 time = 1670
* CHECK dout1_24 vdout1_24ck166 = 0 time = 1670
* CHECK dout1_25 vdout1_25ck166 = 1.95 time = 1670
* CHECK dout1_26 vdout1_26ck166 = 0 time = 1670
* CHECK dout1_27 vdout1_27ck166 = 1.95 time = 1670
* CHECK dout1_28 vdout1_28ck166 = 1.95 time = 1670
* CHECK dout1_29 vdout1_29ck166 = 1.95 time = 1670
* CHECK dout1_30 vdout1_30ck166 = 0 time = 1670
* CHECK dout1_31 vdout1_31ck166 = 1.95 time = 1670
* CHECK dout0_0 vdout0_0ck167 = 0 time = 1680
* CHECK dout0_1 vdout0_1ck167 = 0 time = 1680
* CHECK dout0_2 vdout0_2ck167 = 1.95 time = 1680
* CHECK dout0_3 vdout0_3ck167 = 1.95 time = 1680
* CHECK dout0_4 vdout0_4ck167 = 1.95 time = 1680
* CHECK dout0_5 vdout0_5ck167 = 0 time = 1680
* CHECK dout0_6 vdout0_6ck167 = 1.95 time = 1680
* CHECK dout0_7 vdout0_7ck167 = 0 time = 1680
* CHECK dout0_8 vdout0_8ck167 = 0 time = 1680
* CHECK dout0_9 vdout0_9ck167 = 1.95 time = 1680
* CHECK dout0_10 vdout0_10ck167 = 0 time = 1680
* CHECK dout0_11 vdout0_11ck167 = 0 time = 1680
* CHECK dout0_12 vdout0_12ck167 = 1.95 time = 1680
* CHECK dout0_13 vdout0_13ck167 = 1.95 time = 1680
* CHECK dout0_14 vdout0_14ck167 = 1.95 time = 1680
* CHECK dout0_15 vdout0_15ck167 = 1.95 time = 1680
* CHECK dout0_16 vdout0_16ck167 = 1.95 time = 1680
* CHECK dout0_17 vdout0_17ck167 = 0 time = 1680
* CHECK dout0_18 vdout0_18ck167 = 1.95 time = 1680
* CHECK dout0_19 vdout0_19ck167 = 0 time = 1680
* CHECK dout0_20 vdout0_20ck167 = 0 time = 1680
* CHECK dout0_21 vdout0_21ck167 = 0 time = 1680
* CHECK dout0_22 vdout0_22ck167 = 1.95 time = 1680
* CHECK dout0_23 vdout0_23ck167 = 0 time = 1680
* CHECK dout0_24 vdout0_24ck167 = 0 time = 1680
* CHECK dout0_25 vdout0_25ck167 = 0 time = 1680
* CHECK dout0_26 vdout0_26ck167 = 0 time = 1680
* CHECK dout0_27 vdout0_27ck167 = 1.95 time = 1680
* CHECK dout0_28 vdout0_28ck167 = 0 time = 1680
* CHECK dout0_29 vdout0_29ck167 = 1.95 time = 1680
* CHECK dout0_30 vdout0_30ck167 = 1.95 time = 1680
* CHECK dout0_31 vdout0_31ck167 = 1.95 time = 1680
* CHECK dout0_0 vdout0_0ck170 = 1.95 time = 1710
* CHECK dout0_1 vdout0_1ck170 = 1.95 time = 1710
* CHECK dout0_2 vdout0_2ck170 = 0 time = 1710
* CHECK dout0_3 vdout0_3ck170 = 1.95 time = 1710
* CHECK dout0_4 vdout0_4ck170 = 1.95 time = 1710
* CHECK dout0_5 vdout0_5ck170 = 0 time = 1710
* CHECK dout0_6 vdout0_6ck170 = 0 time = 1710
* CHECK dout0_7 vdout0_7ck170 = 1.95 time = 1710
* CHECK dout0_8 vdout0_8ck170 = 0 time = 1710
* CHECK dout0_9 vdout0_9ck170 = 1.95 time = 1710
* CHECK dout0_10 vdout0_10ck170 = 0 time = 1710
* CHECK dout0_11 vdout0_11ck170 = 0 time = 1710
* CHECK dout0_12 vdout0_12ck170 = 1.95 time = 1710
* CHECK dout0_13 vdout0_13ck170 = 1.95 time = 1710
* CHECK dout0_14 vdout0_14ck170 = 0 time = 1710
* CHECK dout0_15 vdout0_15ck170 = 0 time = 1710
* CHECK dout0_16 vdout0_16ck170 = 0 time = 1710
* CHECK dout0_17 vdout0_17ck170 = 0 time = 1710
* CHECK dout0_18 vdout0_18ck170 = 1.95 time = 1710
* CHECK dout0_19 vdout0_19ck170 = 0 time = 1710
* CHECK dout0_20 vdout0_20ck170 = 0 time = 1710
* CHECK dout0_21 vdout0_21ck170 = 1.95 time = 1710
* CHECK dout0_22 vdout0_22ck170 = 0 time = 1710
* CHECK dout0_23 vdout0_23ck170 = 1.95 time = 1710
* CHECK dout0_24 vdout0_24ck170 = 1.95 time = 1710
* CHECK dout0_25 vdout0_25ck170 = 0 time = 1710
* CHECK dout0_26 vdout0_26ck170 = 0 time = 1710
* CHECK dout0_27 vdout0_27ck170 = 1.95 time = 1710
* CHECK dout0_28 vdout0_28ck170 = 1.95 time = 1710
* CHECK dout0_29 vdout0_29ck170 = 1.95 time = 1710
* CHECK dout0_30 vdout0_30ck170 = 1.95 time = 1710
* CHECK dout0_31 vdout0_31ck170 = 0 time = 1710
* CHECK dout1_0 vdout1_0ck170 = 1.95 time = 1710
* CHECK dout1_1 vdout1_1ck170 = 0 time = 1710
* CHECK dout1_2 vdout1_2ck170 = 1.95 time = 1710
* CHECK dout1_3 vdout1_3ck170 = 0 time = 1710
* CHECK dout1_4 vdout1_4ck170 = 1.95 time = 1710
* CHECK dout1_5 vdout1_5ck170 = 0 time = 1710
* CHECK dout1_6 vdout1_6ck170 = 0 time = 1710
* CHECK dout1_7 vdout1_7ck170 = 0 time = 1710
* CHECK dout1_8 vdout1_8ck170 = 1.95 time = 1710
* CHECK dout1_9 vdout1_9ck170 = 1.95 time = 1710
* CHECK dout1_10 vdout1_10ck170 = 0 time = 1710
* CHECK dout1_11 vdout1_11ck170 = 1.95 time = 1710
* CHECK dout1_12 vdout1_12ck170 = 0 time = 1710
* CHECK dout1_13 vdout1_13ck170 = 0 time = 1710
* CHECK dout1_14 vdout1_14ck170 = 0 time = 1710
* CHECK dout1_15 vdout1_15ck170 = 1.95 time = 1710
* CHECK dout1_16 vdout1_16ck170 = 1.95 time = 1710
* CHECK dout1_17 vdout1_17ck170 = 0 time = 1710
* CHECK dout1_18 vdout1_18ck170 = 0 time = 1710
* CHECK dout1_19 vdout1_19ck170 = 0 time = 1710
* CHECK dout1_20 vdout1_20ck170 = 1.95 time = 1710
* CHECK dout1_21 vdout1_21ck170 = 1.95 time = 1710
* CHECK dout1_22 vdout1_22ck170 = 0 time = 1710
* CHECK dout1_23 vdout1_23ck170 = 1.95 time = 1710
* CHECK dout1_24 vdout1_24ck170 = 1.95 time = 1710
* CHECK dout1_25 vdout1_25ck170 = 0 time = 1710
* CHECK dout1_26 vdout1_26ck170 = 0 time = 1710
* CHECK dout1_27 vdout1_27ck170 = 0 time = 1710
* CHECK dout1_28 vdout1_28ck170 = 1.95 time = 1710
* CHECK dout1_29 vdout1_29ck170 = 1.95 time = 1710
* CHECK dout1_30 vdout1_30ck170 = 0 time = 1710
* CHECK dout1_31 vdout1_31ck170 = 0 time = 1710
* CHECK dout1_0 vdout1_0ck173 = 0 time = 1740
* CHECK dout1_1 vdout1_1ck173 = 0 time = 1740
* CHECK dout1_2 vdout1_2ck173 = 1.95 time = 1740
* CHECK dout1_3 vdout1_3ck173 = 1.95 time = 1740
* CHECK dout1_4 vdout1_4ck173 = 0 time = 1740
* CHECK dout1_5 vdout1_5ck173 = 1.95 time = 1740
* CHECK dout1_6 vdout1_6ck173 = 1.95 time = 1740
* CHECK dout1_7 vdout1_7ck173 = 0 time = 1740
* CHECK dout1_8 vdout1_8ck173 = 0 time = 1740
* CHECK dout1_9 vdout1_9ck173 = 1.95 time = 1740
* CHECK dout1_10 vdout1_10ck173 = 0 time = 1740
* CHECK dout1_11 vdout1_11ck173 = 1.95 time = 1740
* CHECK dout1_12 vdout1_12ck173 = 1.95 time = 1740
* CHECK dout1_13 vdout1_13ck173 = 1.95 time = 1740
* CHECK dout1_14 vdout1_14ck173 = 1.95 time = 1740
* CHECK dout1_15 vdout1_15ck173 = 1.95 time = 1740
* CHECK dout1_16 vdout1_16ck173 = 1.95 time = 1740
* CHECK dout1_17 vdout1_17ck173 = 1.95 time = 1740
* CHECK dout1_18 vdout1_18ck173 = 1.95 time = 1740
* CHECK dout1_19 vdout1_19ck173 = 0 time = 1740
* CHECK dout1_20 vdout1_20ck173 = 0 time = 1740
* CHECK dout1_21 vdout1_21ck173 = 1.95 time = 1740
* CHECK dout1_22 vdout1_22ck173 = 1.95 time = 1740
* CHECK dout1_23 vdout1_23ck173 = 0 time = 1740
* CHECK dout1_24 vdout1_24ck173 = 0 time = 1740
* CHECK dout1_25 vdout1_25ck173 = 0 time = 1740
* CHECK dout1_26 vdout1_26ck173 = 1.95 time = 1740
* CHECK dout1_27 vdout1_27ck173 = 0 time = 1740
* CHECK dout1_28 vdout1_28ck173 = 0 time = 1740
* CHECK dout1_29 vdout1_29ck173 = 1.95 time = 1740
* CHECK dout1_30 vdout1_30ck173 = 0 time = 1740
* CHECK dout1_31 vdout1_31ck173 = 1.95 time = 1740
* CHECK dout0_0 vdout0_0ck175 = 0 time = 1760
* CHECK dout0_1 vdout0_1ck175 = 0 time = 1760
* CHECK dout0_2 vdout0_2ck175 = 1.95 time = 1760
* CHECK dout0_3 vdout0_3ck175 = 1.95 time = 1760
* CHECK dout0_4 vdout0_4ck175 = 0 time = 1760
* CHECK dout0_5 vdout0_5ck175 = 1.95 time = 1760
* CHECK dout0_6 vdout0_6ck175 = 1.95 time = 1760
* CHECK dout0_7 vdout0_7ck175 = 0 time = 1760
* CHECK dout0_8 vdout0_8ck175 = 0 time = 1760
* CHECK dout0_9 vdout0_9ck175 = 1.95 time = 1760
* CHECK dout0_10 vdout0_10ck175 = 0 time = 1760
* CHECK dout0_11 vdout0_11ck175 = 1.95 time = 1760
* CHECK dout0_12 vdout0_12ck175 = 1.95 time = 1760
* CHECK dout0_13 vdout0_13ck175 = 1.95 time = 1760
* CHECK dout0_14 vdout0_14ck175 = 1.95 time = 1760
* CHECK dout0_15 vdout0_15ck175 = 1.95 time = 1760
* CHECK dout0_16 vdout0_16ck175 = 0 time = 1760
* CHECK dout0_17 vdout0_17ck175 = 1.95 time = 1760
* CHECK dout0_18 vdout0_18ck175 = 1.95 time = 1760
* CHECK dout0_19 vdout0_19ck175 = 1.95 time = 1760
* CHECK dout0_20 vdout0_20ck175 = 0 time = 1760
* CHECK dout0_21 vdout0_21ck175 = 1.95 time = 1760
* CHECK dout0_22 vdout0_22ck175 = 1.95 time = 1760
* CHECK dout0_23 vdout0_23ck175 = 1.95 time = 1760
* CHECK dout0_24 vdout0_24ck175 = 1.95 time = 1760
* CHECK dout0_25 vdout0_25ck175 = 0 time = 1760
* CHECK dout0_26 vdout0_26ck175 = 1.95 time = 1760
* CHECK dout0_27 vdout0_27ck175 = 1.95 time = 1760
* CHECK dout0_28 vdout0_28ck175 = 1.95 time = 1760
* CHECK dout0_29 vdout0_29ck175 = 0 time = 1760
* CHECK dout0_30 vdout0_30ck175 = 0 time = 1760
* CHECK dout0_31 vdout0_31ck175 = 1.95 time = 1760
* CHECK dout1_0 vdout1_0ck175 = 1.95 time = 1760
* CHECK dout1_1 vdout1_1ck175 = 1.95 time = 1760
* CHECK dout1_2 vdout1_2ck175 = 0 time = 1760
* CHECK dout1_3 vdout1_3ck175 = 1.95 time = 1760
* CHECK dout1_4 vdout1_4ck175 = 1.95 time = 1760
* CHECK dout1_5 vdout1_5ck175 = 0 time = 1760
* CHECK dout1_6 vdout1_6ck175 = 0 time = 1760
* CHECK dout1_7 vdout1_7ck175 = 1.95 time = 1760
* CHECK dout1_8 vdout1_8ck175 = 0 time = 1760
* CHECK dout1_9 vdout1_9ck175 = 1.95 time = 1760
* CHECK dout1_10 vdout1_10ck175 = 0 time = 1760
* CHECK dout1_11 vdout1_11ck175 = 0 time = 1760
* CHECK dout1_12 vdout1_12ck175 = 1.95 time = 1760
* CHECK dout1_13 vdout1_13ck175 = 1.95 time = 1760
* CHECK dout1_14 vdout1_14ck175 = 0 time = 1760
* CHECK dout1_15 vdout1_15ck175 = 0 time = 1760
* CHECK dout1_16 vdout1_16ck175 = 0 time = 1760
* CHECK dout1_17 vdout1_17ck175 = 0 time = 1760
* CHECK dout1_18 vdout1_18ck175 = 1.95 time = 1760
* CHECK dout1_19 vdout1_19ck175 = 0 time = 1760
* CHECK dout1_20 vdout1_20ck175 = 0 time = 1760
* CHECK dout1_21 vdout1_21ck175 = 1.95 time = 1760
* CHECK dout1_22 vdout1_22ck175 = 0 time = 1760
* CHECK dout1_23 vdout1_23ck175 = 1.95 time = 1760
* CHECK dout1_24 vdout1_24ck175 = 1.95 time = 1760
* CHECK dout1_25 vdout1_25ck175 = 0 time = 1760
* CHECK dout1_26 vdout1_26ck175 = 0 time = 1760
* CHECK dout1_27 vdout1_27ck175 = 1.95 time = 1760
* CHECK dout1_28 vdout1_28ck175 = 1.95 time = 1760
* CHECK dout1_29 vdout1_29ck175 = 1.95 time = 1760
* CHECK dout1_30 vdout1_30ck175 = 1.95 time = 1760
* CHECK dout1_31 vdout1_31ck175 = 0 time = 1760
* CHECK dout1_0 vdout1_0ck177 = 0 time = 1780
* CHECK dout1_1 vdout1_1ck177 = 0 time = 1780
* CHECK dout1_2 vdout1_2ck177 = 0 time = 1780
* CHECK dout1_3 vdout1_3ck177 = 0 time = 1780
* CHECK dout1_4 vdout1_4ck177 = 0 time = 1780
* CHECK dout1_5 vdout1_5ck177 = 1.95 time = 1780
* CHECK dout1_6 vdout1_6ck177 = 1.95 time = 1780
* CHECK dout1_7 vdout1_7ck177 = 1.95 time = 1780
* CHECK dout1_8 vdout1_8ck177 = 1.95 time = 1780
* CHECK dout1_9 vdout1_9ck177 = 0 time = 1780
* CHECK dout1_10 vdout1_10ck177 = 1.95 time = 1780
* CHECK dout1_11 vdout1_11ck177 = 1.95 time = 1780
* CHECK dout1_12 vdout1_12ck177 = 0 time = 1780
* CHECK dout1_13 vdout1_13ck177 = 1.95 time = 1780
* CHECK dout1_14 vdout1_14ck177 = 1.95 time = 1780
* CHECK dout1_15 vdout1_15ck177 = 1.95 time = 1780
* CHECK dout1_16 vdout1_16ck177 = 1.95 time = 1780
* CHECK dout1_17 vdout1_17ck177 = 0 time = 1780
* CHECK dout1_18 vdout1_18ck177 = 0 time = 1780
* CHECK dout1_19 vdout1_19ck177 = 1.95 time = 1780
* CHECK dout1_20 vdout1_20ck177 = 1.95 time = 1780
* CHECK dout1_21 vdout1_21ck177 = 1.95 time = 1780
* CHECK dout1_22 vdout1_22ck177 = 0 time = 1780
* CHECK dout1_23 vdout1_23ck177 = 1.95 time = 1780
* CHECK dout1_24 vdout1_24ck177 = 0 time = 1780
* CHECK dout1_25 vdout1_25ck177 = 1.95 time = 1780
* CHECK dout1_26 vdout1_26ck177 = 0 time = 1780
* CHECK dout1_27 vdout1_27ck177 = 1.95 time = 1780
* CHECK dout1_28 vdout1_28ck177 = 1.95 time = 1780
* CHECK dout1_29 vdout1_29ck177 = 1.95 time = 1780
* CHECK dout1_30 vdout1_30ck177 = 0 time = 1780
* CHECK dout1_31 vdout1_31ck177 = 1.95 time = 1780
* CHECK dout1_0 vdout1_0ck178 = 0 time = 1790
* CHECK dout1_1 vdout1_1ck178 = 0 time = 1790
* CHECK dout1_2 vdout1_2ck178 = 0 time = 1790
* CHECK dout1_3 vdout1_3ck178 = 0 time = 1790
* CHECK dout1_4 vdout1_4ck178 = 0 time = 1790
* CHECK dout1_5 vdout1_5ck178 = 1.95 time = 1790
* CHECK dout1_6 vdout1_6ck178 = 1.95 time = 1790
* CHECK dout1_7 vdout1_7ck178 = 1.95 time = 1790
* CHECK dout1_8 vdout1_8ck178 = 1.95 time = 1790
* CHECK dout1_9 vdout1_9ck178 = 0 time = 1790
* CHECK dout1_10 vdout1_10ck178 = 1.95 time = 1790
* CHECK dout1_11 vdout1_11ck178 = 1.95 time = 1790
* CHECK dout1_12 vdout1_12ck178 = 0 time = 1790
* CHECK dout1_13 vdout1_13ck178 = 1.95 time = 1790
* CHECK dout1_14 vdout1_14ck178 = 1.95 time = 1790
* CHECK dout1_15 vdout1_15ck178 = 1.95 time = 1790
* CHECK dout1_16 vdout1_16ck178 = 1.95 time = 1790
* CHECK dout1_17 vdout1_17ck178 = 0 time = 1790
* CHECK dout1_18 vdout1_18ck178 = 0 time = 1790
* CHECK dout1_19 vdout1_19ck178 = 1.95 time = 1790
* CHECK dout1_20 vdout1_20ck178 = 1.95 time = 1790
* CHECK dout1_21 vdout1_21ck178 = 1.95 time = 1790
* CHECK dout1_22 vdout1_22ck178 = 0 time = 1790
* CHECK dout1_23 vdout1_23ck178 = 1.95 time = 1790
* CHECK dout1_24 vdout1_24ck178 = 0 time = 1790
* CHECK dout1_25 vdout1_25ck178 = 1.95 time = 1790
* CHECK dout1_26 vdout1_26ck178 = 0 time = 1790
* CHECK dout1_27 vdout1_27ck178 = 1.95 time = 1790
* CHECK dout1_28 vdout1_28ck178 = 1.95 time = 1790
* CHECK dout1_29 vdout1_29ck178 = 1.95 time = 1790
* CHECK dout1_30 vdout1_30ck178 = 0 time = 1790
* CHECK dout1_31 vdout1_31ck178 = 1.95 time = 1790
* CHECK dout1_0 vdout1_0ck179 = 1.95 time = 1800
* CHECK dout1_1 vdout1_1ck179 = 1.95 time = 1800
* CHECK dout1_2 vdout1_2ck179 = 0 time = 1800
* CHECK dout1_3 vdout1_3ck179 = 1.95 time = 1800
* CHECK dout1_4 vdout1_4ck179 = 1.95 time = 1800
* CHECK dout1_5 vdout1_5ck179 = 1.95 time = 1800
* CHECK dout1_6 vdout1_6ck179 = 1.95 time = 1800
* CHECK dout1_7 vdout1_7ck179 = 1.95 time = 1800
* CHECK dout1_8 vdout1_8ck179 = 1.95 time = 1800
* CHECK dout1_9 vdout1_9ck179 = 1.95 time = 1800
* CHECK dout1_10 vdout1_10ck179 = 0 time = 1800
* CHECK dout1_11 vdout1_11ck179 = 1.95 time = 1800
* CHECK dout1_12 vdout1_12ck179 = 0 time = 1800
* CHECK dout1_13 vdout1_13ck179 = 0 time = 1800
* CHECK dout1_14 vdout1_14ck179 = 1.95 time = 1800
* CHECK dout1_15 vdout1_15ck179 = 0 time = 1800
* CHECK dout1_16 vdout1_16ck179 = 0 time = 1800
* CHECK dout1_17 vdout1_17ck179 = 1.95 time = 1800
* CHECK dout1_18 vdout1_18ck179 = 0 time = 1800
* CHECK dout1_19 vdout1_19ck179 = 0 time = 1800
* CHECK dout1_20 vdout1_20ck179 = 1.95 time = 1800
* CHECK dout1_21 vdout1_21ck179 = 0 time = 1800
* CHECK dout1_22 vdout1_22ck179 = 1.95 time = 1800
* CHECK dout1_23 vdout1_23ck179 = 0 time = 1800
* CHECK dout1_24 vdout1_24ck179 = 1.95 time = 1800
* CHECK dout1_25 vdout1_25ck179 = 0 time = 1800
* CHECK dout1_26 vdout1_26ck179 = 1.95 time = 1800
* CHECK dout1_27 vdout1_27ck179 = 0 time = 1800
* CHECK dout1_28 vdout1_28ck179 = 0 time = 1800
* CHECK dout1_29 vdout1_29ck179 = 0 time = 1800
* CHECK dout1_30 vdout1_30ck179 = 1.95 time = 1800
* CHECK dout1_31 vdout1_31ck179 = 0 time = 1800
* CHECK dout0_0 vdout0_0ck180 = 0 time = 1810
* CHECK dout0_1 vdout0_1ck180 = 0 time = 1810
* CHECK dout0_2 vdout0_2ck180 = 1.95 time = 1810
* CHECK dout0_3 vdout0_3ck180 = 1.95 time = 1810
* CHECK dout0_4 vdout0_4ck180 = 0 time = 1810
* CHECK dout0_5 vdout0_5ck180 = 1.95 time = 1810
* CHECK dout0_6 vdout0_6ck180 = 1.95 time = 1810
* CHECK dout0_7 vdout0_7ck180 = 0 time = 1810
* CHECK dout0_8 vdout0_8ck180 = 0 time = 1810
* CHECK dout0_9 vdout0_9ck180 = 1.95 time = 1810
* CHECK dout0_10 vdout0_10ck180 = 0 time = 1810
* CHECK dout0_11 vdout0_11ck180 = 1.95 time = 1810
* CHECK dout0_12 vdout0_12ck180 = 1.95 time = 1810
* CHECK dout0_13 vdout0_13ck180 = 1.95 time = 1810
* CHECK dout0_14 vdout0_14ck180 = 1.95 time = 1810
* CHECK dout0_15 vdout0_15ck180 = 1.95 time = 1810
* CHECK dout0_16 vdout0_16ck180 = 0 time = 1810
* CHECK dout0_17 vdout0_17ck180 = 1.95 time = 1810
* CHECK dout0_18 vdout0_18ck180 = 1.95 time = 1810
* CHECK dout0_19 vdout0_19ck180 = 1.95 time = 1810
* CHECK dout0_20 vdout0_20ck180 = 0 time = 1810
* CHECK dout0_21 vdout0_21ck180 = 1.95 time = 1810
* CHECK dout0_22 vdout0_22ck180 = 1.95 time = 1810
* CHECK dout0_23 vdout0_23ck180 = 1.95 time = 1810
* CHECK dout0_24 vdout0_24ck180 = 1.95 time = 1810
* CHECK dout0_25 vdout0_25ck180 = 0 time = 1810
* CHECK dout0_26 vdout0_26ck180 = 1.95 time = 1810
* CHECK dout0_27 vdout0_27ck180 = 1.95 time = 1810
* CHECK dout0_28 vdout0_28ck180 = 1.95 time = 1810
* CHECK dout0_29 vdout0_29ck180 = 0 time = 1810
* CHECK dout0_30 vdout0_30ck180 = 0 time = 1810
* CHECK dout0_31 vdout0_31ck180 = 1.95 time = 1810
* CHECK dout1_0 vdout1_0ck180 = 0 time = 1810
* CHECK dout1_1 vdout1_1ck180 = 0 time = 1810
* CHECK dout1_2 vdout1_2ck180 = 0 time = 1810
* CHECK dout1_3 vdout1_3ck180 = 0 time = 1810
* CHECK dout1_4 vdout1_4ck180 = 0 time = 1810
* CHECK dout1_5 vdout1_5ck180 = 1.95 time = 1810
* CHECK dout1_6 vdout1_6ck180 = 1.95 time = 1810
* CHECK dout1_7 vdout1_7ck180 = 1.95 time = 1810
* CHECK dout1_8 vdout1_8ck180 = 1.95 time = 1810
* CHECK dout1_9 vdout1_9ck180 = 0 time = 1810
* CHECK dout1_10 vdout1_10ck180 = 1.95 time = 1810
* CHECK dout1_11 vdout1_11ck180 = 1.95 time = 1810
* CHECK dout1_12 vdout1_12ck180 = 0 time = 1810
* CHECK dout1_13 vdout1_13ck180 = 1.95 time = 1810
* CHECK dout1_14 vdout1_14ck180 = 1.95 time = 1810
* CHECK dout1_15 vdout1_15ck180 = 1.95 time = 1810
* CHECK dout1_16 vdout1_16ck180 = 1.95 time = 1810
* CHECK dout1_17 vdout1_17ck180 = 0 time = 1810
* CHECK dout1_18 vdout1_18ck180 = 0 time = 1810
* CHECK dout1_19 vdout1_19ck180 = 1.95 time = 1810
* CHECK dout1_20 vdout1_20ck180 = 1.95 time = 1810
* CHECK dout1_21 vdout1_21ck180 = 1.95 time = 1810
* CHECK dout1_22 vdout1_22ck180 = 0 time = 1810
* CHECK dout1_23 vdout1_23ck180 = 1.95 time = 1810
* CHECK dout1_24 vdout1_24ck180 = 0 time = 1810
* CHECK dout1_25 vdout1_25ck180 = 1.95 time = 1810
* CHECK dout1_26 vdout1_26ck180 = 0 time = 1810
* CHECK dout1_27 vdout1_27ck180 = 1.95 time = 1810
* CHECK dout1_28 vdout1_28ck180 = 1.95 time = 1810
* CHECK dout1_29 vdout1_29ck180 = 1.95 time = 1810
* CHECK dout1_30 vdout1_30ck180 = 0 time = 1810
* CHECK dout1_31 vdout1_31ck180 = 1.95 time = 1810
* CHECK dout1_0 vdout1_0ck181 = 0 time = 1820
* CHECK dout1_1 vdout1_1ck181 = 0 time = 1820
* CHECK dout1_2 vdout1_2ck181 = 0 time = 1820
* CHECK dout1_3 vdout1_3ck181 = 0 time = 1820
* CHECK dout1_4 vdout1_4ck181 = 0 time = 1820
* CHECK dout1_5 vdout1_5ck181 = 1.95 time = 1820
* CHECK dout1_6 vdout1_6ck181 = 1.95 time = 1820
* CHECK dout1_7 vdout1_7ck181 = 1.95 time = 1820
* CHECK dout1_8 vdout1_8ck181 = 1.95 time = 1820
* CHECK dout1_9 vdout1_9ck181 = 0 time = 1820
* CHECK dout1_10 vdout1_10ck181 = 1.95 time = 1820
* CHECK dout1_11 vdout1_11ck181 = 1.95 time = 1820
* CHECK dout1_12 vdout1_12ck181 = 0 time = 1820
* CHECK dout1_13 vdout1_13ck181 = 1.95 time = 1820
* CHECK dout1_14 vdout1_14ck181 = 1.95 time = 1820
* CHECK dout1_15 vdout1_15ck181 = 1.95 time = 1820
* CHECK dout1_16 vdout1_16ck181 = 1.95 time = 1820
* CHECK dout1_17 vdout1_17ck181 = 0 time = 1820
* CHECK dout1_18 vdout1_18ck181 = 0 time = 1820
* CHECK dout1_19 vdout1_19ck181 = 1.95 time = 1820
* CHECK dout1_20 vdout1_20ck181 = 1.95 time = 1820
* CHECK dout1_21 vdout1_21ck181 = 1.95 time = 1820
* CHECK dout1_22 vdout1_22ck181 = 0 time = 1820
* CHECK dout1_23 vdout1_23ck181 = 1.95 time = 1820
* CHECK dout1_24 vdout1_24ck181 = 0 time = 1820
* CHECK dout1_25 vdout1_25ck181 = 1.95 time = 1820
* CHECK dout1_26 vdout1_26ck181 = 0 time = 1820
* CHECK dout1_27 vdout1_27ck181 = 1.95 time = 1820
* CHECK dout1_28 vdout1_28ck181 = 1.95 time = 1820
* CHECK dout1_29 vdout1_29ck181 = 1.95 time = 1820
* CHECK dout1_30 vdout1_30ck181 = 0 time = 1820
* CHECK dout1_31 vdout1_31ck181 = 1.95 time = 1820
* CHECK dout0_0 vdout0_0ck182 = 0 time = 1830
* CHECK dout0_1 vdout0_1ck182 = 0 time = 1830
* CHECK dout0_2 vdout0_2ck182 = 0 time = 1830
* CHECK dout0_3 vdout0_3ck182 = 0 time = 1830
* CHECK dout0_4 vdout0_4ck182 = 0 time = 1830
* CHECK dout0_5 vdout0_5ck182 = 1.95 time = 1830
* CHECK dout0_6 vdout0_6ck182 = 1.95 time = 1830
* CHECK dout0_7 vdout0_7ck182 = 1.95 time = 1830
* CHECK dout0_8 vdout0_8ck182 = 1.95 time = 1830
* CHECK dout0_9 vdout0_9ck182 = 0 time = 1830
* CHECK dout0_10 vdout0_10ck182 = 1.95 time = 1830
* CHECK dout0_11 vdout0_11ck182 = 1.95 time = 1830
* CHECK dout0_12 vdout0_12ck182 = 0 time = 1830
* CHECK dout0_13 vdout0_13ck182 = 1.95 time = 1830
* CHECK dout0_14 vdout0_14ck182 = 1.95 time = 1830
* CHECK dout0_15 vdout0_15ck182 = 1.95 time = 1830
* CHECK dout0_16 vdout0_16ck182 = 1.95 time = 1830
* CHECK dout0_17 vdout0_17ck182 = 0 time = 1830
* CHECK dout0_18 vdout0_18ck182 = 0 time = 1830
* CHECK dout0_19 vdout0_19ck182 = 1.95 time = 1830
* CHECK dout0_20 vdout0_20ck182 = 1.95 time = 1830
* CHECK dout0_21 vdout0_21ck182 = 1.95 time = 1830
* CHECK dout0_22 vdout0_22ck182 = 0 time = 1830
* CHECK dout0_23 vdout0_23ck182 = 1.95 time = 1830
* CHECK dout0_24 vdout0_24ck182 = 0 time = 1830
* CHECK dout0_25 vdout0_25ck182 = 1.95 time = 1830
* CHECK dout0_26 vdout0_26ck182 = 0 time = 1830
* CHECK dout0_27 vdout0_27ck182 = 1.95 time = 1830
* CHECK dout0_28 vdout0_28ck182 = 1.95 time = 1830
* CHECK dout0_29 vdout0_29ck182 = 1.95 time = 1830
* CHECK dout0_30 vdout0_30ck182 = 0 time = 1830
* CHECK dout0_31 vdout0_31ck182 = 1.95 time = 1830
* CHECK dout1_0 vdout1_0ck182 = 1.95 time = 1830
* CHECK dout1_1 vdout1_1ck182 = 1.95 time = 1830
* CHECK dout1_2 vdout1_2ck182 = 0 time = 1830
* CHECK dout1_3 vdout1_3ck182 = 1.95 time = 1830
* CHECK dout1_4 vdout1_4ck182 = 1.95 time = 1830
* CHECK dout1_5 vdout1_5ck182 = 1.95 time = 1830
* CHECK dout1_6 vdout1_6ck182 = 1.95 time = 1830
* CHECK dout1_7 vdout1_7ck182 = 1.95 time = 1830
* CHECK dout1_8 vdout1_8ck182 = 1.95 time = 1830
* CHECK dout1_9 vdout1_9ck182 = 1.95 time = 1830
* CHECK dout1_10 vdout1_10ck182 = 0 time = 1830
* CHECK dout1_11 vdout1_11ck182 = 1.95 time = 1830
* CHECK dout1_12 vdout1_12ck182 = 0 time = 1830
* CHECK dout1_13 vdout1_13ck182 = 0 time = 1830
* CHECK dout1_14 vdout1_14ck182 = 1.95 time = 1830
* CHECK dout1_15 vdout1_15ck182 = 0 time = 1830
* CHECK dout1_16 vdout1_16ck182 = 0 time = 1830
* CHECK dout1_17 vdout1_17ck182 = 1.95 time = 1830
* CHECK dout1_18 vdout1_18ck182 = 0 time = 1830
* CHECK dout1_19 vdout1_19ck182 = 0 time = 1830
* CHECK dout1_20 vdout1_20ck182 = 1.95 time = 1830
* CHECK dout1_21 vdout1_21ck182 = 0 time = 1830
* CHECK dout1_22 vdout1_22ck182 = 1.95 time = 1830
* CHECK dout1_23 vdout1_23ck182 = 0 time = 1830
* CHECK dout1_24 vdout1_24ck182 = 1.95 time = 1830
* CHECK dout1_25 vdout1_25ck182 = 0 time = 1830
* CHECK dout1_26 vdout1_26ck182 = 1.95 time = 1830
* CHECK dout1_27 vdout1_27ck182 = 0 time = 1830
* CHECK dout1_28 vdout1_28ck182 = 0 time = 1830
* CHECK dout1_29 vdout1_29ck182 = 0 time = 1830
* CHECK dout1_30 vdout1_30ck182 = 1.95 time = 1830
* CHECK dout1_31 vdout1_31ck182 = 0 time = 1830
* CHECK dout1_0 vdout1_0ck183 = 0 time = 1840
* CHECK dout1_1 vdout1_1ck183 = 0 time = 1840
* CHECK dout1_2 vdout1_2ck183 = 0 time = 1840
* CHECK dout1_3 vdout1_3ck183 = 0 time = 1840
* CHECK dout1_4 vdout1_4ck183 = 0 time = 1840
* CHECK dout1_5 vdout1_5ck183 = 1.95 time = 1840
* CHECK dout1_6 vdout1_6ck183 = 1.95 time = 1840
* CHECK dout1_7 vdout1_7ck183 = 1.95 time = 1840
* CHECK dout1_8 vdout1_8ck183 = 1.95 time = 1840
* CHECK dout1_9 vdout1_9ck183 = 0 time = 1840
* CHECK dout1_10 vdout1_10ck183 = 1.95 time = 1840
* CHECK dout1_11 vdout1_11ck183 = 1.95 time = 1840
* CHECK dout1_12 vdout1_12ck183 = 0 time = 1840
* CHECK dout1_13 vdout1_13ck183 = 1.95 time = 1840
* CHECK dout1_14 vdout1_14ck183 = 1.95 time = 1840
* CHECK dout1_15 vdout1_15ck183 = 1.95 time = 1840
* CHECK dout1_16 vdout1_16ck183 = 1.95 time = 1840
* CHECK dout1_17 vdout1_17ck183 = 0 time = 1840
* CHECK dout1_18 vdout1_18ck183 = 0 time = 1840
* CHECK dout1_19 vdout1_19ck183 = 1.95 time = 1840
* CHECK dout1_20 vdout1_20ck183 = 1.95 time = 1840
* CHECK dout1_21 vdout1_21ck183 = 1.95 time = 1840
* CHECK dout1_22 vdout1_22ck183 = 0 time = 1840
* CHECK dout1_23 vdout1_23ck183 = 1.95 time = 1840
* CHECK dout1_24 vdout1_24ck183 = 0 time = 1840
* CHECK dout1_25 vdout1_25ck183 = 1.95 time = 1840
* CHECK dout1_26 vdout1_26ck183 = 0 time = 1840
* CHECK dout1_27 vdout1_27ck183 = 1.95 time = 1840
* CHECK dout1_28 vdout1_28ck183 = 1.95 time = 1840
* CHECK dout1_29 vdout1_29ck183 = 1.95 time = 1840
* CHECK dout1_30 vdout1_30ck183 = 0 time = 1840
* CHECK dout1_31 vdout1_31ck183 = 1.95 time = 1840
* CHECK dout1_0 vdout1_0ck185 = 1.95 time = 1860
* CHECK dout1_1 vdout1_1ck185 = 1.95 time = 1860
* CHECK dout1_2 vdout1_2ck185 = 0 time = 1860
* CHECK dout1_3 vdout1_3ck185 = 1.95 time = 1860
* CHECK dout1_4 vdout1_4ck185 = 1.95 time = 1860
* CHECK dout1_5 vdout1_5ck185 = 1.95 time = 1860
* CHECK dout1_6 vdout1_6ck185 = 1.95 time = 1860
* CHECK dout1_7 vdout1_7ck185 = 1.95 time = 1860
* CHECK dout1_8 vdout1_8ck185 = 1.95 time = 1860
* CHECK dout1_9 vdout1_9ck185 = 1.95 time = 1860
* CHECK dout1_10 vdout1_10ck185 = 0 time = 1860
* CHECK dout1_11 vdout1_11ck185 = 1.95 time = 1860
* CHECK dout1_12 vdout1_12ck185 = 0 time = 1860
* CHECK dout1_13 vdout1_13ck185 = 0 time = 1860
* CHECK dout1_14 vdout1_14ck185 = 1.95 time = 1860
* CHECK dout1_15 vdout1_15ck185 = 0 time = 1860
* CHECK dout1_16 vdout1_16ck185 = 0 time = 1860
* CHECK dout1_17 vdout1_17ck185 = 1.95 time = 1860
* CHECK dout1_18 vdout1_18ck185 = 0 time = 1860
* CHECK dout1_19 vdout1_19ck185 = 0 time = 1860
* CHECK dout1_20 vdout1_20ck185 = 1.95 time = 1860
* CHECK dout1_21 vdout1_21ck185 = 0 time = 1860
* CHECK dout1_22 vdout1_22ck185 = 1.95 time = 1860
* CHECK dout1_23 vdout1_23ck185 = 0 time = 1860
* CHECK dout1_24 vdout1_24ck185 = 1.95 time = 1860
* CHECK dout1_25 vdout1_25ck185 = 0 time = 1860
* CHECK dout1_26 vdout1_26ck185 = 1.95 time = 1860
* CHECK dout1_27 vdout1_27ck185 = 0 time = 1860
* CHECK dout1_28 vdout1_28ck185 = 0 time = 1860
* CHECK dout1_29 vdout1_29ck185 = 0 time = 1860
* CHECK dout1_30 vdout1_30ck185 = 1.95 time = 1860
* CHECK dout1_31 vdout1_31ck185 = 0 time = 1860
* CHECK dout1_0 vdout1_0ck188 = 0 time = 1890
* CHECK dout1_1 vdout1_1ck188 = 0 time = 1890
* CHECK dout1_2 vdout1_2ck188 = 1.95 time = 1890
* CHECK dout1_3 vdout1_3ck188 = 0 time = 1890
* CHECK dout1_4 vdout1_4ck188 = 1.95 time = 1890
* CHECK dout1_5 vdout1_5ck188 = 0 time = 1890
* CHECK dout1_6 vdout1_6ck188 = 0 time = 1890
* CHECK dout1_7 vdout1_7ck188 = 1.95 time = 1890
* CHECK dout1_8 vdout1_8ck188 = 0 time = 1890
* CHECK dout1_9 vdout1_9ck188 = 0 time = 1890
* CHECK dout1_10 vdout1_10ck188 = 0 time = 1890
* CHECK dout1_11 vdout1_11ck188 = 0 time = 1890
* CHECK dout1_12 vdout1_12ck188 = 1.95 time = 1890
* CHECK dout1_13 vdout1_13ck188 = 1.95 time = 1890
* CHECK dout1_14 vdout1_14ck188 = 1.95 time = 1890
* CHECK dout1_15 vdout1_15ck188 = 0 time = 1890
* CHECK dout1_16 vdout1_16ck188 = 0 time = 1890
* CHECK dout1_17 vdout1_17ck188 = 0 time = 1890
* CHECK dout1_18 vdout1_18ck188 = 1.95 time = 1890
* CHECK dout1_19 vdout1_19ck188 = 1.95 time = 1890
* CHECK dout1_20 vdout1_20ck188 = 0 time = 1890
* CHECK dout1_21 vdout1_21ck188 = 1.95 time = 1890
* CHECK dout1_22 vdout1_22ck188 = 0 time = 1890
* CHECK dout1_23 vdout1_23ck188 = 0 time = 1890
* CHECK dout1_24 vdout1_24ck188 = 1.95 time = 1890
* CHECK dout1_25 vdout1_25ck188 = 1.95 time = 1890
* CHECK dout1_26 vdout1_26ck188 = 1.95 time = 1890
* CHECK dout1_27 vdout1_27ck188 = 0 time = 1890
* CHECK dout1_28 vdout1_28ck188 = 1.95 time = 1890
* CHECK dout1_29 vdout1_29ck188 = 0 time = 1890
* CHECK dout1_30 vdout1_30ck188 = 1.95 time = 1890
* CHECK dout1_31 vdout1_31ck188 = 1.95 time = 1890
* CHECK dout0_0 vdout0_0ck189 = 1.95 time = 1900
* CHECK dout0_1 vdout0_1ck189 = 0 time = 1900
* CHECK dout0_2 vdout0_2ck189 = 1.95 time = 1900
* CHECK dout0_3 vdout0_3ck189 = 1.95 time = 1900
* CHECK dout0_4 vdout0_4ck189 = 1.95 time = 1900
* CHECK dout0_5 vdout0_5ck189 = 1.95 time = 1900
* CHECK dout0_6 vdout0_6ck189 = 1.95 time = 1900
* CHECK dout0_7 vdout0_7ck189 = 1.95 time = 1900
* CHECK dout0_8 vdout0_8ck189 = 1.95 time = 1900
* CHECK dout0_9 vdout0_9ck189 = 0 time = 1900
* CHECK dout0_10 vdout0_10ck189 = 0 time = 1900
* CHECK dout0_11 vdout0_11ck189 = 1.95 time = 1900
* CHECK dout0_12 vdout0_12ck189 = 1.95 time = 1900
* CHECK dout0_13 vdout0_13ck189 = 0 time = 1900
* CHECK dout0_14 vdout0_14ck189 = 1.95 time = 1900
* CHECK dout0_15 vdout0_15ck189 = 1.95 time = 1900
* CHECK dout0_16 vdout0_16ck189 = 1.95 time = 1900
* CHECK dout0_17 vdout0_17ck189 = 0 time = 1900
* CHECK dout0_18 vdout0_18ck189 = 0 time = 1900
* CHECK dout0_19 vdout0_19ck189 = 1.95 time = 1900
* CHECK dout0_20 vdout0_20ck189 = 1.95 time = 1900
* CHECK dout0_21 vdout0_21ck189 = 1.95 time = 1900
* CHECK dout0_22 vdout0_22ck189 = 0 time = 1900
* CHECK dout0_23 vdout0_23ck189 = 1.95 time = 1900
* CHECK dout0_24 vdout0_24ck189 = 0 time = 1900
* CHECK dout0_25 vdout0_25ck189 = 0 time = 1900
* CHECK dout0_26 vdout0_26ck189 = 0 time = 1900
* CHECK dout0_27 vdout0_27ck189 = 1.95 time = 1900
* CHECK dout0_28 vdout0_28ck189 = 1.95 time = 1900
* CHECK dout0_29 vdout0_29ck189 = 1.95 time = 1900
* CHECK dout0_30 vdout0_30ck189 = 1.95 time = 1900
* CHECK dout0_31 vdout0_31ck189 = 1.95 time = 1900
* CHECK dout1_0 vdout1_0ck189 = 0 time = 1900
* CHECK dout1_1 vdout1_1ck189 = 0 time = 1900
* CHECK dout1_2 vdout1_2ck189 = 1.95 time = 1900
* CHECK dout1_3 vdout1_3ck189 = 1.95 time = 1900
* CHECK dout1_4 vdout1_4ck189 = 0 time = 1900
* CHECK dout1_5 vdout1_5ck189 = 1.95 time = 1900
* CHECK dout1_6 vdout1_6ck189 = 1.95 time = 1900
* CHECK dout1_7 vdout1_7ck189 = 0 time = 1900
* CHECK dout1_8 vdout1_8ck189 = 1.95 time = 1900
* CHECK dout1_9 vdout1_9ck189 = 1.95 time = 1900
* CHECK dout1_10 vdout1_10ck189 = 1.95 time = 1900
* CHECK dout1_11 vdout1_11ck189 = 0 time = 1900
* CHECK dout1_12 vdout1_12ck189 = 1.95 time = 1900
* CHECK dout1_13 vdout1_13ck189 = 0 time = 1900
* CHECK dout1_14 vdout1_14ck189 = 1.95 time = 1900
* CHECK dout1_15 vdout1_15ck189 = 1.95 time = 1900
* CHECK dout1_16 vdout1_16ck189 = 0 time = 1900
* CHECK dout1_17 vdout1_17ck189 = 1.95 time = 1900
* CHECK dout1_18 vdout1_18ck189 = 1.95 time = 1900
* CHECK dout1_19 vdout1_19ck189 = 1.95 time = 1900
* CHECK dout1_20 vdout1_20ck189 = 0 time = 1900
* CHECK dout1_21 vdout1_21ck189 = 1.95 time = 1900
* CHECK dout1_22 vdout1_22ck189 = 1.95 time = 1900
* CHECK dout1_23 vdout1_23ck189 = 1.95 time = 1900
* CHECK dout1_24 vdout1_24ck189 = 1.95 time = 1900
* CHECK dout1_25 vdout1_25ck189 = 0 time = 1900
* CHECK dout1_26 vdout1_26ck189 = 1.95 time = 1900
* CHECK dout1_27 vdout1_27ck189 = 1.95 time = 1900
* CHECK dout1_28 vdout1_28ck189 = 1.95 time = 1900
* CHECK dout1_29 vdout1_29ck189 = 0 time = 1900
* CHECK dout1_30 vdout1_30ck189 = 0 time = 1900
* CHECK dout1_31 vdout1_31ck189 = 1.95 time = 1900
* CHECK dout0_0 vdout0_0ck190 = 0 time = 1910
* CHECK dout0_1 vdout0_1ck190 = 0 time = 1910
* CHECK dout0_2 vdout0_2ck190 = 1.95 time = 1910
* CHECK dout0_3 vdout0_3ck190 = 0 time = 1910
* CHECK dout0_4 vdout0_4ck190 = 1.95 time = 1910
* CHECK dout0_5 vdout0_5ck190 = 0 time = 1910
* CHECK dout0_6 vdout0_6ck190 = 0 time = 1910
* CHECK dout0_7 vdout0_7ck190 = 1.95 time = 1910
* CHECK dout0_8 vdout0_8ck190 = 0 time = 1910
* CHECK dout0_9 vdout0_9ck190 = 0 time = 1910
* CHECK dout0_10 vdout0_10ck190 = 0 time = 1910
* CHECK dout0_11 vdout0_11ck190 = 0 time = 1910
* CHECK dout0_12 vdout0_12ck190 = 1.95 time = 1910
* CHECK dout0_13 vdout0_13ck190 = 1.95 time = 1910
* CHECK dout0_14 vdout0_14ck190 = 1.95 time = 1910
* CHECK dout0_15 vdout0_15ck190 = 0 time = 1910
* CHECK dout0_16 vdout0_16ck190 = 0 time = 1910
* CHECK dout0_17 vdout0_17ck190 = 0 time = 1910
* CHECK dout0_18 vdout0_18ck190 = 1.95 time = 1910
* CHECK dout0_19 vdout0_19ck190 = 1.95 time = 1910
* CHECK dout0_20 vdout0_20ck190 = 0 time = 1910
* CHECK dout0_21 vdout0_21ck190 = 1.95 time = 1910
* CHECK dout0_22 vdout0_22ck190 = 0 time = 1910
* CHECK dout0_23 vdout0_23ck190 = 0 time = 1910
* CHECK dout0_24 vdout0_24ck190 = 1.95 time = 1910
* CHECK dout0_25 vdout0_25ck190 = 1.95 time = 1910
* CHECK dout0_26 vdout0_26ck190 = 1.95 time = 1910
* CHECK dout0_27 vdout0_27ck190 = 0 time = 1910
* CHECK dout0_28 vdout0_28ck190 = 1.95 time = 1910
* CHECK dout0_29 vdout0_29ck190 = 0 time = 1910
* CHECK dout0_30 vdout0_30ck190 = 1.95 time = 1910
* CHECK dout0_31 vdout0_31ck190 = 1.95 time = 1910
* CHECK dout1_0 vdout1_0ck190 = 0 time = 1910
* CHECK dout1_1 vdout1_1ck190 = 0 time = 1910
* CHECK dout1_2 vdout1_2ck190 = 1.95 time = 1910
* CHECK dout1_3 vdout1_3ck190 = 1.95 time = 1910
* CHECK dout1_4 vdout1_4ck190 = 0 time = 1910
* CHECK dout1_5 vdout1_5ck190 = 1.95 time = 1910
* CHECK dout1_6 vdout1_6ck190 = 1.95 time = 1910
* CHECK dout1_7 vdout1_7ck190 = 0 time = 1910
* CHECK dout1_8 vdout1_8ck190 = 1.95 time = 1910
* CHECK dout1_9 vdout1_9ck190 = 1.95 time = 1910
* CHECK dout1_10 vdout1_10ck190 = 1.95 time = 1910
* CHECK dout1_11 vdout1_11ck190 = 0 time = 1910
* CHECK dout1_12 vdout1_12ck190 = 1.95 time = 1910
* CHECK dout1_13 vdout1_13ck190 = 0 time = 1910
* CHECK dout1_14 vdout1_14ck190 = 1.95 time = 1910
* CHECK dout1_15 vdout1_15ck190 = 1.95 time = 1910
* CHECK dout1_16 vdout1_16ck190 = 0 time = 1910
* CHECK dout1_17 vdout1_17ck190 = 1.95 time = 1910
* CHECK dout1_18 vdout1_18ck190 = 1.95 time = 1910
* CHECK dout1_19 vdout1_19ck190 = 1.95 time = 1910
* CHECK dout1_20 vdout1_20ck190 = 0 time = 1910
* CHECK dout1_21 vdout1_21ck190 = 1.95 time = 1910
* CHECK dout1_22 vdout1_22ck190 = 1.95 time = 1910
* CHECK dout1_23 vdout1_23ck190 = 1.95 time = 1910
* CHECK dout1_24 vdout1_24ck190 = 1.95 time = 1910
* CHECK dout1_25 vdout1_25ck190 = 0 time = 1910
* CHECK dout1_26 vdout1_26ck190 = 1.95 time = 1910
* CHECK dout1_27 vdout1_27ck190 = 1.95 time = 1910
* CHECK dout1_28 vdout1_28ck190 = 1.95 time = 1910
* CHECK dout1_29 vdout1_29ck190 = 0 time = 1910
* CHECK dout1_30 vdout1_30ck190 = 0 time = 1910
* CHECK dout1_31 vdout1_31ck190 = 1.95 time = 1910
* CHECK dout0_0 vdout0_0ck192 = 0 time = 1930
* CHECK dout0_1 vdout0_1ck192 = 0 time = 1930
* CHECK dout0_2 vdout0_2ck192 = 1.95 time = 1930
* CHECK dout0_3 vdout0_3ck192 = 1.95 time = 1930
* CHECK dout0_4 vdout0_4ck192 = 0 time = 1930
* CHECK dout0_5 vdout0_5ck192 = 1.95 time = 1930
* CHECK dout0_6 vdout0_6ck192 = 1.95 time = 1930
* CHECK dout0_7 vdout0_7ck192 = 0 time = 1930
* CHECK dout0_8 vdout0_8ck192 = 1.95 time = 1930
* CHECK dout0_9 vdout0_9ck192 = 1.95 time = 1930
* CHECK dout0_10 vdout0_10ck192 = 1.95 time = 1930
* CHECK dout0_11 vdout0_11ck192 = 0 time = 1930
* CHECK dout0_12 vdout0_12ck192 = 1.95 time = 1930
* CHECK dout0_13 vdout0_13ck192 = 0 time = 1930
* CHECK dout0_14 vdout0_14ck192 = 1.95 time = 1930
* CHECK dout0_15 vdout0_15ck192 = 1.95 time = 1930
* CHECK dout0_16 vdout0_16ck192 = 0 time = 1930
* CHECK dout0_17 vdout0_17ck192 = 1.95 time = 1930
* CHECK dout0_18 vdout0_18ck192 = 1.95 time = 1930
* CHECK dout0_19 vdout0_19ck192 = 1.95 time = 1930
* CHECK dout0_20 vdout0_20ck192 = 0 time = 1930
* CHECK dout0_21 vdout0_21ck192 = 1.95 time = 1930
* CHECK dout0_22 vdout0_22ck192 = 1.95 time = 1930
* CHECK dout0_23 vdout0_23ck192 = 1.95 time = 1930
* CHECK dout0_24 vdout0_24ck192 = 1.95 time = 1930
* CHECK dout0_25 vdout0_25ck192 = 0 time = 1930
* CHECK dout0_26 vdout0_26ck192 = 1.95 time = 1930
* CHECK dout0_27 vdout0_27ck192 = 1.95 time = 1930
* CHECK dout0_28 vdout0_28ck192 = 1.95 time = 1930
* CHECK dout0_29 vdout0_29ck192 = 0 time = 1930
* CHECK dout0_30 vdout0_30ck192 = 0 time = 1930
* CHECK dout0_31 vdout0_31ck192 = 1.95 time = 1930
* CHECK dout1_0 vdout1_0ck192 = 1.95 time = 1930
* CHECK dout1_1 vdout1_1ck192 = 0 time = 1930
* CHECK dout1_2 vdout1_2ck192 = 1.95 time = 1930
* CHECK dout1_3 vdout1_3ck192 = 1.95 time = 1930
* CHECK dout1_4 vdout1_4ck192 = 1.95 time = 1930
* CHECK dout1_5 vdout1_5ck192 = 1.95 time = 1930
* CHECK dout1_6 vdout1_6ck192 = 1.95 time = 1930
* CHECK dout1_7 vdout1_7ck192 = 1.95 time = 1930
* CHECK dout1_8 vdout1_8ck192 = 1.95 time = 1930
* CHECK dout1_9 vdout1_9ck192 = 0 time = 1930
* CHECK dout1_10 vdout1_10ck192 = 0 time = 1930
* CHECK dout1_11 vdout1_11ck192 = 1.95 time = 1930
* CHECK dout1_12 vdout1_12ck192 = 1.95 time = 1930
* CHECK dout1_13 vdout1_13ck192 = 0 time = 1930
* CHECK dout1_14 vdout1_14ck192 = 1.95 time = 1930
* CHECK dout1_15 vdout1_15ck192 = 1.95 time = 1930
* CHECK dout1_16 vdout1_16ck192 = 1.95 time = 1930
* CHECK dout1_17 vdout1_17ck192 = 0 time = 1930
* CHECK dout1_18 vdout1_18ck192 = 0 time = 1930
* CHECK dout1_19 vdout1_19ck192 = 1.95 time = 1930
* CHECK dout1_20 vdout1_20ck192 = 1.95 time = 1930
* CHECK dout1_21 vdout1_21ck192 = 1.95 time = 1930
* CHECK dout1_22 vdout1_22ck192 = 0 time = 1930
* CHECK dout1_23 vdout1_23ck192 = 1.95 time = 1930
* CHECK dout1_24 vdout1_24ck192 = 0 time = 1930
* CHECK dout1_25 vdout1_25ck192 = 0 time = 1930
* CHECK dout1_26 vdout1_26ck192 = 0 time = 1930
* CHECK dout1_27 vdout1_27ck192 = 1.95 time = 1930
* CHECK dout1_28 vdout1_28ck192 = 1.95 time = 1930
* CHECK dout1_29 vdout1_29ck192 = 1.95 time = 1930
* CHECK dout1_30 vdout1_30ck192 = 1.95 time = 1930
* CHECK dout1_31 vdout1_31ck192 = 1.95 time = 1930
* CHECK dout0_0 vdout0_0ck194 = 0 time = 1950
* CHECK dout0_1 vdout0_1ck194 = 1.95 time = 1950
* CHECK dout0_2 vdout0_2ck194 = 0 time = 1950
* CHECK dout0_3 vdout0_3ck194 = 0 time = 1950
* CHECK dout0_4 vdout0_4ck194 = 1.95 time = 1950
* CHECK dout0_5 vdout0_5ck194 = 1.95 time = 1950
* CHECK dout0_6 vdout0_6ck194 = 0 time = 1950
* CHECK dout0_7 vdout0_7ck194 = 1.95 time = 1950
* CHECK dout0_8 vdout0_8ck194 = 1.95 time = 1950
* CHECK dout0_9 vdout0_9ck194 = 1.95 time = 1950
* CHECK dout0_10 vdout0_10ck194 = 0 time = 1950
* CHECK dout0_11 vdout0_11ck194 = 1.95 time = 1950
* CHECK dout0_12 vdout0_12ck194 = 0 time = 1950
* CHECK dout0_13 vdout0_13ck194 = 0 time = 1950
* CHECK dout0_14 vdout0_14ck194 = 0 time = 1950
* CHECK dout0_15 vdout0_15ck194 = 1.95 time = 1950
* CHECK dout0_16 vdout0_16ck194 = 1.95 time = 1950
* CHECK dout0_17 vdout0_17ck194 = 0 time = 1950
* CHECK dout0_18 vdout0_18ck194 = 0 time = 1950
* CHECK dout0_19 vdout0_19ck194 = 0 time = 1950
* CHECK dout0_20 vdout0_20ck194 = 1.95 time = 1950
* CHECK dout0_21 vdout0_21ck194 = 1.95 time = 1950
* CHECK dout0_22 vdout0_22ck194 = 0 time = 1950
* CHECK dout0_23 vdout0_23ck194 = 1.95 time = 1950
* CHECK dout0_24 vdout0_24ck194 = 1.95 time = 1950
* CHECK dout0_25 vdout0_25ck194 = 0 time = 1950
* CHECK dout0_26 vdout0_26ck194 = 1.95 time = 1950
* CHECK dout0_27 vdout0_27ck194 = 0 time = 1950
* CHECK dout0_28 vdout0_28ck194 = 0 time = 1950
* CHECK dout0_29 vdout0_29ck194 = 0 time = 1950
* CHECK dout0_30 vdout0_30ck194 = 0 time = 1950
* CHECK dout0_31 vdout0_31ck194 = 0 time = 1950
* CHECK dout1_0 vdout1_0ck195 = 1.95 time = 1960
* CHECK dout1_1 vdout1_1ck195 = 0 time = 1960
* CHECK dout1_2 vdout1_2ck195 = 1.95 time = 1960
* CHECK dout1_3 vdout1_3ck195 = 1.95 time = 1960
* CHECK dout1_4 vdout1_4ck195 = 1.95 time = 1960
* CHECK dout1_5 vdout1_5ck195 = 1.95 time = 1960
* CHECK dout1_6 vdout1_6ck195 = 1.95 time = 1960
* CHECK dout1_7 vdout1_7ck195 = 1.95 time = 1960
* CHECK dout1_8 vdout1_8ck195 = 1.95 time = 1960
* CHECK dout1_9 vdout1_9ck195 = 0 time = 1960
* CHECK dout1_10 vdout1_10ck195 = 0 time = 1960
* CHECK dout1_11 vdout1_11ck195 = 1.95 time = 1960
* CHECK dout1_12 vdout1_12ck195 = 1.95 time = 1960
* CHECK dout1_13 vdout1_13ck195 = 0 time = 1960
* CHECK dout1_14 vdout1_14ck195 = 1.95 time = 1960
* CHECK dout1_15 vdout1_15ck195 = 1.95 time = 1960
* CHECK dout1_16 vdout1_16ck195 = 1.95 time = 1960
* CHECK dout1_17 vdout1_17ck195 = 0 time = 1960
* CHECK dout1_18 vdout1_18ck195 = 0 time = 1960
* CHECK dout1_19 vdout1_19ck195 = 1.95 time = 1960
* CHECK dout1_20 vdout1_20ck195 = 1.95 time = 1960
* CHECK dout1_21 vdout1_21ck195 = 1.95 time = 1960
* CHECK dout1_22 vdout1_22ck195 = 0 time = 1960
* CHECK dout1_23 vdout1_23ck195 = 1.95 time = 1960
* CHECK dout1_24 vdout1_24ck195 = 0 time = 1960
* CHECK dout1_25 vdout1_25ck195 = 0 time = 1960
* CHECK dout1_26 vdout1_26ck195 = 0 time = 1960
* CHECK dout1_27 vdout1_27ck195 = 1.95 time = 1960
* CHECK dout1_28 vdout1_28ck195 = 1.95 time = 1960
* CHECK dout1_29 vdout1_29ck195 = 1.95 time = 1960
* CHECK dout1_30 vdout1_30ck195 = 1.95 time = 1960
* CHECK dout1_31 vdout1_31ck195 = 1.95 time = 1960
* CHECK dout1_0 vdout1_0ck198 = 1.95 time = 1990
* CHECK dout1_1 vdout1_1ck198 = 0 time = 1990
* CHECK dout1_2 vdout1_2ck198 = 0 time = 1990
* CHECK dout1_3 vdout1_3ck198 = 1.95 time = 1990
* CHECK dout1_4 vdout1_4ck198 = 0 time = 1990
* CHECK dout1_5 vdout1_5ck198 = 0 time = 1990
* CHECK dout1_6 vdout1_6ck198 = 0 time = 1990
* CHECK dout1_7 vdout1_7ck198 = 1.95 time = 1990
* CHECK dout1_8 vdout1_8ck198 = 0 time = 1990
* CHECK dout1_9 vdout1_9ck198 = 1.95 time = 1990
* CHECK dout1_10 vdout1_10ck198 = 1.95 time = 1990
* CHECK dout1_11 vdout1_11ck198 = 0 time = 1990
* CHECK dout1_12 vdout1_12ck198 = 0 time = 1990
* CHECK dout1_13 vdout1_13ck198 = 0 time = 1990
* CHECK dout1_14 vdout1_14ck198 = 1.95 time = 1990
* CHECK dout1_15 vdout1_15ck198 = 1.95 time = 1990
* CHECK dout1_16 vdout1_16ck198 = 0 time = 1990
* CHECK dout1_17 vdout1_17ck198 = 0 time = 1990
* CHECK dout1_18 vdout1_18ck198 = 1.95 time = 1990
* CHECK dout1_19 vdout1_19ck198 = 1.95 time = 1990
* CHECK dout1_20 vdout1_20ck198 = 1.95 time = 1990
* CHECK dout1_21 vdout1_21ck198 = 1.95 time = 1990
* CHECK dout1_22 vdout1_22ck198 = 0 time = 1990
* CHECK dout1_23 vdout1_23ck198 = 1.95 time = 1990
* CHECK dout1_24 vdout1_24ck198 = 0 time = 1990
* CHECK dout1_25 vdout1_25ck198 = 0 time = 1990
* CHECK dout1_26 vdout1_26ck198 = 1.95 time = 1990
* CHECK dout1_27 vdout1_27ck198 = 0 time = 1990
* CHECK dout1_28 vdout1_28ck198 = 1.95 time = 1990
* CHECK dout1_29 vdout1_29ck198 = 0 time = 1990
* CHECK dout1_30 vdout1_30ck198 = 1.95 time = 1990
* CHECK dout1_31 vdout1_31ck198 = 1.95 time = 1990
* CHECK dout0_0 vdout0_0ck200 = 0 time = 2010
* CHECK dout0_1 vdout0_1ck200 = 1.95 time = 2010
* CHECK dout0_2 vdout0_2ck200 = 0 time = 2010
* CHECK dout0_3 vdout0_3ck200 = 0 time = 2010
* CHECK dout0_4 vdout0_4ck200 = 1.95 time = 2010
* CHECK dout0_5 vdout0_5ck200 = 1.95 time = 2010
* CHECK dout0_6 vdout0_6ck200 = 0 time = 2010
* CHECK dout0_7 vdout0_7ck200 = 1.95 time = 2010
* CHECK dout0_8 vdout0_8ck200 = 1.95 time = 2010
* CHECK dout0_9 vdout0_9ck200 = 1.95 time = 2010
* CHECK dout0_10 vdout0_10ck200 = 0 time = 2010
* CHECK dout0_11 vdout0_11ck200 = 1.95 time = 2010
* CHECK dout0_12 vdout0_12ck200 = 0 time = 2010
* CHECK dout0_13 vdout0_13ck200 = 0 time = 2010
* CHECK dout0_14 vdout0_14ck200 = 0 time = 2010
* CHECK dout0_15 vdout0_15ck200 = 1.95 time = 2010
* CHECK dout0_16 vdout0_16ck200 = 1.95 time = 2010
* CHECK dout0_17 vdout0_17ck200 = 0 time = 2010
* CHECK dout0_18 vdout0_18ck200 = 0 time = 2010
* CHECK dout0_19 vdout0_19ck200 = 0 time = 2010
* CHECK dout0_20 vdout0_20ck200 = 1.95 time = 2010
* CHECK dout0_21 vdout0_21ck200 = 1.95 time = 2010
* CHECK dout0_22 vdout0_22ck200 = 0 time = 2010
* CHECK dout0_23 vdout0_23ck200 = 1.95 time = 2010
* CHECK dout0_24 vdout0_24ck200 = 1.95 time = 2010
* CHECK dout0_25 vdout0_25ck200 = 0 time = 2010
* CHECK dout0_26 vdout0_26ck200 = 1.95 time = 2010
* CHECK dout0_27 vdout0_27ck200 = 0 time = 2010
* CHECK dout0_28 vdout0_28ck200 = 0 time = 2010
* CHECK dout0_29 vdout0_29ck200 = 0 time = 2010
* CHECK dout0_30 vdout0_30ck200 = 0 time = 2010
* CHECK dout0_31 vdout0_31ck200 = 0 time = 2010
* CHECK dout0_0 vdout0_0ck201 = 0 time = 2020
* CHECK dout0_1 vdout0_1ck201 = 0 time = 2020
* CHECK dout0_2 vdout0_2ck201 = 1.95 time = 2020
* CHECK dout0_3 vdout0_3ck201 = 0 time = 2020
* CHECK dout0_4 vdout0_4ck201 = 1.95 time = 2020
* CHECK dout0_5 vdout0_5ck201 = 0 time = 2020
* CHECK dout0_6 vdout0_6ck201 = 0 time = 2020
* CHECK dout0_7 vdout0_7ck201 = 1.95 time = 2020
* CHECK dout0_8 vdout0_8ck201 = 0 time = 2020
* CHECK dout0_9 vdout0_9ck201 = 0 time = 2020
* CHECK dout0_10 vdout0_10ck201 = 0 time = 2020
* CHECK dout0_11 vdout0_11ck201 = 0 time = 2020
* CHECK dout0_12 vdout0_12ck201 = 1.95 time = 2020
* CHECK dout0_13 vdout0_13ck201 = 1.95 time = 2020
* CHECK dout0_14 vdout0_14ck201 = 1.95 time = 2020
* CHECK dout0_15 vdout0_15ck201 = 0 time = 2020
* CHECK dout0_16 vdout0_16ck201 = 1.95 time = 2020
* CHECK dout0_17 vdout0_17ck201 = 1.95 time = 2020
* CHECK dout0_18 vdout0_18ck201 = 0 time = 2020
* CHECK dout0_19 vdout0_19ck201 = 0 time = 2020
* CHECK dout0_20 vdout0_20ck201 = 1.95 time = 2020
* CHECK dout0_21 vdout0_21ck201 = 1.95 time = 2020
* CHECK dout0_22 vdout0_22ck201 = 1.95 time = 2020
* CHECK dout0_23 vdout0_23ck201 = 1.95 time = 2020
* CHECK dout0_24 vdout0_24ck201 = 1.95 time = 2020
* CHECK dout0_25 vdout0_25ck201 = 1.95 time = 2020
* CHECK dout0_26 vdout0_26ck201 = 1.95 time = 2020
* CHECK dout0_27 vdout0_27ck201 = 0 time = 2020
* CHECK dout0_28 vdout0_28ck201 = 1.95 time = 2020
* CHECK dout0_29 vdout0_29ck201 = 0 time = 2020
* CHECK dout0_30 vdout0_30ck201 = 1.95 time = 2020
* CHECK dout0_31 vdout0_31ck201 = 1.95 time = 2020
* CHECK dout0_0 vdout0_0ck202 = 0 time = 2030
* CHECK dout0_1 vdout0_1ck202 = 1.95 time = 2030
* CHECK dout0_2 vdout0_2ck202 = 0 time = 2030
* CHECK dout0_3 vdout0_3ck202 = 0 time = 2030
* CHECK dout0_4 vdout0_4ck202 = 1.95 time = 2030
* CHECK dout0_5 vdout0_5ck202 = 1.95 time = 2030
* CHECK dout0_6 vdout0_6ck202 = 0 time = 2030
* CHECK dout0_7 vdout0_7ck202 = 1.95 time = 2030
* CHECK dout0_8 vdout0_8ck202 = 1.95 time = 2030
* CHECK dout0_9 vdout0_9ck202 = 1.95 time = 2030
* CHECK dout0_10 vdout0_10ck202 = 0 time = 2030
* CHECK dout0_11 vdout0_11ck202 = 1.95 time = 2030
* CHECK dout0_12 vdout0_12ck202 = 0 time = 2030
* CHECK dout0_13 vdout0_13ck202 = 0 time = 2030
* CHECK dout0_14 vdout0_14ck202 = 0 time = 2030
* CHECK dout0_15 vdout0_15ck202 = 1.95 time = 2030
* CHECK dout0_16 vdout0_16ck202 = 1.95 time = 2030
* CHECK dout0_17 vdout0_17ck202 = 0 time = 2030
* CHECK dout0_18 vdout0_18ck202 = 0 time = 2030
* CHECK dout0_19 vdout0_19ck202 = 0 time = 2030
* CHECK dout0_20 vdout0_20ck202 = 1.95 time = 2030
* CHECK dout0_21 vdout0_21ck202 = 1.95 time = 2030
* CHECK dout0_22 vdout0_22ck202 = 0 time = 2030
* CHECK dout0_23 vdout0_23ck202 = 1.95 time = 2030
* CHECK dout0_24 vdout0_24ck202 = 1.95 time = 2030
* CHECK dout0_25 vdout0_25ck202 = 0 time = 2030
* CHECK dout0_26 vdout0_26ck202 = 1.95 time = 2030
* CHECK dout0_27 vdout0_27ck202 = 0 time = 2030
* CHECK dout0_28 vdout0_28ck202 = 0 time = 2030
* CHECK dout0_29 vdout0_29ck202 = 0 time = 2030
* CHECK dout0_30 vdout0_30ck202 = 0 time = 2030
* CHECK dout0_31 vdout0_31ck202 = 0 time = 2030
* CHECK dout1_0 vdout1_0ck202 = 0 time = 2030
* CHECK dout1_1 vdout1_1ck202 = 0 time = 2030
* CHECK dout1_2 vdout1_2ck202 = 1.95 time = 2030
* CHECK dout1_3 vdout1_3ck202 = 1.95 time = 2030
* CHECK dout1_4 vdout1_4ck202 = 0 time = 2030
* CHECK dout1_5 vdout1_5ck202 = 1.95 time = 2030
* CHECK dout1_6 vdout1_6ck202 = 1.95 time = 2030
* CHECK dout1_7 vdout1_7ck202 = 0 time = 2030
* CHECK dout1_8 vdout1_8ck202 = 1.95 time = 2030
* CHECK dout1_9 vdout1_9ck202 = 1.95 time = 2030
* CHECK dout1_10 vdout1_10ck202 = 1.95 time = 2030
* CHECK dout1_11 vdout1_11ck202 = 0 time = 2030
* CHECK dout1_12 vdout1_12ck202 = 1.95 time = 2030
* CHECK dout1_13 vdout1_13ck202 = 0 time = 2030
* CHECK dout1_14 vdout1_14ck202 = 1.95 time = 2030
* CHECK dout1_15 vdout1_15ck202 = 1.95 time = 2030
* CHECK dout1_16 vdout1_16ck202 = 0 time = 2030
* CHECK dout1_17 vdout1_17ck202 = 0 time = 2030
* CHECK dout1_18 vdout1_18ck202 = 0 time = 2030
* CHECK dout1_19 vdout1_19ck202 = 1.95 time = 2030
* CHECK dout1_20 vdout1_20ck202 = 1.95 time = 2030
* CHECK dout1_21 vdout1_21ck202 = 1.95 time = 2030
* CHECK dout1_22 vdout1_22ck202 = 0 time = 2030
* CHECK dout1_23 vdout1_23ck202 = 1.95 time = 2030
* CHECK dout1_24 vdout1_24ck202 = 1.95 time = 2030
* CHECK dout1_25 vdout1_25ck202 = 0 time = 2030
* CHECK dout1_26 vdout1_26ck202 = 1.95 time = 2030
* CHECK dout1_27 vdout1_27ck202 = 1.95 time = 2030
* CHECK dout1_28 vdout1_28ck202 = 1.95 time = 2030
* CHECK dout1_29 vdout1_29ck202 = 0 time = 2030
* CHECK dout1_30 vdout1_30ck202 = 0 time = 2030
* CHECK dout1_31 vdout1_31ck202 = 1.95 time = 2030
* CHECK dout0_0 vdout0_0ck203 = 0 time = 2040
* CHECK dout0_1 vdout0_1ck203 = 0 time = 2040
* CHECK dout0_2 vdout0_2ck203 = 1.95 time = 2040
* CHECK dout0_3 vdout0_3ck203 = 0 time = 2040
* CHECK dout0_4 vdout0_4ck203 = 1.95 time = 2040
* CHECK dout0_5 vdout0_5ck203 = 0 time = 2040
* CHECK dout0_6 vdout0_6ck203 = 0 time = 2040
* CHECK dout0_7 vdout0_7ck203 = 1.95 time = 2040
* CHECK dout0_8 vdout0_8ck203 = 0 time = 2040
* CHECK dout0_9 vdout0_9ck203 = 0 time = 2040
* CHECK dout0_10 vdout0_10ck203 = 0 time = 2040
* CHECK dout0_11 vdout0_11ck203 = 0 time = 2040
* CHECK dout0_12 vdout0_12ck203 = 1.95 time = 2040
* CHECK dout0_13 vdout0_13ck203 = 1.95 time = 2040
* CHECK dout0_14 vdout0_14ck203 = 1.95 time = 2040
* CHECK dout0_15 vdout0_15ck203 = 0 time = 2040
* CHECK dout0_16 vdout0_16ck203 = 1.95 time = 2040
* CHECK dout0_17 vdout0_17ck203 = 1.95 time = 2040
* CHECK dout0_18 vdout0_18ck203 = 0 time = 2040
* CHECK dout0_19 vdout0_19ck203 = 0 time = 2040
* CHECK dout0_20 vdout0_20ck203 = 1.95 time = 2040
* CHECK dout0_21 vdout0_21ck203 = 1.95 time = 2040
* CHECK dout0_22 vdout0_22ck203 = 1.95 time = 2040
* CHECK dout0_23 vdout0_23ck203 = 1.95 time = 2040
* CHECK dout0_24 vdout0_24ck203 = 1.95 time = 2040
* CHECK dout0_25 vdout0_25ck203 = 1.95 time = 2040
* CHECK dout0_26 vdout0_26ck203 = 1.95 time = 2040
* CHECK dout0_27 vdout0_27ck203 = 0 time = 2040
* CHECK dout0_28 vdout0_28ck203 = 1.95 time = 2040
* CHECK dout0_29 vdout0_29ck203 = 0 time = 2040
* CHECK dout0_30 vdout0_30ck203 = 1.95 time = 2040
* CHECK dout0_31 vdout0_31ck203 = 1.95 time = 2040
* CHECK dout0_0 vdout0_0ck204 = 0 time = 2050
* CHECK dout0_1 vdout0_1ck204 = 1.95 time = 2050
* CHECK dout0_2 vdout0_2ck204 = 0 time = 2050
* CHECK dout0_3 vdout0_3ck204 = 0 time = 2050
* CHECK dout0_4 vdout0_4ck204 = 1.95 time = 2050
* CHECK dout0_5 vdout0_5ck204 = 1.95 time = 2050
* CHECK dout0_6 vdout0_6ck204 = 0 time = 2050
* CHECK dout0_7 vdout0_7ck204 = 1.95 time = 2050
* CHECK dout0_8 vdout0_8ck204 = 1.95 time = 2050
* CHECK dout0_9 vdout0_9ck204 = 1.95 time = 2050
* CHECK dout0_10 vdout0_10ck204 = 0 time = 2050
* CHECK dout0_11 vdout0_11ck204 = 1.95 time = 2050
* CHECK dout0_12 vdout0_12ck204 = 0 time = 2050
* CHECK dout0_13 vdout0_13ck204 = 0 time = 2050
* CHECK dout0_14 vdout0_14ck204 = 0 time = 2050
* CHECK dout0_15 vdout0_15ck204 = 1.95 time = 2050
* CHECK dout0_16 vdout0_16ck204 = 1.95 time = 2050
* CHECK dout0_17 vdout0_17ck204 = 0 time = 2050
* CHECK dout0_18 vdout0_18ck204 = 0 time = 2050
* CHECK dout0_19 vdout0_19ck204 = 0 time = 2050
* CHECK dout0_20 vdout0_20ck204 = 1.95 time = 2050
* CHECK dout0_21 vdout0_21ck204 = 1.95 time = 2050
* CHECK dout0_22 vdout0_22ck204 = 0 time = 2050
* CHECK dout0_23 vdout0_23ck204 = 1.95 time = 2050
* CHECK dout0_24 vdout0_24ck204 = 1.95 time = 2050
* CHECK dout0_25 vdout0_25ck204 = 0 time = 2050
* CHECK dout0_26 vdout0_26ck204 = 1.95 time = 2050
* CHECK dout0_27 vdout0_27ck204 = 0 time = 2050
* CHECK dout0_28 vdout0_28ck204 = 0 time = 2050
* CHECK dout0_29 vdout0_29ck204 = 0 time = 2050
* CHECK dout0_30 vdout0_30ck204 = 0 time = 2050
* CHECK dout0_31 vdout0_31ck204 = 0 time = 2050
* CHECK dout1_0 vdout1_0ck204 = 1.95 time = 2050
* CHECK dout1_1 vdout1_1ck204 = 1.95 time = 2050
* CHECK dout1_2 vdout1_2ck204 = 0 time = 2050
* CHECK dout1_3 vdout1_3ck204 = 0 time = 2050
* CHECK dout1_4 vdout1_4ck204 = 1.95 time = 2050
* CHECK dout1_5 vdout1_5ck204 = 1.95 time = 2050
* CHECK dout1_6 vdout1_6ck204 = 1.95 time = 2050
* CHECK dout1_7 vdout1_7ck204 = 1.95 time = 2050
* CHECK dout1_8 vdout1_8ck204 = 1.95 time = 2050
* CHECK dout1_9 vdout1_9ck204 = 0 time = 2050
* CHECK dout1_10 vdout1_10ck204 = 1.95 time = 2050
* CHECK dout1_11 vdout1_11ck204 = 1.95 time = 2050
* CHECK dout1_12 vdout1_12ck204 = 0 time = 2050
* CHECK dout1_13 vdout1_13ck204 = 1.95 time = 2050
* CHECK dout1_14 vdout1_14ck204 = 1.95 time = 2050
* CHECK dout1_15 vdout1_15ck204 = 1.95 time = 2050
* CHECK dout1_16 vdout1_16ck204 = 0 time = 2050
* CHECK dout1_17 vdout1_17ck204 = 0 time = 2050
* CHECK dout1_18 vdout1_18ck204 = 1.95 time = 2050
* CHECK dout1_19 vdout1_19ck204 = 0 time = 2050
* CHECK dout1_20 vdout1_20ck204 = 1.95 time = 2050
* CHECK dout1_21 vdout1_21ck204 = 0 time = 2050
* CHECK dout1_22 vdout1_22ck204 = 1.95 time = 2050
* CHECK dout1_23 vdout1_23ck204 = 0 time = 2050
* CHECK dout1_24 vdout1_24ck204 = 0 time = 2050
* CHECK dout1_25 vdout1_25ck204 = 0 time = 2050
* CHECK dout1_26 vdout1_26ck204 = 1.95 time = 2050
* CHECK dout1_27 vdout1_27ck204 = 0 time = 2050
* CHECK dout1_28 vdout1_28ck204 = 1.95 time = 2050
* CHECK dout1_29 vdout1_29ck204 = 0 time = 2050
* CHECK dout1_30 vdout1_30ck204 = 1.95 time = 2050
* CHECK dout1_31 vdout1_31ck204 = 1.95 time = 2050
.include /home/link/tools/openram/OpenRAM/build/functional_meas.sp
.TEMP -40
.TRAN 10p 2060n 0n 10p UIC
.OPTIONS POST=1 RELTOL=0.001 PROBE method=gear ACCT
* probe is used for hspice/xa, while plot is used in ngspice
*.probe V(*)
*.plot V(*)
.end
